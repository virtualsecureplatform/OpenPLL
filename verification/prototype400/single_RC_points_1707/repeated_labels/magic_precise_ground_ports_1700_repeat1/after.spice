* NGSPICE file created from OpenPLL_Coupling_R_Probe.ext - technology: sky130A

.subckt OpenPLL_Coupling_R_Probe A B AFAR
R0 MID A 0.000000
C0 B AFAR 3.9111100000000006e-15
R1 A AFAR 1.5
C1 MID SUB 0 $ **FLOATING
C2 A SUB 4.2619501373291038e-16
C3 B SUB 2.8413000000000006e-15
C4 dummy SUB 0 $ **FLOATING
C5 SUB SUB 0
C6 AFAR SUB 2.4151049862670897e-15
.ends
