* NGSPICE file created from RotatedCrop.ext - technology: sky130A

.subckt RotatedCrop
* OPENPLL_ORIGIN X0 sky130_fd_pr__pfet_01v8_hvt 65395 22591 65396 22592
X0 w_65333_20000.t14 a_64549_20015.t35 w_65333_20000.t0 w_65333_20000.t0 sky130_fd_pr__pfet_01v8_hvt ad=0.2262 pd=2.26 as=0 ps=0 w=0.87 l=3.11
* OPENPLL_ORIGIN X1 sky130_fd_pr__nfet_01v8 64915 21119 64916 21120
X1 a_64549_20015.t5 w_64364_19964.t18 a_64549_20015.t3 a_64549_20015.t3 sky130_fd_pr__nfet_01v8 ad=0.143 pd=1.62 as=0 ps=0 w=0.55 l=4.73
* OPENPLL_ORIGIN X2 sky130_fd_pr__nfet_01v8 64915 20015 64916 20016
X2 a_64549_20015.t2 w_64364_19964.t19 a_64549_20015.t0 a_64549_20015.t0 sky130_fd_pr__nfet_01v8 ad=0.143 pd=1.62 as=0 ps=0 w=0.55 l=4.73
* OPENPLL_ORIGIN X3 sky130_fd_pr__pfet_01v8_hvt 65395 20000 65396 20001
X3 w_65333_20000.t13 a_64549_20015.t43 w_65333_20000.t0 w_65333_20000.t0 sky130_fd_pr__pfet_01v8_hvt ad=0.2262 pd=2.26 as=0 ps=0 w=0.87 l=2.53
* OPENPLL_ORIGIN X4 sky130_fd_pr__pfet_01v8_hvt 64575 22223 64576 22224
X4 w_64364_19964.t8 a_64549_20015.t34 w_64364_19964.t2 w_64364_19964.t2 sky130_fd_pr__pfet_01v8_hvt ad=0.2262 pd=2.26 as=0 ps=0 w=0.87 l=4.73
* OPENPLL_ORIGIN X5 sky130_fd_pr__nfet_01v8 65119 22591 65120 22592
X5 a_64549_20015.t30 w_65333_20000.t15 a_64549_20015.t29 a_64549_20015.t29 sky130_fd_pr__nfet_01v8 ad=0.143 pd=1.62 as=0 ps=0 w=0.55 l=3.27
* OPENPLL_ORIGIN X6 sky130_fd_pr__pfet_01v8_hvt 65395 22039 65396 22040
X6 w_65333_20000.t2 a_64549_20015.t37 w_65333_20000.t0 w_65333_20000.t0 sky130_fd_pr__pfet_01v8_hvt ad=0.2262 pd=2.26 as=0 ps=0 w=0.87 l=1.97
* OPENPLL_ORIGIN X7 sky130_fd_pr__nfet_01v8 65119 20000 65120 20001
X7 a_64549_20015.t13 w_65333_20000.t21 a_64549_20015.t12 a_64549_20015.t12 sky130_fd_pr__nfet_01v8 ad=0.143 pd=1.62 as=0 ps=0 w=0.55 l=2.69
* OPENPLL_ORIGIN X8 sky130_fd_pr__pfet_01v8_hvt 65663 20000 65664 20001
X8 w_65333_20000.t10 a_64549_20015.t44 w_65333_20000.t3 w_65333_20000.t3 sky130_fd_pr__pfet_01v8_hvt ad=0.2262 pd=2.26 as=0 ps=0 w=0.87 l=2.53
* OPENPLL_ORIGIN X9 sky130_fd_pr__nfet_01v8_lvt 21547 108389 21548 108390
X9 a_20000_108402.t7 a_20431_108389.t5 a_20000_108402.t6 a_64549_20015.t32 sky130_fd_pr__nfet_01v8_lvt ad=0.1113 pd=1.37 as=0 ps=0 w=0.42 l=1
* OPENPLL_ORIGIN X10 sky130_fd_pr__nfet_01v8 65119 22039 65120 22040
X10 a_64549_20015.t28 w_65333_20000.t16 a_64549_20015.t26 a_64549_20015.t26 sky130_fd_pr__nfet_01v8 ad=0.143 pd=1.62 as=0 ps=0 w=0.55 l=1.97
* OPENPLL_ORIGIN X11 sky130_fd_pr__pfet_01v8 22456 108402 22457 108403
X11 a_21763_108389.t1 a_22430_108402# a_21763_108389.t0 w_22048_107200.t0 sky130_fd_pr__pfet_01v8 ad=0.0605 pd=0.99 as=0 ps=0 w=0.22 l=1
* OPENPLL_ORIGIN X12 sky130_fd_pr__pfet_01v8 22108 108402 22109 108403
X12 a_21763_108389.t3 a_20000_108402.t10 a_21763_108389.t2 w_22048_107200.t1 sky130_fd_pr__pfet_01v8 ad=0.275 pd=2.55 as=0 ps=0 w=1 l=1
* OPENPLL_ORIGIN X13 sky130_fd_pr__nfet_01v8 66003 20000 66004 20001
X13 a_64549_20015.t11 w_65333_20000.t22 a_64549_20015.t10 a_64549_20015.t10 sky130_fd_pr__nfet_01v8 ad=0.143 pd=1.62 as=0 ps=0 w=0.55 l=2.69
* OPENPLL_ORIGIN X14 sky130_fd_pr__nfet_01v8_lvt 20469 108389 20470 108390
X14 a_20000_108402.t5 a_20431_108389.t4 a_20000_108402.t4 a_64549_20015.t33 sky130_fd_pr__nfet_01v8_lvt ad=0.1113 pd=1.37 as=0 ps=0 w=0.42 l=1
* OPENPLL_ORIGIN X15 sky130_fd_pr__pfet_01v8_hvt 64400 20751 64401 20752
X15 w_64364_19964.t16 a_64400_20751# w_64364_19964.t14 w_64364_19964.t14 sky130_fd_pr__pfet_01v8_hvt ad=0.1053 pd=1.33 as=0 ps=0 w=0.405 l=4.73
* OPENPLL_ORIGIN X16 sky130_fd_pr__nfet_01v8 64915 22223 64916 22224
X16 a_64549_20015.t8 w_64364_19964.t17 a_64549_20015.t6 a_64549_20015.t6 sky130_fd_pr__nfet_01v8 ad=0.143 pd=1.62 as=0 ps=0 w=0.55 l=4.73
* OPENPLL_ORIGIN X17 sky130_fd_pr__pfet_01v8_hvt 65663 21947 65664 21948
X17 w_65333_20000.t7 a_64549_20015.t39 w_65333_20000.t3 w_65333_20000.t3 sky130_fd_pr__pfet_01v8_hvt ad=0.2262 pd=2.26 as=0 ps=0 w=0.87 l=0.59
* OPENPLL_ORIGIN X18 sky130_fd_pr__pfet_01v8 20776 108402 20777 108403
X18 a_20431_108389.t3 a_20000_108402.t8 a_20431_108389.t2 w_20716_107200.t1 sky130_fd_pr__pfet_01v8 ad=0.275 pd=2.55 as=0 ps=0 w=1 l=1
* OPENPLL_ORIGIN X19 sky130_fd_pr__nfet_01v8 66003 21947 66004 21948
X19 a_64549_20015.t22 w_65333_20000.t18 a_64549_20015.t20 a_64549_20015.t20 sky130_fd_pr__nfet_01v8 ad=0.143 pd=1.62 as=0 ps=0 w=0.55 l=0.59
* OPENPLL_ORIGIN X20 sky130_fd_pr__pfet_01v8_hvt 64400 22591 64401 22592
X20 w_64364_19964.t6 a_64400_22591# w_64364_19964.t5 w_64364_19964.t5 sky130_fd_pr__pfet_01v8_hvt ad=0.1053 pd=1.33 as=0 ps=0 w=0.405 l=1.57
* OPENPLL_ORIGIN X21 sky130_fd_pr__pfet_01v8_hvt 64400 20000 64401 20001
X21 w_64364_19964.t1 a_64400_20000# w_64364_19964.t0 w_64364_19964.t0 sky130_fd_pr__pfet_01v8_hvt ad=0.1053 pd=1.33 as=0 ps=0 w=0.405 l=1.28
* OPENPLL_ORIGIN X22 sky130_fd_pr__pfet_01v8_hvt 65395 20751 65396 20752
X22 w_65333_20000.t9 a_64549_20015.t41 w_65333_20000.t0 w_65333_20000.t0 sky130_fd_pr__pfet_01v8_hvt ad=0.2262 pd=2.26 as=0 ps=0 w=0.87 l=4.73
* OPENPLL_ORIGIN X23 sky130_fd_pr__pfet_01v8_hvt 64400 22039 64401 22040
X23 w_64364_19964.t11 a_64400_22039# w_64364_19964.t9 w_64364_19964.t9 sky130_fd_pr__pfet_01v8_hvt ad=0.1053 pd=1.33 as=0 ps=0 w=0.405 l=1.97
* OPENPLL_ORIGIN X24 sky130_fd_pr__pfet_01v8_hvt 64575 20015 64576 20016
X24 w_64364_19964.t13 a_64549_20015.t40 w_64364_19964.t2 w_64364_19964.t2 sky130_fd_pr__pfet_01v8_hvt ad=0.2262 pd=2.26 as=0 ps=0 w=0.87 l=4.73
* OPENPLL_ORIGIN X25 sky130_fd_pr__nfet_01v8 65119 20751 65120 20752
X25 a_64549_20015.t19 w_65333_20000.t19 a_64549_20015.t17 a_64549_20015.t17 sky130_fd_pr__nfet_01v8 ad=0.143 pd=1.62 as=0 ps=0 w=0.55 l=4.73
* OPENPLL_ORIGIN X26 sky130_fd_pr__pfet_01v8_hvt 65663 20751 65664 20752
X26 w_65333_20000.t12 a_64549_20015.t42 w_65333_20000.t3 w_65333_20000.t3 sky130_fd_pr__pfet_01v8_hvt ad=0.2262 pd=2.26 as=0 ps=0 w=0.87 l=4.73
* OPENPLL_ORIGIN X27 sky130_fd_pr__nfet_01v8_lvt 20215 108389 20216 108390
X27 a_20000_108402.t3 a_20068_108389# a_20000_108402.t2 a_64549_20015.t31 sky130_fd_pr__nfet_01v8_lvt ad=0.1113 pd=1.37 as=0 ps=0 w=0.42 l=1
* OPENPLL_ORIGIN X28 sky130_fd_pr__pfet_01v8_hvt 64575 21119 64576 21120
X28 w_64364_19964.t4 a_64549_20015.t36 w_64364_19964.t2 w_64364_19964.t2 sky130_fd_pr__pfet_01v8_hvt ad=0.2262 pd=2.26 as=0 ps=0 w=0.87 l=4.73
* OPENPLL_ORIGIN X29 sky130_fd_pr__pfet_01v8 21124 108402 21125 108403
X29 a_20431_108389.t1 a_20000_108402.t9 a_20431_108389.t0 w_20716_107200.t0 sky130_fd_pr__pfet_01v8 ad=0.275 pd=2.55 as=0 ps=0 w=1 l=1
* OPENPLL_ORIGIN X30 sky130_fd_pr__pfet_01v8_hvt 65663 22223 65664 22224
X30 w_65333_20000.t5 a_64549_20015.t38 w_65333_20000.t3 w_65333_20000.t3 sky130_fd_pr__pfet_01v8_hvt ad=0.2262 pd=2.26 as=0 ps=0 w=0.87 l=4.73
* OPENPLL_ORIGIN X31 sky130_fd_pr__nfet_01v8 66003 20751 66004 20752
X31 a_64549_20015.t16 w_65333_20000.t20 a_64549_20015.t14 a_64549_20015.t14 sky130_fd_pr__nfet_01v8 ad=0.143 pd=1.62 as=0 ps=0 w=0.55 l=4.73
* OPENPLL_ORIGIN X32 sky130_fd_pr__nfet_01v8_lvt 21801 108389 21802 108390
X32 a_20000_108402.t1 a_21763_108389.t4 a_20000_108402.t0 a_64549_20015.t9 sky130_fd_pr__nfet_01v8_lvt ad=0.1113 pd=1.37 as=0 ps=0 w=0.42 l=1
* OPENPLL_ORIGIN X33 sky130_fd_pr__nfet_01v8 66003 22223 66004 22224
X33 a_64549_20015.t25 w_65333_20000.t17 a_64549_20015.t23 a_64549_20015.t23 sky130_fd_pr__nfet_01v8 ad=0.143 pd=1.62 as=0 ps=0 w=0.55 l=4.73
C0 m5_20864_107200# m1_21172_107500# 1.1621500000000001e-17
C1 a_64400_22039# a_64400_20751# 1.2163700000000001e-18
C2 m1_20222_107200# a_20068_108389# 1.7539699999999999e-17
C3 m1_20222_107200# a_20000_108402# 8.5240000000000001e-16
C4 a_64400_22039# a_64400_22591# 2.6329100000000002e-18
C5 m2_20000_107326# m1_21172_107500# 1.6445500000000003e-16
C6 a_22430_108402# a_21763_108389# 5.9348399999999998e-17
C7 a_20431_108389# m1_20222_107200# 1.1850400000000001e-17
C8 a_22430_108402# a_20000_108402# 3.35961e-17
C9 a_20000_108402# a_20068_108389# 2.1590700000000004e-16
C10 a_20000_108402# a_21763_108389# 6.3810599999999996e-16
C11 a_20431_108389# a_20068_108389# 3.4042600000000001e-17
C12 a_20431_108389# a_21763_108389# 4.1809300000000004e-17
C13 m5_20864_107200# m1_20222_107200# 2.3707300000000004e-18
C14 a_20431_108389# a_20000_108402# 1.2376300000000002e-15
C15 m5_20864_107200# a_22430_108402# -1.0281100000000001e-34
C16 m5_20864_107200# a_20068_108389# 3.5281500000000001e-19
C17 m5_20864_107200# a_21763_108389# 5.1755800000000002e-18
C18 m5_20864_107200# a_20000_108402# 7.4302000000000009e-16
C19 m5_20864_107200# a_20431_108389# 2.8862400000000001e-17
C20 m2_20000_107326# m1_20222_107200# 2.3529000000000002e-17
C21 w_20716_107200# m1_21172_107500# 8.1488200000000022e-17
C22 m1_21172_107500# w_22048_107200# 3.8351200000000004e-19
C23 w_20000_107200# m1_21172_107500# 3.2119600000000002e-18
C24 m2_20000_107326# a_22430_108402# 7.8486300000000013e-21
C25 m2_20000_107326# a_20068_108389# 1.10534e-19
C26 m2_20000_107326# a_21763_108389# 7.3327300000000006e-17
C27 m2_20000_107326# a_20000_108402# 1.5127600000000004e-16
C28 m2_20000_107326# a_20431_108389# 7.4594999999999995e-17
C29 m5_20864_107200# m2_20000_107326# 1.2434900000000002e-17
C30 m3_21536_107398# m4_20000_107214# 3.5329800000000001e-16
C31 a_64400_20751# w_65333_20000# 4.3139900000000006e-18
C32 a_64400_20751# w_64364_19964# 4.4880300000000007e-16
C33 m1_20222_107200# w_20000_107200# 1.4063000000000002e-18
C34 a_64400_22039# w_64364_19964# 2.1416300000000004e-16
C35 a_64400_22039# w_65333_20000# 4.3139900000000006e-18
C36 a_64400_22591# w_65333_20000# 3.5767900000000004e-18
C37 a_64400_22591# w_64364_19964# 3.3554199999999996e-16
C38 a_22430_108402# w_22048_107200# 5.2726700000000005e-17
C39 a_21763_108389# w_22048_107200# 5.3274900000000011e-16
C40 a_20000_108402# w_22048_107200# 2.0189100000000001e-16
C41 w_20716_107200# a_20000_108402# 4.0230400000000002e-16
C42 w_20000_107200# a_20068_108389# 2.2428400000000003e-17
C43 w_20000_107200# a_20000_108402# 6.0162100000000004e-17
C44 a_20431_108389# w_20716_107200# 7.2327600000000002e-16
C45 m5_20864_107200# w_20716_107200# 2.0536599999999999e-17
C46 m5_20864_107200# w_22048_107200# 4.8700000000000003e-18
C47 m1_20136_108556# m4_20000_107214# 1.7991299999999999e-18
C48 m5_20864_107200# w_20000_107200# 1.5137900000000001e-18
C49 m2_20000_107326# w_20716_107200# 5.2978499999999999e-17
C50 m2_20000_107326# w_22048_107200# 3.1349100000000002e-17
C51 m2_20000_107326# w_20000_107200# 3.5987800000000002e-18
C52 w_65333_20000# w_64364_19964# 8.8069700000000004e-16
C53 m2_20000_107998# m4_20000_107598# 1.0179600000000001e-17
C54 m4_20000_107982# m2_20000_107998# 2.66712e-17
C55 m1_21172_107500# m4_20000_107214# 8.8940900000000013e-18
C56 m4_20000_107982# m4_20000_107598# 5.3652999999999996e-16
C57 m1_20222_107200# m4_20000_107214# 1.4477500000000001e-18
C58 a_22430_108402# m4_20000_107214# 9.3524300000000013e-22
C59 m4_20000_107214# a_20068_108389# 1.0530900000000002e-19
C60 a_20000_108402# m4_20000_107214# 1.7684100000000003e-17
C61 a_21763_108389# m4_20000_107214# 4.5276800000000007e-18
C62 a_20431_108389# m4_20000_107214# 7.7190600000000003e-18
C63 m5_20864_107200# m4_20000_107214# 1.6045500000000004e-16
C64 m2_20000_107998# m3_21536_107398# 1.5491500000000002e-18
C65 m2_20000_107326# m4_20000_107214# 2.5023100000000001e-17
C66 m1_20136_108556# m2_20000_107998# 2.49988e-17
C67 m3_21536_107398# m4_20000_107598# 6.140160000000001e-16
C68 w_22048_107200# m4_20000_107214# 4.0374999999999995e-18
C69 w_20716_107200# m4_20000_107214# 8.2920700000000015e-18
C70 w_20000_107200# m4_20000_107214# 9.3597800000000002e-19
C71 m4_20000_107982# m3_21536_107398# 2.0485600000000002e-19
C72 m1_20136_108556# m4_20000_107598# 1.6285e-18
C73 m2_20000_107998# m2_20000_108190# 5.5803600000000002e-16
C74 m1_20136_108556# m4_20000_107982# 2.9948400000000002e-18
C75 m4_20000_107982# m2_20000_108190# 1.4945500000000001e-17
C76 m2_20000_107998# m1_21172_107500# 1.2037300000000002e-16
C77 m1_20136_108556# m3_21536_107398# 1.6020600000000002e-18
C78 m1_20222_107200# m2_20000_107998# 2.3884200000000004e-17
C79 m2_20000_107998# a_22430_108402# 3.1880400000000006e-20
C80 m2_20000_107998# a_20068_108389# 5.5591599999999995e-19
C81 m2_20000_107998# a_20000_108402# 1.5544400000000001e-16
C82 m2_20000_107998# a_21763_108389# 7.6047300000000016e-17
C83 m1_21172_107500# m4_20000_107598# 1.4423900000000002e-17
C84 a_20431_108389# m2_20000_107998# 7.9094400000000003e-17
C85 m5_20864_107200# m2_20000_107998# 8.0638400000000022e-18
C86 m4_20000_107982# m1_21172_107500# 4.7e-19
C87 m2_20000_108190# m3_21536_107398# 8.4636000000000015e-20
C88 m2_20000_107326# m2_20000_107998# 1.3387800000000001e-16
C89 m1_20222_107200# m4_20000_107598# 2.5642200000000004e-18
C90 m4_20000_107598# a_20068_108389# 1.2061800000000001e-19
C91 a_22430_108402# m4_20000_107598# 1.0612000000000001e-20
C92 a_20000_108402# m4_20000_107598# 1.6941400000000004e-17
C93 a_21763_108389# m4_20000_107598# 9.049500000000001e-18
C94 a_20431_108389# m4_20000_107598# 8.8562999999999996e-18
C95 m1_20136_108556# m2_20000_108190# 4.8298300000000001e-17
C96 m4_20000_107982# m1_20222_107200# 3.8046000000000005e-18
C97 m5_20864_107200# m4_20000_107598# 1.98648e-16
C98 m4_20000_107982# a_22430_108402# 2.8074700000000005e-19
C99 m4_20000_107982# a_20068_108389# 1.9722600000000002e-18
C100 m4_20000_107982# a_21763_108389# 1.6507000000000003e-17
C101 m4_20000_107982# a_20000_108402# 2.27618e-16
C102 m4_20000_107982# a_20431_108389# 1.6397200000000001e-17
C103 m5_20864_107200# m4_20000_107982# 2.4036099999999999e-16
C104 m2_20000_107998# w_20716_107200# 4.7071100000000005e-17
C105 m2_20000_107998# w_22048_107200# 3.3636200000000009e-17
C106 m2_20000_107998# w_20000_107200# 2.9277600000000006e-18
C107 m2_20000_107326# m4_20000_107598# 1.5639100000000002e-17
C108 m4_20000_107982# m2_20000_107326# 1.1895700000000002e-18
C109 m3_21536_107398# m1_21172_107500# 1.9391000000000001e-17
C110 w_20716_107200# m4_20000_107598# 9.0080500000000004e-18
C111 w_22048_107200# m4_20000_107598# 6.5861000000000007e-18
C112 w_20000_107200# m4_20000_107598# 1.08472e-18
C113 m1_20136_108556# m1_21172_107500# 2.4991099999999999e-17
C114 m4_20000_107982# w_20716_107200# 1.1378399999999999e-17
C115 m4_20000_107982# w_22048_107200# 8.1896100000000012e-18
C116 m1_20222_107200# m3_21536_107398# 1.5272800000000001e-18
C117 m4_20000_107982# w_20000_107200# 2.5581000000000003e-18
C118 m3_21536_107398# a_20068_108389# 9.1782600000000015e-20
C119 m3_21536_107398# a_20000_108402# 2.8119599999999999e-17
C120 m3_21536_107398# a_21763_108389# 1.61041e-18
C121 a_20431_108389# m3_21536_107398# 1.24753e-17
C122 m5_20864_107200# m3_21536_107398# 1.7783400000000002e-16
C123 m1_20136_108556# m1_20222_107200# 6.5872900000000004e-16
C124 m1_20136_108556# a_20068_108389# 4.1616900000000002e-17
C125 m1_20136_108556# a_20000_108402# 7.302050000000001e-17
C126 m1_20136_108556# a_20431_108389# 4.434400000000001e-19
C127 m2_20000_107326# m3_21536_107398# 5.1122700000000006e-17
C128 m1_20136_108556# m5_20864_107200# 1.4143500000000001e-18
C129 a_64400_20751# a_64400_20000# 2.6329100000000002e-18
C130 m2_20000_108190# m1_21172_107500# 4.0203900000000004e-20
C131 m1_20136_108556# m2_20000_107326# 2.4623200000000003e-17
C132 m3_21536_107398# w_22048_107200# 4.9466100000000001e-18
C133 m3_21536_107398# w_20716_107200# 1.6701200000000002e-17
C134 w_20000_107200# m3_21536_107398# 8.4649000000000005e-19
C135 m1_20222_107200# m2_20000_108190# 2.4562000000000002e-17
C136 m2_20000_108190# a_22430_108402# 2.0855700000000003e-18
C137 m2_20000_108190# a_20068_108389# 1.1578200000000001e-17
C138 m2_20000_108190# a_21763_108389# 1.01416e-16
C139 m2_20000_108190# a_20000_108402# 2.3021e-16
C140 a_20431_108389# m2_20000_108190# 1.1764e-16
C141 m5_20864_107200# m2_20000_108190# 1.3326700000000002e-17
C142 m1_20136_108556# w_20716_107200# 8.5384699999999998e-20
C143 m1_20136_108556# w_20000_107200# 1.4178000000000003e-17
C144 w_65333_20000# a_64400_20000# 4.0955600000000003e-19
C145 w_64364_19964# a_64400_20000# 2.63403e-16
C146 m1_20222_107200# m1_21172_107500# 2.3896500000000002e-17
C147 m2_20000_108190# w_20716_107200# 3.0487600000000004e-17
C148 m2_20000_108190# w_22048_107200# 1.8931300000000003e-17
C149 m1_21172_107500# a_20068_108389# 1.6522900000000002e-19
C150 m2_20000_108190# w_20000_107200# 3.3428399999999998e-18
C151 m1_21172_107500# a_21763_108389# 6.1075300000000006e-20
C152 m1_21172_107500# a_20000_108402# 1.08716e-16
C153 m4_20000_107214# m4_20000_107598# 3.6473300000000006e-16
C154 a_20431_108389# m1_21172_107500# 2.0253100000000003e-16
R0 a_21763_108389.t0 a_21763_108389.n0 739.10000000000002
R1 a_21763_108389.n1 a_21763_108389.n0 10.631
R2 a_21763_108389.n2 a_21763_108389.n1 19.430800781249999
R3 a_21763_108389.n1 a_21763_108389.t1 721.81600000000003
R4 a_21763_108389.n2 a_21763_108389.t3 219.089
R5 a_21763_108389.t4 a_21763_108389.n2 278.63299999999998
R6 a_21763_108389# a_21763_108389.t4 126.842
R7 a_21763_108389.n0 a_21763_108389.t2 252.01300000000001
R8 a_20000_108402.t0 a_20000_108402.n46 225
R9 a_20000_108402.n2 a_20000_108402.n0 14.371900390624999
R10 a_20000_108402.n2 a_20000_108402.n46 14.371900390624999
R11 a_20000_108402.n1 a_20000_108402.n3 5.8117202148437501
R12 a_20000_108402.n4 a_20000_108402.n5 4.5
R13 a_20000_108402.n6 a_20000_108402.n7 4.5
R14 a_20000_108402.n8 a_20000_108402.n9 4.5
R15 a_20000_108402.n10 a_20000_108402.n11 4.5
R16 a_20000_108402.n4 a_20000_108402.n1 0.91030798339843755
R17 a_20000_108402.n6 a_20000_108402.n4 0.083333297729492189
R18 a_20000_108402.n8 a_20000_108402.n6 0.083333297729492189
R19 a_20000_108402.n10 a_20000_108402.n8 0.083333297729492189
R20 a_20000_108402.n12 a_20000_108402.n10 2.3277700195312501
R21 a_20000_108402.n14 a_20000_108402.n13 3.4100000000000001
R22 a_20000_108402.n16 a_20000_108402.n15 3.4100000000000001
R23 a_20000_108402.n18 a_20000_108402.n17 3.4100000000000001
R24 a_20000_108402.n5 a_20000_108402.n7 0.10810800170898438
R25 a_20000_108402.n17 a_20000_108402.n7 0.027027000427246095
R26 a_20000_108402.n17 a_20000_108402.n9 0.081081100463867184
R27 a_20000_108402.n9 a_20000_108402.n15 0.054054100036621096
R28 a_20000_108402.n15 a_20000_108402.n11 0.054054100036621096
R29 a_20000_108402.n13 a_20000_108402.n11 0.081081100463867184
R30 a_20000_108402.n13 a_20000_108402.n12 0.080455200195312507
R31 a_20000_108402.n21 a_20000_108402.n20 1.6913800048828125
R32 a_20000_108402.n21 a_20000_108402.n19 1.6913800048828125
R33 a_20000_108402.n19 a_20000_108402.n14 0.028748899459838866
R34 a_20000_108402.n16 a_20000_108402.n21 3.4100000000000001
R35 a_20000_108402.n20 a_20000_108402.n18 0.028748899459838866
R36 a_20000_108402.n20 a_20000_108402.n5 3.4387500000000002
R37 a_20000_108402.n18 a_20000_108402.n16 0.056969699859619138
R38 a_20000_108402.n16 a_20000_108402.n14 0.056969699859619138
R39 a_20000_108402.n19 a_20000_108402.n12 3.493159912109375
R40 a_20000_108402.n22 a_20000_108402.n23 3.4100000000000001
R41 a_20000_108402.n24 a_20000_108402.n23 1.6913800048828125
R42 a_20000_108402.n26 a_20000_108402.n27 0.028748899459838866
R43 a_20000_108402.n27 a_20000_108402.n23 1.6913800048828125
R44 a_20000_108402.n23 a_20000_108402.n21 0.15650999450683595
R45 a_20000_108402.n29 a_20000_108402.n22 3.4100000000000001
R46 a_20000_108402.n30 a_20000_108402.n25 3.4100000000000001
R47 a_20000_108402.n31 a_20000_108402.n26 3.4100000000000001
R48 a_20000_108402.n45 a_20000_108402.n28 3.4100000000000001
R49 a_20000_108402.n28 a_20000_108402.n22 0.056969699859619138
R50 a_20000_108402.n27 a_20000_108402.n28 0.028748899459838866
R51 a_20000_108402.n25 a_20000_108402.n26 0.056969699859619138
R52 a_20000_108402.n25 a_20000_108402.n24 0.028748899459838866
R53 a_20000_108402.n32 a_20000_108402.n29 4.5
R54 a_20000_108402.n33 a_20000_108402.n34 4.5
R55 a_20000_108402.n35 a_20000_108402.n36 4.5
R56 a_20000_108402.n37 a_20000_108402.n38 4.5
R57 a_20000_108402.n34 a_20000_108402.n29 0.10810800170898438
R58 a_20000_108402.n45 a_20000_108402.n34 0.027027000427246095
R59 a_20000_108402.n36 a_20000_108402.n45 0.081081100463867184
R60 a_20000_108402.n31 a_20000_108402.n36 0.054054100036621096
R61 a_20000_108402.n38 a_20000_108402.n31 0.054054100036621096
R62 a_20000_108402.n30 a_20000_108402.n38 0.081081100463867184
R63 a_20000_108402.n39 a_20000_108402.n30 0.080455200195312507
R64 a_20000_108402.n32 a_20000_108402.n33 0.083333297729492189
R65 a_20000_108402.n33 a_20000_108402.n35 0.083333297729492189
R66 a_20000_108402.n35 a_20000_108402.n37 0.083333297729492189
R67 a_20000_108402.n37 a_20000_108402.n39 2.3277700195312501
R68 a_20000_108402.n39 a_20000_108402.n24 3.493159912109375
R69 a_20000_108402.n41 a_20000_108402.n40 3.9453701171875002
R70 a_20000_108402.n40 a_20000_108402.n32 0.91030798339843755
R71 a_20000_108402.n44 a_20000_108402.t5 249.82400000000001
R72 a_20000_108402.n44 a_20000_108402.t3 249.82400000000001
R73 a_20000_108402.n40 a_20000_108402.n44 5.8117202148437501
R74 a_20000_108402.n42 a_20000_108402.n41 14.371900390624999
R75 a_20000_108402.n41 a_20000_108402.n43 14.371900390624999
R76 a_20000_108402.n43 a_20000_108402.t8 271.81400000000002
R77 a_20000_108402.n43 a_20000_108402.t4 225
R78 a_20000_108402.n42 a_20000_108402.t2 225
R79 a_20000_108402# a_20000_108402.n42 594.79600000000005
R80 a_20000_108402.n3 a_20000_108402.t1 249.82400000000001
R81 a_20000_108402.n3 a_20000_108402.t7 249.82400000000001
R82 a_20000_108402.n1 a_20000_108402.n2 3.9453701171875002
R83 a_20000_108402.n46 a_20000_108402.t10 271.81400000000002
R84 a_20000_108402.n0 a_20000_108402.t9 271.81400000000002
R85 a_20000_108402.n0 a_20000_108402.t6 225
R86 a_20431_108389.t2 a_20431_108389.n0 252.012
R87 a_20431_108389.n1 a_20431_108389.n0 10.631
R88 a_20431_108389.n2 a_20431_108389.n1 19.430800781249999
R89 a_20431_108389.n1 a_20431_108389.n3 19.430499999999999
R90 a_20431_108389.n3 a_20431_108389.t1 219.089
R91 a_20431_108389.n3 a_20431_108389.t5 278.63299999999998
R92 a_20431_108389.n2 a_20431_108389.t3 219.089
R93 a_20431_108389.t4 a_20431_108389.n2 278.63299999999998
R94 a_20431_108389# a_20431_108389.t4 126.842
R95 a_20431_108389.n0 a_20431_108389.t0 252.01300000000001
R96 w_65333_20000.n55 w_65333_20000.t1 751.69200000000001
R97 w_65333_20000.t1 w_65333_20000.n0 804.73099999999999
R98 w_65333_20000.n4 w_65333_20000.n3 2.2526201171875
R99 w_65333_20000.n4 w_65333_20000.n38 1.6834100341796876
R100 w_65333_20000.n54 w_65333_20000.n55 2.65225
R101 w_65333_20000.n0 w_65333_20000.n54 1.2684699707031251
R102 w_65333_20000.n3 w_65333_20000.n0 2.9213200683593752
R103 w_65333_20000.n3 w_65333_20000.n2 2.9213200683593752
R104 w_65333_20000.n2 w_65333_20000.n41 1.2684699707031251
R105 w_65333_20000.n41 w_65333_20000.n1 2.65225
R106 w_65333_20000.n8 w_65333_20000.n7 4.6207402343749999
R107 w_65333_20000.n54 w_65333_20000.n6 4.7740498046875004
R108 w_65333_20000.n54 w_65333_20000.n5 2.283239990234375
R109 w_65333_20000.n5 w_65333_20000.n7 5.2583798828125001
R110 w_65333_20000.n7 w_65333_20000.n50 1.1014100341796875
R111 w_65333_20000.n50 w_65333_20000.n52 3.120659912109375
R112 w_65333_20000.n53 w_65333_20000.n51 2.3744499511718749
R113 w_65333_20000.n51 w_65333_20000.t18 245.667
R114 w_65333_20000.n52 w_65333_20000.n53 2.634889892578125
R115 w_65333_20000.n53 w_65333_20000.t7 380.19299999999998
R116 w_65333_20000.n52 w_65333_20000.t6 804.73099999999999
R117 w_65333_20000.n51 w_65333_20000.t6 725.173
R118 w_65333_20000.n11 w_65333_20000.n10 9.3000000000000007
R119 w_65333_20000.n12 w_65333_20000.n10 23.717599609375
R120 w_65333_20000.n10 w_65333_20000.n50 6.4000000000000004
R121 w_65333_20000.n15 w_65333_20000.n14 269.48399999999998
R122 w_65333_20000.n12 w_65333_20000.n48 9.3000000000000007
R123 w_65333_20000.n14 w_65333_20000.n12 76.072398437499999
R124 w_65333_20000.n49 w_65333_20000.n12 215.37200000000001
R125 w_65333_20000# w_65333_20000.n13 24.469699218750002
R126 w_65333_20000.n13 w_65333_20000.t0 18.424199218750001
R127 w_65333_20000.t0 w_65333_20000.n15 8.3484804687499992
R128 w_65333_20000.n15 w_65333_20000.n49 64.366898437499998
R129 w_65333_20000.n49 w_65333_20000.t3 4.3158999023437499
R130 w_65333_20000.n17 w_65333_20000.n18 9.3000000000000007
R131 w_65333_20000.n19 w_65333_20000.n33 1.439969970703125
R132 w_65333_20000.n20 w_65333_20000.n21 9.3000000000000007
R133 w_65333_20000.n22 w_65333_20000.n23 9.3000000000000007
R134 w_65333_20000.n24 w_65333_20000.n25 9.3000000000000007
R135 w_65333_20000.n26 w_65333_20000.n27 9.3000000000000007
R136 w_65333_20000.n28 w_65333_20000.n29 9.3000000000000007
R137 w_65333_20000.n36 w_65333_20000.n37 9.3000000000000007
R138 w_65333_20000.n18 w_65333_20000.n16 0.71329498291015625
R139 w_65333_20000.n19 w_65333_20000.n18 0.40857699584960938
R140 w_65333_20000.n21 w_65333_20000.n19 0.40895401000976561
R141 w_65333_20000.n23 w_65333_20000.n21 0.11979199981689453
R142 w_65333_20000.n25 w_65333_20000.n23 0.11979199981689453
R143 w_65333_20000.n27 w_65333_20000.n25 0.11979199981689453
R144 w_65333_20000.n29 w_65333_20000.n27 0.11979199981689453
R145 w_65333_20000.n37 w_65333_20000.n29 0.11979199981689453
R146 w_65333_20000.n48 w_65333_20000.n37 0.11979199981689453
R147 w_65333_20000.n48 w_65333_20000.n11 0.11979199981689453
R148 w_65333_20000.n11 w_65333_20000.n8 0.17980400085449219
R149 w_65333_20000.n8 w_65333_20000.n4 0.35680398559570314
R150 w_65333_20000.n38 w_65333_20000.t4 395.90899999999999
R151 w_65333_20000.n38 w_65333_20000.n39 3.17343994140625
R152 w_65333_20000.n38 w_65333_20000.n41 2.68825
R153 w_65333_20000.n41 w_65333_20000.n40 3.1075100097656252
R154 w_65333_20000.n41 w_65333_20000.n47 46.079999999999998
R155 w_65333_20000.n43 w_65333_20000.n44 152
R156 w_65333_20000.n45 w_65333_20000.n47 18.195
R157 w_65333_20000.n44 w_65333_20000.n47 0.49230801391601564
R158 w_65333_20000.n40 w_65333_20000.n44 10.953799804687501
R159 w_65333_20000.n40 w_65333_20000.n42 156.80000000000001
R160 w_65333_20000.n1 w_65333_20000.n45 6.50068017578125
R161 w_65333_20000.n45 w_65333_20000.n46 119.19199999999999
R162 w_65333_20000.n46 w_65333_20000.n43 32.461199218749996
R163 w_65333_20000.n43 w_65333_20000.n42 62.955101562499998
R164 w_65333_20000.n46 w_65333_20000.t17 107.79300000000001
R165 w_65333_20000.t17 w_65333_20000.n42 571.74400000000003
R166 w_65333_20000.n39 w_65333_20000.t14 388.02699999999999
R167 w_65333_20000.n39 w_65333_20000.t15 105.643
R168 w_65333_20000.n33 w_65333_20000.n20 1.661280029296875
R169 w_65333_20000.n20 w_65333_20000.n22 2.505530029296875
R170 w_65333_20000.n22 w_65333_20000.n24 2.505530029296875
R171 w_65333_20000.n24 w_65333_20000.n26 2.505530029296875
R172 w_65333_20000.n28 w_65333_20000.n26 2.505530029296875
R173 w_65333_20000.n30 w_65333_20000.n28 2.3421298828124999
R174 w_65333_20000.n36 w_65333_20000.n30 0.1634040069580078
R175 w_65333_20000.n34 w_65333_20000.t19 147.852
R176 w_65333_20000.n33 w_65333_20000.n34 3.17343994140625
R177 w_65333_20000.n33 w_65333_20000.n35 3.17343994140625
R178 w_65333_20000.n35 w_65333_20000.t12 388.02699999999999
R179 w_65333_20000.n35 w_65333_20000.t20 147.851
R180 w_65333_20000.n34 w_65333_20000.t9 388.02699999999999
R181 w_65333_20000.n16 w_65333_20000.n32 4.1059599609374997
R182 w_65333_20000.n16 w_65333_20000.n31 5.5688198242187497
R183 w_65333_20000.n31 w_65333_20000.n17 0.1634040069580078
R184 w_65333_20000.n17 w_65333_20000.n33 13.9662998046875
R185 w_65333_20000.n32 w_65333_20000.t21 279.48200000000003
R186 w_65333_20000.n32 w_65333_20000.t22 279.48200000000003
R187 w_65333_20000.n31 w_65333_20000.t10 388.65499999999997
R188 w_65333_20000.n31 w_65333_20000.t13 388.65499999999997
R189 w_65333_20000.n12 w_65333_20000.n36 13.5897998046875
R190 w_65333_20000.n30 w_65333_20000.t11 388.65499999999997
R191 w_65333_20000.n30 w_65333_20000.t8 388.65499999999997
R192 w_65333_20000.n13 w_65333_20000.n14 278.85700000000003
R193 w_65333_20000.n6 w_65333_20000.n9 11.017900390625
R194 w_65333_20000.n55 w_65333_20000.n9 9.5140898437499999
R195 w_65333_20000.n9 w_65333_20000.t16 122.636
R196 w_65333_20000.n6 w_65333_20000.t2 751.69200000000001
R197 w_65333_20000.t2 w_65333_20000.n5 804.73099999999999
R198 w_65333_20000.n2 w_65333_20000.t5 804.73099999999999
R199 w_65333_20000.n1 w_65333_20000.t5 751.69200000000001
R200 w_64364_19964.t1 w_64364_19964.n0 656.01199999999994
R201 w_64364_19964.n1 w_64364_19964.n0 4.6207402343749999
R202 w_64364_19964.n0 w_64364_19964.n70 3.7274699707031251
R203 w_64364_19964.n3 w_64364_19964.n2 152
R204 w_64364_19964.n5 w_64364_19964.n4 152
R205 w_64364_19964.n7 w_64364_19964.n6 152
R206 w_64364_19964.n11 w_64364_19964.n12 9.3000000000000007
R207 w_64364_19964.n14 w_64364_19964.n13 9.3000000000000007
R208 w_64364_19964.n15 w_64364_19964.n69 9.3000000000000007
R209 w_64364_19964.n9 w_64364_19964.t13 625.404
R210 w_64364_19964.n10 w_64364_19964.n9 1.7217499999999999
R211 w_64364_19964.n10 w_64364_19964.n7 1.4882500000000001
R212 w_64364_19964.n7 w_64364_19964.n11 2.1378999023437499
R213 w_64364_19964.n11 w_64364_19964.n5 1.3704499511718751
R214 w_64364_19964.n5 w_64364_19964.n13 1.1511800537109376
R215 w_64364_19964.n13 w_64364_19964.n3 2.3571699218750002
R216 w_64364_19964.n15 w_64364_19964.n3 0.16445399475097655
R217 w_64364_19964.n70 w_64364_19964.n15 0.84967901611328123
R218 w_64364_19964.n18 w_64364_19964.n17 9.3000000000000007
R219 w_64364_19964.n20 w_64364_19964.n19 9.3000000000000007
R220 w_64364_19964.n22 w_64364_19964.n21 9.3000000000000007
R221 w_64364_19964.n24 w_64364_19964.n23 9.3000000000000007
R222 w_64364_19964.n26 w_64364_19964.n25 9.3000000000000007
R223 w_64364_19964.n27 w_64364_19964.n28 9.3000000000000007
R224 w_64364_19964.n29 w_64364_19964.n30 9.3000000000000007
R225 w_64364_19964.n31 w_64364_19964.n32 9.3000000000000007
R226 w_64364_19964.n33 w_64364_19964.n34 9.3000000000000007
R227 w_64364_19964.n35 w_64364_19964.n36 9.3000000000000007
R228 w_64364_19964.n37 w_64364_19964.n38 4.6207402343749999
R229 w_64364_19964.n40 w_64364_19964.n41 9.3000000000000007
R230 w_64364_19964.n42 w_64364_19964.n43 9.3000000000000007
R231 w_64364_19964.n45 w_64364_19964.n44 4.6207402343749999
R232 w_64364_19964.n47 w_64364_19964.n46 2.2526201171875
R233 w_64364_19964.n47 w_64364_19964.n49 0.35758700561523438
R234 w_64364_19964.n49 w_64364_19964.n48 4.6207402343749999
R235 w_64364_19964.n12 w_64364_19964.n10 4.2445000000000004
R236 w_64364_19964.n14 w_64364_19964.n12 0.11979199981689453
R237 w_64364_19964.n69 w_64364_19964.n14 0.11979199981689453
R238 w_64364_19964.n1 w_64364_19964.n69 0.17980400085449219
R239 w_64364_19964.n18 w_64364_19964.n1 0.17980400085449219
R240 w_64364_19964.n20 w_64364_19964.n18 0.11979199981689453
R241 w_64364_19964.n22 w_64364_19964.n20 0.11979199981689453
R242 w_64364_19964.n24 w_64364_19964.n22 0.11979199981689453
R243 w_64364_19964.n26 w_64364_19964.n24 0.11979199981689453
R244 w_64364_19964.n28 w_64364_19964.n26 0.11979199981689453
R245 w_64364_19964.n30 w_64364_19964.n28 0.11979199981689453
R246 w_64364_19964.n32 w_64364_19964.n30 0.11979199981689453
R247 w_64364_19964.n34 w_64364_19964.n32 0.11979199981689453
R248 w_64364_19964.n36 w_64364_19964.n34 0.11979199981689453
R249 w_64364_19964.n38 w_64364_19964.n36 0.17980400085449219
R250 w_64364_19964.n41 w_64364_19964.n38 0.17980400085449219
R251 w_64364_19964.n41 w_64364_19964.n43 0.11979199981689453
R252 w_64364_19964.n43 w_64364_19964.n45 0.17980400085449219
R253 w_64364_19964.n45 w_64364_19964.n47 0.35680398559570314
R254 w_64364_19964.n49 w_64364_19964.n16 0.60636401367187498
R255 w_64364_19964.n16 w_64364_19964.t7 392.072
R256 w_64364_19964.n16 w_64364_19964.n68 5.8896000976562499
R257 w_64364_19964.n48 w_64364_19964.n68 4.4927202148437502
R258 w_64364_19964.n68 w_64364_19964.n51 9.1549697265625003
R259 w_64364_19964.n50 w_64364_19964.t17 149.13399999999999
R260 w_64364_19964.n50 w_64364_19964.t8 752.02599999999995
R261 w_64364_19964.n46 w_64364_19964.n67 2.1525500488281248
R262 w_64364_19964.n46 w_64364_19964.n52 2.9213200683593752
R263 w_64364_19964.n52 w_64364_19964.n51 3.2672700195312498
R264 w_64364_19964.n51 w_64364_19964.n50 0.3193489990234375
R265 w_64364_19964.n67 w_64364_19964.n66 3.0896599121093749
R266 w_64364_19964.n66 w_64364_19964.n44 4.7786699218750002
R267 w_64364_19964.n44 w_64364_19964.n53 7.93372021484375
R268 w_64364_19964.n40 w_64364_19964.n42 4.6730200195312497
R269 w_64364_19964.n42 w_64364_19964.n53 4.5635498046874998
R270 w_64364_19964.n65 w_64364_19964.n37 3.7274699707031251
R271 w_64364_19964.n40 w_64364_19964.n65 7.1384599609375003
R272 w_64364_19964.n55 w_64364_19964.n54 152
R273 w_64364_19964.n57 w_64364_19964.n56 152
R274 w_64364_19964.n59 w_64364_19964.n58 152
R275 w_64364_19964.n25 w_64364_19964.n62 0.16445399475097655
R276 w_64364_19964.n62 w_64364_19964.n61 1.7541800537109375
R277 w_64364_19964.n27 w_64364_19964.n61 0.60299798583984376
R278 w_64364_19964.n29 w_64364_19964.n27 2.5216298828124999
R279 w_64364_19964.n59 w_64364_19964.n29 0.38372601318359373
R280 w_64364_19964.n31 w_64364_19964.n59 2.1378999023437499
R281 w_64364_19964.n57 w_64364_19964.n31 1.3704499511718751
R282 w_64364_19964.n33 w_64364_19964.n57 1.1511800537109376
R283 w_64364_19964.n55 w_64364_19964.n33 2.3571699218750002
R284 w_64364_19964.n35 w_64364_19964.n55 0.16445399475097655
R285 w_64364_19964.n65 w_64364_19964.n35 0.84967901611328123
R286 w_64364_19964.n17 w_64364_19964.n63 0.21157000732421874
R287 w_64364_19964.n63 w_64364_19964.n19 3.032510009765625
R288 w_64364_19964.n19 w_64364_19964.n21 3.2440800781250001
R289 w_64364_19964.n21 w_64364_19964.n64 3.032510009765625
R290 w_64364_19964.n23 w_64364_19964.n64 0.21157000732421874
R291 w_64364_19964.n23 w_64364_19964.n25 4.8797001953125001
R292 w_64364_19964.n70 w_64364_19964.n17 6.70356982421875
R293 w_64364_19964.n64 w_64364_19964.t12 388.65499999999997
R294 w_64364_19964.n63 w_64364_19964.t16 650.66700000000003
R295 w_64364_19964.n62 w_64364_19964.t4 388.65499999999997
R296 w_64364_19964.n61 w_64364_19964.n58 214.95500000000001
R297 w_64364_19964.n58 w_64364_19964.n60 30.493900390625001
R298 w_64364_19964.n56 w_64364_19964.n60 32.461199218749996
R299 w_64364_19964.n56 w_64364_19964.n54 62.955101562499998
R300 w_64364_19964.n60 w_64364_19964.t18 107.79300000000001
R301 w_64364_19964.t18 w_64364_19964.n54 571.74400000000003
R302 w_64364_19964.n37 w_64364_19964.t15 656.01199999999994
R303 w_64364_19964.n53 w_64364_19964.t3 389.51999999999998
R304 w_64364_19964.n66 w_64364_19964.t11 652.37300000000005
R305 w_64364_19964.n52 w_64364_19964.t8 804.73099999999999
R306 w_64364_19964.n67 w_64364_19964.t10 651.43499999999995
R307 w_64364_19964.n48 w_64364_19964.t6 657.10900000000004
R308 w_64364_19964.n39 w_64364_19964.n40 1029.79
R309 w_64364_19964.n39 w_64364_19964.t14 153.97800000000001
R310 w_64364_19964.n39 w_64364_19964.t9 336.37299999999999
R311 w_64364_19964.t2 w_64364_19964.n39 25.884499999999999
R312 w_64364_19964.t0 w_64364_19964.t2 55.257300781250002
R313 w_64364_19964.t2 w_64364_19964.t5 176.398
R314 w_64364_19964# w_64364_19964.t0 2634.6399999999999
R315 w_64364_19964.n9 w_64364_19964.n6 214.95500000000001
R316 w_64364_19964.n6 w_64364_19964.n8 30.493900390625001
R317 w_64364_19964.n8 w_64364_19964.n4 32.461199218749996
R318 w_64364_19964.n4 w_64364_19964.n2 62.955101562499998
R319 w_64364_19964.n8 w_64364_19964.t19 107.79300000000001
R320 w_64364_19964.t19 w_64364_19964.n2 571.74400000000003
R321 w_22048_107200# w_22048_107200.t1 99.868601562500004
R322 w_22048_107200.t1 w_22048_107200.t0 168.52799999999999
R323 w_20716_107200# w_20716_107200.t1 99.868601562500004
R324 w_20716_107200.t1 w_20716_107200.t0 217.214
R325 a_64549_20015.n213 a_64549_20015.t30 214.45500000000001
R326 a_64549_20015.n1 a_64549_20015.n0 9.3000000000000007
R327 a_64549_20015.n3 a_64549_20015.n2 9.3000000000000007
R328 a_64549_20015.n0 a_64549_20015.n213 0.22456100463867187
R329 a_64549_20015.n213 a_64549_20015.n2 3.2187099609374998
R330 a_64549_20015.n7 a_64549_20015.n6 9.3000000000000007
R331 a_64549_20015.n9 a_64549_20015.n8 9.3000000000000007
R332 a_64549_20015.n11 a_64549_20015.n10 9.3000000000000007
R333 a_64549_20015.n13 a_64549_20015.n12 9.3000000000000007
R334 a_64549_20015.n6 a_64549_20015.n4 0.22456100463867187
R335 a_64549_20015.n4 a_64549_20015.n8 3.2187099609374998
R336 a_64549_20015.n8 a_64549_20015.n10 3.44327001953125
R337 a_64549_20015.n10 a_64549_20015.n5 3.2187099609374998
R338 a_64549_20015.n12 a_64549_20015.n5 0.22456100463867187
R339 a_64549_20015.n12 a_64549_20015.n0 4.5163100585937501
R340 a_64549_20015.n212 a_64549_20015.n6 3.430929931640625
R341 a_64549_20015.n16 a_64549_20015.n15 4.6207402343749999
R342 a_64549_20015.n211 a_64549_20015.n14 2.901330078125
R343 a_64549_20015.n15 a_64549_20015.n14 8.1066699218749996
R344 a_64549_20015.n15 a_64549_20015.n212 6.570669921875
R345 a_64549_20015.n18 a_64549_20015.n17 152
R346 a_64549_20015.n20 a_64549_20015.n19 152
R347 a_64549_20015.n23 a_64549_20015.n22 152
R348 a_64549_20015.n25 a_64549_20015.n24 9.3000000000000007
R349 a_64549_20015.n27 a_64549_20015.n26 9.3000000000000007
R350 a_64549_20015.n29 a_64549_20015.n28 9.3000000000000007
R351 a_64549_20015.n129 a_64549_20015.n128 9.3000000000000007
R352 a_64549_20015.n26 a_64549_20015.n18 0.43835598754882815
R353 a_64549_20015.n18 a_64549_20015.n130 1.6219200439453125
R354 a_64549_20015.n130 a_64549_20015.n28 1.9725999755859376
R355 a_64549_20015.n28 a_64549_20015.n20 2.0164399414062499
R356 a_64549_20015.n20 a_64549_20015.n128 2.0164399414062499
R357 a_64549_20015.n128 a_64549_20015.n23 3.5945200195312501
R358 a_64549_20015.n24 a_64549_20015.n23 0.43835598754882815
R359 a_64549_20015.n24 a_64549_20015.n211 2.7616398925781249
R360 a_64549_20015.n133 a_64549_20015.n132 9.3000000000000007
R361 a_64549_20015.n135 a_64549_20015.n134 9.3000000000000007
R362 a_64549_20015.n137 a_64549_20015.n136 9.3000000000000007
R363 a_64549_20015.n139 a_64549_20015.n138 9.3000000000000007
R364 a_64549_20015.n141 a_64549_20015.n140 9.3000000000000007
R365 a_64549_20015.n143 a_64549_20015.n142 9.3000000000000007
R366 a_64549_20015.n132 a_64549_20015.n131 0.40851098632812499
R367 a_64549_20015.n131 a_64549_20015.n145 3.94893994140625
R368 a_64549_20015.n134 a_64549_20015.n145 1.9063800048828126
R369 a_64549_20015.n134 a_64549_20015.n136 6.2638300781250003
R370 a_64549_20015.n136 a_64549_20015.n138 6.2638300781250003
R371 a_64549_20015.n138 a_64549_20015.n144 4.4255297851562503
R372 a_64549_20015.n140 a_64549_20015.n144 1.8383000488281249
R373 a_64549_20015.n140 a_64549_20015.n142 6.2638300781250003
R374 a_64549_20015.n142 a_64549_20015.n26 5.6090898437499996
R375 a_64549_20015.n146 a_64549_20015.n132 8.6828496093749994
R376 a_64549_20015.n148 a_64549_20015.n149 152
R377 a_64549_20015.n150 a_64549_20015.n151 152
R378 a_64549_20015.n152 a_64549_20015.n153 152
R379 a_64549_20015.n156 a_64549_20015.n157 9.3000000000000007
R380 a_64549_20015.n158 a_64549_20015.n159 9.3000000000000007
R381 a_64549_20015.n160 a_64549_20015.n161 9.3000000000000007
R382 a_64549_20015.n162 a_64549_20015.n163 9.3000000000000007
R383 a_64549_20015.n164 a_64549_20015.n165 9.3000000000000007
R384 a_64549_20015.n166 a_64549_20015.n167 9.3000000000000007
R385 a_64549_20015.n149 a_64549_20015.n156 0.43835598754882815
R386 a_64549_20015.n175 a_64549_20015.n149 1.6219200439453125
R387 a_64549_20015.n158 a_64549_20015.n175 1.9725999755859376
R388 a_64549_20015.n151 a_64549_20015.n158 2.0164399414062499
R389 a_64549_20015.n151 a_64549_20015.n160 2.0164399414062499
R390 a_64549_20015.n160 a_64549_20015.n153 3.5945200195312501
R391 a_64549_20015.n153 a_64549_20015.n162 0.43835598754882815
R392 a_64549_20015.n162 a_64549_20015.n174 2.0164399414062499
R393 a_64549_20015.n174 a_64549_20015.n164 2.0164399414062499
R394 a_64549_20015.n164 a_64549_20015.n155 1.13972998046875
R395 a_64549_20015.n155 a_64549_20015.n147 2.630139892578125
R396 a_64549_20015.n147 a_64549_20015.n166 0.26301400756835935
R397 a_64549_20015.n166 a_64549_20015.n146 7.67122998046875
R398 a_64549_20015.n177 a_64549_20015.n178 9.3000000000000007
R399 a_64549_20015.n179 a_64549_20015.n202 9.3000000000000007
R400 a_64549_20015.n176 a_64549_20015.n210 4.1516298828125002
R401 a_64549_20015.n176 a_64549_20015.n203 8.1403701171874996
R402 a_64549_20015.n203 a_64549_20015.n177 1.8383000488281249
R403 a_64549_20015.n179 a_64549_20015.n177 6.2638300781250003
R404 a_64549_20015.n156 a_64549_20015.n179 5.6090898437499996
R405 a_64549_20015.n205 a_64549_20015.n206 152
R406 a_64549_20015.n208 a_64549_20015.n207 152
R407 a_64549_20015.n210 a_64549_20015.n208 8.9263095703124993
R408 a_64549_20015.n206 a_64549_20015.n208 6.3503901367187501
R409 a_64549_20015.n203 a_64549_20015.n206 0.94263598632812495
R410 a_64549_20015.n204 a_64549_20015.n203 7.9939599609374996
R411 a_64549_20015.n175 a_64549_20015.n204 4.6990097656250001
R412 a_64549_20015.n207 a_64549_20015.n205 62.955101562499998
R413 a_64549_20015.n209 a_64549_20015.n205 31.477599609375002
R414 a_64549_20015.n204 a_64549_20015.n209 119.002
R415 a_64549_20015.n207 a_64549_20015.t43 212.035
R416 a_64549_20015.n209 a_64549_20015.t43 19.944800781249999
R417 a_64549_20015.n175 a_64549_20015.t13 216.38900000000001
R418 a_64549_20015.n182 a_64549_20015.n181 9.3000000000000007
R419 a_64549_20015.n184 a_64549_20015.n183 9.3000000000000007
R420 a_64549_20015.n186 a_64549_20015.n185 9.3000000000000007
R421 a_64549_20015.n188 a_64549_20015.n187 9.3000000000000007
R422 a_64549_20015.n190 a_64549_20015.n189 9.3000000000000007
R423 a_64549_20015.n178 a_64549_20015.n176 1.6874100341796876
R424 a_64549_20015.n202 a_64549_20015.n178 0.11979199981689453
R425 a_64549_20015.n157 a_64549_20015.n202 0.11979199981689453
R426 a_64549_20015.n159 a_64549_20015.n157 0.11979199981689453
R427 a_64549_20015.n161 a_64549_20015.n159 0.11979199981689453
R428 a_64549_20015.n163 a_64549_20015.n161 0.11979199981689453
R429 a_64549_20015.n163 a_64549_20015.n165 0.11979199981689453
R430 a_64549_20015.n165 a_64549_20015.n167 0.11979199981689453
R431 a_64549_20015.n167 a_64549_20015.n133 0.11979199981689453
R432 a_64549_20015.n133 a_64549_20015.n135 0.11979199981689453
R433 a_64549_20015.n135 a_64549_20015.n137 0.11979199981689453
R434 a_64549_20015.n137 a_64549_20015.n139 0.11979199981689453
R435 a_64549_20015.n139 a_64549_20015.n141 0.11979199981689453
R436 a_64549_20015.n141 a_64549_20015.n143 0.11979199981689453
R437 a_64549_20015.n143 a_64549_20015.n27 0.11979199981689453
R438 a_64549_20015.n27 a_64549_20015.n29 0.11979199981689453
R439 a_64549_20015.n29 a_64549_20015.n129 0.11979199981689453
R440 a_64549_20015.n129 a_64549_20015.n25 0.11979199981689453
R441 a_64549_20015.n25 a_64549_20015.n16 0.17980400085449219
R442 a_64549_20015.n16 a_64549_20015.n7 0.17980400085449219
R443 a_64549_20015.n7 a_64549_20015.n9 0.11979199981689453
R444 a_64549_20015.n9 a_64549_20015.n11 0.11979199981689453
R445 a_64549_20015.n11 a_64549_20015.n13 0.11979199981689453
R446 a_64549_20015.n13 a_64549_20015.n1 0.11979199981689453
R447 a_64549_20015.n1 a_64549_20015.n3 0.11979199981689453
R448 a_64549_20015.n3 a_64549_20015.n182 0.11979199981689453
R449 a_64549_20015.n182 a_64549_20015.n184 0.11979199981689453
R450 a_64549_20015.n184 a_64549_20015.n186 0.11979199981689453
R451 a_64549_20015.n186 a_64549_20015.n188 0.11979199981689453
R452 a_64549_20015.n188 a_64549_20015.n190 0.11979199981689453
R453 a_64549_20015.n190 a_64549_20015.n180 6.6347500000000004
R454 a_64549_20015.n193 a_64549_20015.n192 152
R455 a_64549_20015.n195 a_64549_20015.n194 152
R456 a_64549_20015.n197 a_64549_20015.n196 152
R457 a_64549_20015.n2 a_64549_20015.n181 3.2076398925781251
R458 a_64549_20015.n181 a_64549_20015.n193 0.28699600219726562
R459 a_64549_20015.n193 a_64549_20015.n183 2.3533601074218748
R460 a_64549_20015.n183 a_64549_20015.n195 1.3201800537109376
R461 a_64549_20015.n195 a_64549_20015.n185 1.3201800537109376
R462 a_64549_20015.n185 a_64549_20015.n197 2.3533601074218748
R463 a_64549_20015.n187 a_64549_20015.n197 0.28699600219726562
R464 a_64549_20015.n187 a_64549_20015.n189 2.6403601074218752
R465 a_64549_20015.n189 a_64549_20015.n199 0.74618798828124999
R466 a_64549_20015.n200 a_64549_20015.n199 0.60269097900390622
R467 a_64549_20015.n191 a_64549_20015.n200 1.119280029296875
R468 a_64549_20015.n180 a_64549_20015.n191 0.40150799560546874
R469 a_64549_20015.n201 a_64549_20015.n180 25.501999999999999
R470 a_64549_20015.n201 a_64549_20015.t35 146.54300000000001
R471 a_64549_20015.n200 a_64549_20015.n201 5.4828701171874998
R472 a_64549_20015.n192 a_64549_20015.n194 62.955101562499998
R473 a_64549_20015.n194 a_64549_20015.n198 31.477599609375002
R474 a_64549_20015.n196 a_64549_20015.n198 31.477599609375002
R475 a_64549_20015.n196 a_64549_20015.n199 214.95500000000001
R476 a_64549_20015.n192 a_64549_20015.t34 538.31200000000001
R477 a_64549_20015.n198 a_64549_20015.t34 68.698898437500006
R478 a_64549_20015.n191 a_64549_20015.t7 214.45500000000001
R479 a_64549_20015.n210 a_64549_20015.t2 203.744
R480 a_64549_20015.n174 a_64549_20015.n146 15.2935
R481 a_64549_20015.n146 a_64549_20015.n145 9.1428603515625007
R482 a_64549_20015.n170 a_64549_20015.n169 152
R483 a_64549_20015.n172 a_64549_20015.n171 152
R484 a_64549_20015.n145 a_64549_20015.n172 9.5655302734374992
R485 a_64549_20015.n170 a_64549_20015.n172 6.3503901367187501
R486 a_64549_20015.n144 a_64549_20015.n170 0.94263598632812495
R487 a_64549_20015.n144 a_64549_20015.n168 7.9939599609374996
R488 a_64549_20015.n130 a_64549_20015.n168 4.6990097656250001
R489 a_64549_20015.n171 a_64549_20015.n169 62.955101562499998
R490 a_64549_20015.n169 a_64549_20015.n173 31.477599609375002
R491 a_64549_20015.n168 a_64549_20015.n173 119.002
R492 a_64549_20015.n171 a_64549_20015.t41 538.31200000000001
R493 a_64549_20015.n173 a_64549_20015.t41 68.698898437500006
R494 a_64549_20015.n130 a_64549_20015.t18 216.38900000000001
R495 a_64549_20015.n174 a_64549_20015.t19 225.42599999999999
R496 a_64549_20015.n150 a_64549_20015.n148 62.955101562499998
R497 a_64549_20015.n154 a_64549_20015.n150 31.477599609375002
R498 a_64549_20015.n154 a_64549_20015.n152 31.477599609375002
R499 a_64549_20015.n152 a_64549_20015.n155 214.95500000000001
R500 a_64549_20015.n148 a_64549_20015.t40 538.31200000000001
R501 a_64549_20015.t40 a_64549_20015.n154 68.698898437500006
R502 a_64549_20015# a_64549_20015.t40 876.86900000000003
R503 a_64549_20015.n147 a_64549_20015.t1 214.45500000000001
R504 a_64549_20015.n131 a_64549_20015.t5 214.45500000000001
R505 a_64549_20015.n128 a_64549_20015.n127 1194.5
R506 a_64549_20015.t0 a_64549_20015.t12 1618.3900000000001
R507 a_64549_20015.t17 a_64549_20015.t0 6203.8299999999999
R508 a_64549_20015.t3 a_64549_20015.t17 3101.9200000000001
R509 a_64549_20015.n127 a_64549_20015.t3 1938.7
R510 a_64549_20015.n127 a_64549_20015.t26 3489.6599999999999
R511 a_64549_20015.t26 a_64549_20015.t6 3877.3899999999999
R512 a_64549_20015.t6 a_64549_20015.t29 2098.8499999999999
R513 a_64549_20015.t29 a_64549_20015.n125 19370.099999999999
R514 a_64549_20015.n125 a_64549_20015.n126 7752.1300000000001
R515 a_64549_20015.n126 a_64549_20015.t32 367.14800000000002
R516 a_64549_20015.n126 a_64549_20015.t9 367.14800000000002
R517 a_64549_20015.n126 a_64549_20015.t31 367.14800000000002
R518 a_64549_20015.n126 a_64549_20015.t33 367.14800000000002
R519 a_64549_20015.t14 a_64549_20015.t10 2400.4699999999998
R520 a_64549_20015.n30 a_64549_20015.t14 1546.8499999999999
R521 a_64549_20015.t20 a_64549_20015.n30 475.95499999999998
R522 a_64549_20015.t23 a_64549_20015.t20 1784.8299999999999
R523 a_64549_20015.n125 a_64549_20015.t23 19529
R524 a_64549_20015.n31 a_64549_20015.n124 9.3000000000000007
R525 a_64549_20015.n30 a_64549_20015.n31 1198.25
R526 a_64549_20015.n33 a_64549_20015.n32 9.3000000000000007
R527 a_64549_20015.n35 a_64549_20015.n34 9.3000000000000007
R528 a_64549_20015.n37 a_64549_20015.n36 9.3000000000000007
R529 a_64549_20015.n39 a_64549_20015.n38 9.3000000000000007
R530 a_64549_20015.n41 a_64549_20015.n40 9.3000000000000007
R531 a_64549_20015.n43 a_64549_20015.n42 9.3000000000000007
R532 a_64549_20015.n45 a_64549_20015.n44 9.3000000000000007
R533 a_64549_20015.n47 a_64549_20015.n46 9.3000000000000007
R534 a_64549_20015.n49 a_64549_20015.n48 9.3000000000000007
R535 a_64549_20015.n51 a_64549_20015.n50 9.3000000000000007
R536 a_64549_20015.n53 a_64549_20015.n52 9.3000000000000007
R537 a_64549_20015.n55 a_64549_20015.n54 9.3000000000000007
R538 a_64549_20015.n57 a_64549_20015.n56 9.3000000000000007
R539 a_64549_20015.n71 a_64549_20015.n72 9.3000000000000007
R540 a_64549_20015.n73 a_64549_20015.n74 9.3000000000000007
R541 a_64549_20015.n75 a_64549_20015.n76 9.3000000000000007
R542 a_64549_20015.n78 a_64549_20015.n77 9.3000000000000007
R543 a_64549_20015.n80 a_64549_20015.n79 9.3000000000000007
R544 a_64549_20015.n82 a_64549_20015.n81 9.3000000000000007
R545 a_64549_20015.n84 a_64549_20015.n83 9.3000000000000007
R546 a_64549_20015.n86 a_64549_20015.n85 9.3000000000000007
R547 a_64549_20015.n88 a_64549_20015.n87 9.3000000000000007
R548 a_64549_20015.n90 a_64549_20015.n89 9.3000000000000007
R549 a_64549_20015.n92 a_64549_20015.n91 9.3000000000000007
R550 a_64549_20015.n94 a_64549_20015.n93 9.3000000000000007
R551 a_64549_20015.n96 a_64549_20015.n95 9.3000000000000007
R552 a_64549_20015.n98 a_64549_20015.n97 9.3000000000000007
R553 a_64549_20015.n100 a_64549_20015.n99 9.3000000000000007
R554 a_64549_20015.n102 a_64549_20015.n101 9.3000000000000007
R555 a_64549_20015.n103 a_64549_20015.n104 9.3000000000000007
R556 a_64549_20015.n104 a_64549_20015.n105 3.2858898925781248
R557 a_64549_20015.n102 a_64549_20015.n104 0.11979199981689453
R558 a_64549_20015.n100 a_64549_20015.n102 0.11979199981689453
R559 a_64549_20015.n98 a_64549_20015.n100 0.11979199981689453
R560 a_64549_20015.n96 a_64549_20015.n98 0.11979199981689453
R561 a_64549_20015.n94 a_64549_20015.n96 0.11979199981689453
R562 a_64549_20015.n92 a_64549_20015.n94 0.11979199981689453
R563 a_64549_20015.n90 a_64549_20015.n92 0.11979199981689453
R564 a_64549_20015.n88 a_64549_20015.n90 0.11979199981689453
R565 a_64549_20015.n86 a_64549_20015.n88 0.11979199981689453
R566 a_64549_20015.n84 a_64549_20015.n86 0.11979199981689453
R567 a_64549_20015.n82 a_64549_20015.n84 0.11979199981689453
R568 a_64549_20015.n80 a_64549_20015.n82 0.11979199981689453
R569 a_64549_20015.n78 a_64549_20015.n80 0.11979199981689453
R570 a_64549_20015.n76 a_64549_20015.n78 0.11979199981689453
R571 a_64549_20015.n74 a_64549_20015.n76 0.11979199981689453
R572 a_64549_20015.n124 a_64549_20015.n74 0.11979199981689453
R573 a_64549_20015.n124 a_64549_20015.n72 0.11979199981689453
R574 a_64549_20015.n72 a_64549_20015.n57 0.11979199981689453
R575 a_64549_20015.n57 a_64549_20015.n55 0.11979199981689453
R576 a_64549_20015.n55 a_64549_20015.n53 0.11979199981689453
R577 a_64549_20015.n53 a_64549_20015.n51 0.11979199981689453
R578 a_64549_20015.n51 a_64549_20015.n49 0.11979199981689453
R579 a_64549_20015.n49 a_64549_20015.n47 0.11979199981689453
R580 a_64549_20015.n47 a_64549_20015.n45 0.11979199981689453
R581 a_64549_20015.n45 a_64549_20015.n43 0.11979199981689453
R582 a_64549_20015.n43 a_64549_20015.n41 0.11979199981689453
R583 a_64549_20015.n41 a_64549_20015.n39 0.11979199981689453
R584 a_64549_20015.n39 a_64549_20015.n37 0.11979199981689453
R585 a_64549_20015.n37 a_64549_20015.n35 0.11979199981689453
R586 a_64549_20015.n35 a_64549_20015.n33 0.11979199981689453
R587 a_64549_20015.n109 a_64549_20015.n108 152
R588 a_64549_20015.n111 a_64549_20015.n110 152
R589 a_64549_20015.n105 a_64549_20015.n107 153.22399999999999
R590 a_64549_20015.n105 a_64549_20015.n109 3.7269799804687498
R591 a_64549_20015.n109 a_64549_20015.n103 2.0164399414062499
R592 a_64549_20015.n103 a_64549_20015.n111 3.5945200195312501
R593 a_64549_20015.n101 a_64549_20015.n111 0.43835598754882815
R594 a_64549_20015.n101 a_64549_20015.n99 4.0328798828124999
R595 a_64549_20015.n99 a_64549_20015.n113 1.13972998046875
R596 a_64549_20015.n113 a_64549_20015.n106 2.630139892578125
R597 a_64549_20015.n97 a_64549_20015.n106 0.26301400756835935
R598 a_64549_20015.n97 a_64549_20015.n95 16.354099609375002
R599 a_64549_20015.n95 a_64549_20015.n114 0.40851098632812499
R600 a_64549_20015.n114 a_64549_20015.n93 5.8553198242187499
R601 a_64549_20015.n93 a_64549_20015.n91 6.2638300781250003
R602 a_64549_20015.n91 a_64549_20015.n89 6.2638300781250003
R603 a_64549_20015.n89 a_64549_20015.n87 6.2638300781250003
R604 a_64549_20015.n87 a_64549_20015.n85 6.2638300781250003
R605 a_64549_20015.n117 a_64549_20015.n116 152
R606 a_64549_20015.n119 a_64549_20015.n118 152
R607 a_64549_20015.n121 a_64549_20015.n120 152
R608 a_64549_20015.n85 a_64549_20015.n83 5.6090898437499996
R609 a_64549_20015.n83 a_64549_20015.n117 0.43835598754882815
R610 a_64549_20015.n117 a_64549_20015.n81 3.5945200195312501
R611 a_64549_20015.n81 a_64549_20015.n119 2.0164399414062499
R612 a_64549_20015.n79 a_64549_20015.n119 2.0164399414062499
R613 a_64549_20015.n79 a_64549_20015.n121 3.5945200195312501
R614 a_64549_20015.n77 a_64549_20015.n121 0.43835598754882815
R615 a_64549_20015.n77 a_64549_20015.n75 4.0328798828124999
R616 a_64549_20015.n123 a_64549_20015.n75 1.13972998046875
R617 a_64549_20015.n115 a_64549_20015.n123 2.630139892578125
R618 a_64549_20015.n73 a_64549_20015.n115 0.26301400756835935
R619 a_64549_20015.n31 a_64549_20015.n73 14.0712001953125
R620 a_64549_20015.n116 a_64549_20015.n118 62.955101562499998
R621 a_64549_20015.n118 a_64549_20015.n122 31.477599609375002
R622 a_64549_20015.n120 a_64549_20015.n122 31.477599609375002
R623 a_64549_20015.n120 a_64549_20015.n123 214.95500000000001
R624 a_64549_20015.n116 a_64549_20015.t42 538.31200000000001
R625 a_64549_20015.n122 a_64549_20015.t42 68.698898437500006
R626 a_64549_20015.n115 a_64549_20015.t15 214.45500000000001
R627 a_64549_20015.n114 a_64549_20015.t16 214.45500000000001
R628 a_64549_20015.n107 a_64549_20015.n108 62.955101562499998
R629 a_64549_20015.n108 a_64549_20015.n112 31.477599609375002
R630 a_64549_20015.n112 a_64549_20015.n110 31.477599609375002
R631 a_64549_20015.n110 a_64549_20015.n113 214.95500000000001
R632 a_64549_20015.n107 a_64549_20015.t44 212.035
R633 a_64549_20015.n112 a_64549_20015.t44 19.944800781249999
R634 a_64549_20015.n106 a_64549_20015.t11 214.45500000000001
R635 a_64549_20015.n71 a_64549_20015.n59 0.41739099121093748
R636 a_64549_20015.n59 a_64549_20015.n56 5.9826098632812501
R637 a_64549_20015.n56 a_64549_20015.n60 4.7999999999999998
R638 a_64549_20015.n58 a_64549_20015.n60 1.1826099853515626
R639 a_64549_20015.n54 a_64549_20015.n58 0.41739099121093748
R640 a_64549_20015.n31 a_64549_20015.n71 14.817400390625
R641 a_64549_20015.n54 a_64549_20015.n52 17.100199218749999
R642 a_64549_20015.n52 a_64549_20015.n61 0.40851098632812499
R643 a_64549_20015.n61 a_64549_20015.n50 5.8553198242187499
R644 a_64549_20015.n50 a_64549_20015.n48 6.2638300781250003
R645 a_64549_20015.n48 a_64549_20015.n46 6.2638300781250003
R646 a_64549_20015.n46 a_64549_20015.n44 6.2638300781250003
R647 a_64549_20015.n44 a_64549_20015.n42 6.2638300781250003
R648 a_64549_20015.n64 a_64549_20015.n63 152
R649 a_64549_20015.n66 a_64549_20015.n65 152
R650 a_64549_20015.n68 a_64549_20015.n67 152
R651 a_64549_20015.n42 a_64549_20015.n40 5.6090898437499996
R652 a_64549_20015.n40 a_64549_20015.n64 0.43835598754882815
R653 a_64549_20015.n64 a_64549_20015.n38 3.5945200195312501
R654 a_64549_20015.n38 a_64549_20015.n66 2.0164399414062499
R655 a_64549_20015.n66 a_64549_20015.n36 2.0164399414062499
R656 a_64549_20015.n36 a_64549_20015.n68 3.5945200195312501
R657 a_64549_20015.n34 a_64549_20015.n68 0.43835598754882815
R658 a_64549_20015.n34 a_64549_20015.n32 4.0328798828124999
R659 a_64549_20015.n32 a_64549_20015.n70 1.13972998046875
R660 a_64549_20015.n62 a_64549_20015.n70 2.630139892578125
R661 a_64549_20015.n33 a_64549_20015.n62 7.0755200195312504
R662 a_64549_20015.n63 a_64549_20015.n65 62.955101562499998
R663 a_64549_20015.n65 a_64549_20015.n69 31.477599609375002
R664 a_64549_20015.n67 a_64549_20015.n69 31.477599609375002
R665 a_64549_20015.n67 a_64549_20015.n70 214.95500000000001
R666 a_64549_20015.n63 a_64549_20015.t38 538.31200000000001
R667 a_64549_20015.n69 a_64549_20015.t38 68.698898437500006
R668 a_64549_20015.n62 a_64549_20015.t24 214.45500000000001
R669 a_64549_20015.n61 a_64549_20015.t25 214.45500000000001
R670 a_64549_20015.n60 a_64549_20015.t39 259.08100000000002
R671 a_64549_20015.n59 a_64549_20015.t22 214.45500000000001
R672 a_64549_20015.n58 a_64549_20015.t21 214.45500000000001
R673 a_64549_20015.n17 a_64549_20015.n19 62.955101562499998
R674 a_64549_20015.n19 a_64549_20015.n21 31.477599609375002
R675 a_64549_20015.n22 a_64549_20015.n21 31.477599609375002
R676 a_64549_20015.n22 a_64549_20015.n211 225.96299999999999
R677 a_64549_20015.n17 a_64549_20015.t36 538.31200000000001
R678 a_64549_20015.n21 a_64549_20015.t36 68.698898437500006
R679 a_64549_20015.n212 a_64549_20015.t28 215.99100000000001
R680 a_64549_20015.n14 a_64549_20015.t4 214.45500000000001
R681 a_64549_20015.n10 a_64549_20015.t37 116.733
R682 a_64549_20015.n5 a_64549_20015.t27 214.45500000000001
R683 a_64549_20015.n4 a_64549_20015.t8 214.45500000000001
C155 m5_66900_20000# a_64549_20015# 0 $ **FLOATING
C156 m5_64900_20000# a_64549_20015# 0 $ **FLOATING
C157 m5_64400_20000# a_64549_20015# 0 $ **FLOATING
C158 m5_66900_20600# a_64549_20015# 0 $ **FLOATING
C159 m5_64900_20600# a_64549_20015# 0 $ **FLOATING
C160 m5_64400_20600# a_64549_20015# 0 $ **FLOATING
C161 m5_66900_22600# a_64549_20015# 0 $ **FLOATING
C162 m5_64900_22600# a_64549_20015# 0 $ **FLOATING
C163 m5_64400_22600# a_64549_20015# 0 $ **FLOATING
C164 m5_21584_107200# a_64549_20015# 0 $ **FLOATING
C165 m5_21584_108600# a_64549_20015# 0 $ **FLOATING
C166 m5_20864_107200# a_64549_20015# 8.8871e-16
C167 m5_20000_107200# a_64549_20015# 0 $ **FLOATING
C168 m5_20000_108600# a_64549_20015# 0 $ **FLOATING
C169 m4_67310_20000# a_64549_20015# 0 $ **FLOATING
C170 m4_66750_20000# a_64549_20015# 0 $ **FLOATING
C171 m4_67310_20290# a_64549_20015# 0 $ **FLOATING
C172 m4_66190_20010# a_64549_20015# 0 $ **FLOATING
C173 m4_65070_20000# a_64549_20015# 0 $ **FLOATING
C174 m4_66750_20430# a_64549_20015# 0 $ **FLOATING
C175 m4_65630_20150# a_64549_20015# 0 $ **FLOATING
C176 m4_64510_20000# a_64549_20015# 0 $ **FLOATING
C177 m4_67310_20850# a_64549_20015# 0 $ **FLOATING
C178 m4_66190_20570# a_64549_20015# 0 $ **FLOATING
C179 m4_65070_20290# a_64549_20015# 0 $ **FLOATING
C180 m4_66750_20990# a_64549_20015# 0 $ **FLOATING
C181 m4_65630_20710# a_64549_20015# 0 $ **FLOATING
C182 m4_64510_20430# a_64549_20015# 0 $ **FLOATING
C183 m4_67310_21410# a_64549_20015# 0 $ **FLOATING
C184 m4_66190_21130# a_64549_20015# 0 $ **FLOATING
C185 m4_65070_20850# a_64549_20015# 0 $ **FLOATING
C186 m4_66750_21550# a_64549_20015# 0 $ **FLOATING
C187 m4_65630_21270# a_64549_20015# 0 $ **FLOATING
C188 m4_64510_20990# a_64549_20015# 0 $ **FLOATING
C189 m4_67310_21970# a_64549_20015# 0 $ **FLOATING
C190 m4_66190_21690# a_64549_20015# 0 $ **FLOATING
C191 m4_65070_21410# a_64549_20015# 0 $ **FLOATING
C192 m4_66750_22110# a_64549_20015# 0 $ **FLOATING
C193 m4_65630_21830# a_64549_20015# 0 $ **FLOATING
C194 m4_64510_21550# a_64549_20015# 0 $ **FLOATING
C195 m4_67310_22530# a_64549_20015# 0 $ **FLOATING
C196 m4_66190_22250# a_64549_20015# 0 $ **FLOATING
C197 m4_65070_21970# a_64549_20015# 0 $ **FLOATING
C198 m4_66750_22670# a_64549_20015# 0 $ **FLOATING
C199 m4_65630_22390# a_64549_20015# 0 $ **FLOATING
C200 m4_64510_22110# a_64549_20015# 0 $ **FLOATING
C201 m4_67310_23090# a_64549_20015# 0 $ **FLOATING
C202 m4_66190_22810# a_64549_20015# 0 $ **FLOATING
C203 m4_65070_22530# a_64549_20015# 0 $ **FLOATING
C204 m4_66750_23230# a_64549_20015# 0 $ **FLOATING
C205 m4_65630_22950# a_64549_20015# 0 $ **FLOATING
C206 m4_64510_22670# a_64549_20015# 0 $ **FLOATING
C207 m4_65070_23090# a_64549_20015# 0 $ **FLOATING
C208 m4_64510_23230# a_64549_20015# 0 $ **FLOATING
C209 m4_20000_107214# a_64549_20015# 5.3096900000000011e-16
C210 m4_22056_107380# a_64549_20015# 0 $ **FLOATING
C211 m4_21770_107380# a_64549_20015# 0 $ **FLOATING
C212 m4_20000_107598# a_64549_20015# 1.1617500000000001e-16
C213 m4_22410_107740# a_64549_20015# 0 $ **FLOATING
C214 m4_22250_107770# a_64549_20015# 0 $ **FLOATING
C215 m4_22090_107800# a_64549_20015# 0 $ **FLOATING
C216 m4_21352_107764# a_64549_20015# 0 $ **FLOATING
C217 m4_20650_107750# a_64549_20015# 0 $ **FLOATING
C218 m4_20472_107760# a_64549_20015# 0 $ **FLOATING
C219 m4_20000_107982# a_64549_20015# 2.46726e-16
C220 m4_22408_108156# a_64549_20015# 0 $ **FLOATING
C221 m4_22408_108332# a_64549_20015# 0 $ **FLOATING
C222 m4_22232_108296# a_64549_20015# 0 $ **FLOATING
C223 m4_22056_108260# a_64549_20015# 0 $ **FLOATING
C224 m4_21880_108224# a_64549_20015# 0 $ **FLOATING
C225 m4_21704_108188# a_64549_20015# 0 $ **FLOATING
C226 m4_21528_108152# a_64549_20015# 0 $ **FLOATING
C227 m4_22408_108508# a_64549_20015# 0 $ **FLOATING
C228 m4_22232_108472# a_64549_20015# 0 $ **FLOATING
C229 m4_22056_108436# a_64549_20015# 0 $ **FLOATING
C230 m4_21880_108400# a_64549_20015# 0 $ **FLOATING
C231 m4_21704_108364# a_64549_20015# 0 $ **FLOATING
C232 m4_21528_108328# a_64549_20015# 0 $ **FLOATING
C233 m4_21352_108292# a_64549_20015# 0 $ **FLOATING
C234 m4_21176_108256# a_64549_20015# 0 $ **FLOATING
C235 m4_21000_108220# a_64549_20015# 0 $ **FLOATING
C236 m4_20824_108184# a_64549_20015# 0 $ **FLOATING
C237 m4_20648_108148# a_64549_20015# 0 $ **FLOATING
C238 m4_22408_108684# a_64549_20015# 0 $ **FLOATING
C239 m4_22232_108648# a_64549_20015# 0 $ **FLOATING
C240 m4_22056_108612# a_64549_20015# 0 $ **FLOATING
C241 m4_21880_108576# a_64549_20015# 0 $ **FLOATING
C242 m4_21704_108540# a_64549_20015# 0 $ **FLOATING
C243 m4_21528_108504# a_64549_20015# 0 $ **FLOATING
C244 m4_21352_108468# a_64549_20015# 0 $ **FLOATING
C245 m4_21176_108432# a_64549_20015# 0 $ **FLOATING
C246 m4_21000_108396# a_64549_20015# 0 $ **FLOATING
C247 m4_20824_108360# a_64549_20015# 0 $ **FLOATING
C248 m4_20648_108324# a_64549_20015# 0 $ **FLOATING
C249 m4_20472_108288# a_64549_20015# 0 $ **FLOATING
C250 m4_20296_108252# a_64549_20015# 0 $ **FLOATING
C251 m4_20120_108216# a_64549_20015# 0 $ **FLOATING
C252 m4_20000_108180# a_64549_20015# 0 $ **FLOATING
C253 m4_22408_108860# a_64549_20015# 0 $ **FLOATING
C254 m4_22232_108824# a_64549_20015# 0 $ **FLOATING
C255 m4_22056_108788# a_64549_20015# 0 $ **FLOATING
C256 m4_21880_108752# a_64549_20015# 0 $ **FLOATING
C257 m4_21704_108716# a_64549_20015# 0 $ **FLOATING
C258 m4_21528_108680# a_64549_20015# 0 $ **FLOATING
C259 m4_21352_108644# a_64549_20015# 0 $ **FLOATING
C260 m4_21176_108608# a_64549_20015# 0 $ **FLOATING
C261 m4_21000_108572# a_64549_20015# 0 $ **FLOATING
C262 m4_20824_108536# a_64549_20015# 0 $ **FLOATING
C263 m4_20648_108500# a_64549_20015# 0 $ **FLOATING
C264 m4_20472_108464# a_64549_20015# 0 $ **FLOATING
C265 m4_20296_108428# a_64549_20015# 0 $ **FLOATING
C266 m4_20120_108392# a_64549_20015# 0 $ **FLOATING
C267 m4_20000_108356# a_64549_20015# 0 $ **FLOATING
C268 m4_21528_108856# a_64549_20015# 0 $ **FLOATING
C269 m4_21352_108820# a_64549_20015# 0 $ **FLOATING
C270 m4_21176_108784# a_64549_20015# 0 $ **FLOATING
C271 m4_21000_108748# a_64549_20015# 0 $ **FLOATING
C272 m4_20824_108712# a_64549_20015# 0 $ **FLOATING
C273 m4_20648_108676# a_64549_20015# 0 $ **FLOATING
C274 m4_20472_108640# a_64549_20015# 0 $ **FLOATING
C275 m4_20296_108604# a_64549_20015# 0 $ **FLOATING
C276 m4_20120_108568# a_64549_20015# 0 $ **FLOATING
C277 m4_20000_108532# a_64549_20015# 0 $ **FLOATING
C278 m4_20648_108852# a_64549_20015# 0 $ **FLOATING
C279 m4_20472_108816# a_64549_20015# 0 $ **FLOATING
C280 m4_20296_108780# a_64549_20015# 0 $ **FLOATING
C281 m4_20120_108744# a_64549_20015# 0 $ **FLOATING
C282 m4_20000_108708# a_64549_20015# 0 $ **FLOATING
C283 m4_22410_109660# a_64549_20015# 0 $ **FLOATING
C284 m4_22250_109690# a_64549_20015# 0 $ **FLOATING
C285 m4_22056_109668# a_64549_20015# 0 $ **FLOATING
C286 m4_21880_109632# a_64549_20015# 0 $ **FLOATING
C287 m4_21704_109596# a_64549_20015# 0 $ **FLOATING
C288 m4_21450_109680# a_64549_20015# 0 $ **FLOATING
C289 m4_21176_109664# a_64549_20015# 0 $ **FLOATING
C290 m4_21000_109628# a_64549_20015# 0 $ **FLOATING
C291 m4_20824_109592# a_64549_20015# 0 $ **FLOATING
C292 m4_20650_109670# a_64549_20015# 0 $ **FLOATING
C293 m3_67310_20000# a_64549_20015# 0 $ **FLOATING
C294 m3_66750_20000# a_64549_20015# 0 $ **FLOATING
C295 m3_67310_20290# a_64549_20015# 0 $ **FLOATING
C296 m3_66190_20010# a_64549_20015# 0 $ **FLOATING
C297 m3_65070_20000# a_64549_20015# 0 $ **FLOATING
C298 m3_66750_20430# a_64549_20015# 0 $ **FLOATING
C299 m3_65630_20150# a_64549_20015# 0 $ **FLOATING
C300 m3_64510_20000# a_64549_20015# 0 $ **FLOATING
C301 m3_67310_20850# a_64549_20015# 0 $ **FLOATING
C302 m3_66190_20570# a_64549_20015# 0 $ **FLOATING
C303 m3_65070_20290# a_64549_20015# 0 $ **FLOATING
C304 m3_66750_20990# a_64549_20015# 0 $ **FLOATING
C305 m3_65630_20710# a_64549_20015# 0 $ **FLOATING
C306 m3_64510_20430# a_64549_20015# 0 $ **FLOATING
C307 m3_67310_21410# a_64549_20015# 0 $ **FLOATING
C308 m3_66190_21130# a_64549_20015# 0 $ **FLOATING
C309 m3_65070_20850# a_64549_20015# 0 $ **FLOATING
C310 m3_66750_21550# a_64549_20015# 0 $ **FLOATING
C311 m3_65630_21270# a_64549_20015# 0 $ **FLOATING
C312 m3_64510_20990# a_64549_20015# 0 $ **FLOATING
C313 m3_67310_21970# a_64549_20015# 0 $ **FLOATING
C314 m3_66190_21690# a_64549_20015# 0 $ **FLOATING
C315 m3_65070_21410# a_64549_20015# 0 $ **FLOATING
C316 m3_66750_22110# a_64549_20015# 0 $ **FLOATING
C317 m3_65630_21830# a_64549_20015# 0 $ **FLOATING
C318 m3_64510_21550# a_64549_20015# 0 $ **FLOATING
C319 m3_67310_22530# a_64549_20015# 0 $ **FLOATING
C320 m3_66190_22250# a_64549_20015# 0 $ **FLOATING
C321 m3_65070_21970# a_64549_20015# 0 $ **FLOATING
C322 m3_66750_22670# a_64549_20015# 0 $ **FLOATING
C323 m3_65630_22390# a_64549_20015# 0 $ **FLOATING
C324 m3_64510_22110# a_64549_20015# 0 $ **FLOATING
C325 m3_67310_23090# a_64549_20015# 0 $ **FLOATING
C326 m3_66190_22810# a_64549_20015# 0 $ **FLOATING
C327 m3_65070_22530# a_64549_20015# 0 $ **FLOATING
C328 m3_66750_23230# a_64549_20015# 0 $ **FLOATING
C329 m3_65630_22950# a_64549_20015# 0 $ **FLOATING
C330 m3_64510_22670# a_64549_20015# 0 $ **FLOATING
C331 m3_65070_23090# a_64549_20015# 0 $ **FLOATING
C332 m3_64510_23230# a_64549_20015# 0 $ **FLOATING
C333 m3_22338_107200# a_64549_20015# 0 $ **FLOATING
C334 m3_22162_107200# a_64549_20015# 0 $ **FLOATING
C335 m3_21986_107200# a_64549_20015# 0 $ **FLOATING
C336 m3_22338_107346# a_64549_20015# 0 $ **FLOATING
C337 m3_22162_107310# a_64549_20015# 0 $ **FLOATING
C338 m3_21986_107274# a_64549_20015# 0 $ **FLOATING
C339 m3_21810_107238# a_64549_20015# 0 $ **FLOATING
C340 m3_21282_107200# a_64549_20015# 0 $ **FLOATING
C341 m3_21106_107200# a_64549_20015# 0 $ **FLOATING
C342 m3_22162_107486# a_64549_20015# 0 $ **FLOATING
C343 m3_21986_107450# a_64549_20015# 0 $ **FLOATING
C344 m3_21810_107414# a_64549_20015# 0 $ **FLOATING
C345 m3_21282_107306# a_64549_20015# 0 $ **FLOATING
C346 m3_21106_107270# a_64549_20015# 0 $ **FLOATING
C347 m3_20930_107234# a_64549_20015# 0 $ **FLOATING
C348 m3_20754_107200# a_64549_20015# 0 $ **FLOATING
C349 m3_20578_107200# a_64549_20015# 0 $ **FLOATING
C350 m3_20402_107200# a_64549_20015# 0 $ **FLOATING
C351 m3_20226_107200# a_64549_20015# 0 $ **FLOATING
C352 m3_21536_107398# a_64549_20015# 1.5996000000000004e-16
C353 m3_22162_107662# a_64549_20015# 0 $ **FLOATING
C354 m3_21986_107626# a_64549_20015# 0 $ **FLOATING
C355 m3_21810_107590# a_64549_20015# 0 $ **FLOATING
C356 m3_21282_107482# a_64549_20015# 0 $ **FLOATING
C357 m3_21106_107446# a_64549_20015# 0 $ **FLOATING
C358 m3_20930_107410# a_64549_20015# 0 $ **FLOATING
C359 m3_20754_107374# a_64549_20015# 0 $ **FLOATING
C360 m3_20578_107338# a_64549_20015# 0 $ **FLOATING
C361 m3_20402_107302# a_64549_20015# 0 $ **FLOATING
C362 m3_20226_107266# a_64549_20015# 0 $ **FLOATING
C363 m3_20050_107230# a_64549_20015# 0 $ **FLOATING
C364 m3_22162_107838# a_64549_20015# 0 $ **FLOATING
C365 m3_21986_107802# a_64549_20015# 0 $ **FLOATING
C366 m3_21810_107766# a_64549_20015# 0 $ **FLOATING
C367 m3_21634_107730# a_64549_20015# 0 $ **FLOATING
C368 m3_21458_107694# a_64549_20015# 0 $ **FLOATING
C369 m3_21282_107658# a_64549_20015# 0 $ **FLOATING
C370 m3_21106_107622# a_64549_20015# 0 $ **FLOATING
C371 m3_20930_107586# a_64549_20015# 0 $ **FLOATING
C372 m3_20754_107550# a_64549_20015# 0 $ **FLOATING
C373 m3_20226_107442# a_64549_20015# 0 $ **FLOATING
C374 m3_20050_107406# a_64549_20015# 0 $ **FLOATING
C375 m3_22162_108014# a_64549_20015# 0 $ **FLOATING
C376 m3_21810_107942# a_64549_20015# 0 $ **FLOATING
C377 m3_21634_107906# a_64549_20015# 0 $ **FLOATING
C378 m3_21458_107870# a_64549_20015# 0 $ **FLOATING
C379 m3_21282_107834# a_64549_20015# 0 $ **FLOATING
C380 m3_21106_107798# a_64549_20015# 0 $ **FLOATING
C381 m3_20930_107762# a_64549_20015# 0 $ **FLOATING
C382 m3_20754_107726# a_64549_20015# 0 $ **FLOATING
C383 m3_22390_108240# a_64549_20015# 0 $ **FLOATING
C384 m3_22390_108400# a_64549_20015# 0 $ **FLOATING
C385 m3_22090_108240# a_64549_20015# 0 $ **FLOATING
C386 m3_21830_108120# a_64549_20015# 0 $ **FLOATING
C387 m3_21634_108082# a_64549_20015# 0 $ **FLOATING
C388 m3_21106_107974# a_64549_20015# 0 $ **FLOATING
C389 m3_20930_107938# a_64549_20015# 0 $ **FLOATING
C390 m3_20754_107902# a_64549_20015# 0 $ **FLOATING
C391 m3_20270_107650# a_64549_20015# 0 $ **FLOATING
C392 m3_20050_107582# a_64549_20015# 0 $ **FLOATING
C393 m3_20050_107758# a_64549_20015# 0 $ **FLOATING
C394 m3_20050_107934# a_64549_20015# 0 $ **FLOATING
C395 m3_21570_108260# a_64549_20015# 0 $ **FLOATING
C396 m3_21310_108140# a_64549_20015# 0 $ **FLOATING
C397 m3_21050_108280# a_64549_20015# 0 $ **FLOATING
C398 m3_20790_108160# a_64549_20015# 0 $ **FLOATING
C399 m3_20578_108218# a_64549_20015# 0 $ **FLOATING
C400 m3_20270_108180# a_64549_20015# 0 $ **FLOATING
C401 m3_20050_108110# a_64549_20015# 0 $ **FLOATING
C402 m3_22338_108578# a_64549_20015# 0 $ **FLOATING
C403 m3_22162_108542# a_64549_20015# 0 $ **FLOATING
C404 m3_21986_108506# a_64549_20015# 0 $ **FLOATING
C405 m3_20754_108430# a_64549_20015# 0 $ **FLOATING
C406 m3_20578_108394# a_64549_20015# 0 $ **FLOATING
C407 m3_20050_108286# a_64549_20015# 0 $ **FLOATING
C408 m3_22338_108754# a_64549_20015# 0 $ **FLOATING
C409 m3_22162_108718# a_64549_20015# 0 $ **FLOATING
C410 m3_21986_108682# a_64549_20015# 0 $ **FLOATING
C411 m3_21810_108646# a_64549_20015# 0 $ **FLOATING
C412 m3_21634_108610# a_64549_20015# 0 $ **FLOATING
C413 m3_21458_108574# a_64549_20015# 0 $ **FLOATING
C414 m3_22338_108930# a_64549_20015# 0 $ **FLOATING
C415 m3_22162_108894# a_64549_20015# 0 $ **FLOATING
C416 m3_21986_108858# a_64549_20015# 0 $ **FLOATING
C417 m3_21810_108822# a_64549_20015# 0 $ **FLOATING
C418 m3_21634_108786# a_64549_20015# 0 $ **FLOATING
C419 m3_21458_108750# a_64549_20015# 0 $ **FLOATING
C420 m3_21282_108714# a_64549_20015# 0 $ **FLOATING
C421 m3_21106_108678# a_64549_20015# 0 $ **FLOATING
C422 m3_20930_108642# a_64549_20015# 0 $ **FLOATING
C423 m3_20754_108606# a_64549_20015# 0 $ **FLOATING
C424 m3_20578_108570# a_64549_20015# 0 $ **FLOATING
C425 m3_20402_108534# a_64549_20015# 0 $ **FLOATING
C426 m3_20226_108498# a_64549_20015# 0 $ **FLOATING
C427 m3_20050_108462# a_64549_20015# 0 $ **FLOATING
C428 m3_22338_109106# a_64549_20015# 0 $ **FLOATING
C429 m3_22162_109070# a_64549_20015# 0 $ **FLOATING
C430 m3_21986_109034# a_64549_20015# 0 $ **FLOATING
C431 m3_21458_108926# a_64549_20015# 0 $ **FLOATING
C432 m3_21282_108890# a_64549_20015# 0 $ **FLOATING
C433 m3_21106_108854# a_64549_20015# 0 $ **FLOATING
C434 m3_20930_108818# a_64549_20015# 0 $ **FLOATING
C435 m3_20754_108782# a_64549_20015# 0 $ **FLOATING
C436 m3_20578_108746# a_64549_20015# 0 $ **FLOATING
C437 m3_20402_108710# a_64549_20015# 0 $ **FLOATING
C438 m3_20226_108674# a_64549_20015# 0 $ **FLOATING
C439 m3_20050_108638# a_64549_20015# 0 $ **FLOATING
C440 m3_22338_109282# a_64549_20015# 0 $ **FLOATING
C441 m3_22162_109246# a_64549_20015# 0 $ **FLOATING
C442 m3_21986_109210# a_64549_20015# 0 $ **FLOATING
C443 m3_21458_109102# a_64549_20015# 0 $ **FLOATING
C444 m3_21282_109066# a_64549_20015# 0 $ **FLOATING
C445 m3_21106_109030# a_64549_20015# 0 $ **FLOATING
C446 m3_20930_108994# a_64549_20015# 0 $ **FLOATING
C447 m3_20754_108958# a_64549_20015# 0 $ **FLOATING
C448 m3_20578_108922# a_64549_20015# 0 $ **FLOATING
C449 m3_20226_108850# a_64549_20015# 0 $ **FLOATING
C450 m3_20050_108814# a_64549_20015# 0 $ **FLOATING
C451 m3_22338_109458# a_64549_20015# 0 $ **FLOATING
C452 m3_22162_109422# a_64549_20015# 0 $ **FLOATING
C453 m3_21986_109386# a_64549_20015# 0 $ **FLOATING
C454 m3_21458_109278# a_64549_20015# 0 $ **FLOATING
C455 m3_21282_109242# a_64549_20015# 0 $ **FLOATING
C456 m3_21106_109206# a_64549_20015# 0 $ **FLOATING
C457 m3_20930_109170# a_64549_20015# 0 $ **FLOATING
C458 m3_20754_109134# a_64549_20015# 0 $ **FLOATING
C459 m3_20578_109098# a_64549_20015# 0 $ **FLOATING
C460 m3_20050_108990# a_64549_20015# 0 $ **FLOATING
C461 m3_22338_109634# a_64549_20015# 0 $ **FLOATING
C462 m3_22162_109598# a_64549_20015# 0 $ **FLOATING
C463 m3_21986_109562# a_64549_20015# 0 $ **FLOATING
C464 m3_21458_109454# a_64549_20015# 0 $ **FLOATING
C465 m3_21282_109418# a_64549_20015# 0 $ **FLOATING
C466 m3_21106_109382# a_64549_20015# 0 $ **FLOATING
C467 m3_20930_109346# a_64549_20015# 0 $ **FLOATING
C468 m3_20754_109310# a_64549_20015# 0 $ **FLOATING
C469 m3_20578_109274# a_64549_20015# 0 $ **FLOATING
C470 m3_20050_109166# a_64549_20015# 0 $ **FLOATING
C471 m3_21634_109666# a_64549_20015# 0 $ **FLOATING
C472 m3_21458_109630# a_64549_20015# 0 $ **FLOATING
C473 m3_21282_109594# a_64549_20015# 0 $ **FLOATING
C474 m3_21106_109558# a_64549_20015# 0 $ **FLOATING
C475 m3_20930_109522# a_64549_20015# 0 $ **FLOATING
C476 m3_20754_109486# a_64549_20015# 0 $ **FLOATING
C477 m3_20578_109450# a_64549_20015# 0 $ **FLOATING
C478 m3_20050_109342# a_64549_20015# 0 $ **FLOATING
C479 m3_20754_109662# a_64549_20015# 0 $ **FLOATING
C480 m3_20578_109626# a_64549_20015# 0 $ **FLOATING
C481 m3_20050_109518# a_64549_20015# 0 $ **FLOATING
C482 m3_20050_109694# a_64549_20015# 0 $ **FLOATING
C483 m2_67310_20000# a_64549_20015# 0 $ **FLOATING
C484 m2_67340_20180# a_64549_20015# 0 $ **FLOATING
C485 m2_66750_20000# a_64549_20015# 0 $ **FLOATING
C486 m2_66640_20020# a_64549_20015# 0 $ **FLOATING
C487 m2_66640_20120# a_64549_20015# 0 $ **FLOATING
C488 m2_66640_20220# a_64549_20015# 0 $ **FLOATING
C489 m2_67310_20290# a_64549_20015# 0 $ **FLOATING
C490 m2_67140_20320# a_64549_20015# 0 $ **FLOATING
C491 m2_66640_20320# a_64549_20015# 0 $ **FLOATING
C492 m2_66190_20010# a_64549_20015# 0 $ **FLOATING
C493 m2_66040_20040# a_64549_20015# 0 $ **FLOATING
C494 m2_65540_20040# a_64549_20015# 0 $ **FLOATING
C495 m2_65070_20000# a_64549_20015# 0 $ **FLOATING
C496 m2_67540_20740# a_64549_20015# 0 $ **FLOATING
C497 m2_66750_20430# a_64549_20015# 0 $ **FLOATING
C498 m2_66640_20420# a_64549_20015# 0 $ **FLOATING
C499 m2_66440_20460# a_64549_20015# 0 $ **FLOATING
C500 m2_66640_20520# a_64549_20015# 0 $ **FLOATING
C501 m2_65630_20150# a_64549_20015# 0 $ **FLOATING
C502 m2_65340_20180# a_64549_20015# 0 $ **FLOATING
C503 m2_64510_20000# a_64549_20015# 0 $ **FLOATING
C504 m2_66640_20620# a_64549_20015# 0 $ **FLOATING
C505 m2_66640_20720# a_64549_20015# 0 $ **FLOATING
C506 m2_67310_20850# a_64549_20015# 0 $ **FLOATING
C507 m2_66640_20820# a_64549_20015# 0 $ **FLOATING
C508 m2_66840_20880# a_64549_20015# 0 $ **FLOATING
C509 m2_66640_20920# a_64549_20015# 0 $ **FLOATING
C510 m2_66190_20570# a_64549_20015# 0 $ **FLOATING
C511 m2_65740_20600# a_64549_20015# 0 $ **FLOATING
C512 m2_65070_20290# a_64549_20015# 0 $ **FLOATING
C513 m2_64640_20320# a_64549_20015# 0 $ **FLOATING
C514 m2_67240_21300# a_64549_20015# 0 $ **FLOATING
C515 m2_66750_20990# a_64549_20015# 0 $ **FLOATING
C516 m2_66640_21020# a_64549_20015# 0 $ **FLOATING
C517 m2_66140_21020# a_64549_20015# 0 $ **FLOATING
C518 m2_65630_20710# a_64549_20015# 0 $ **FLOATING
C519 m2_65040_20740# a_64549_20015# 0 $ **FLOATING
C520 m2_64510_20430# a_64549_20015# 0 $ **FLOATING
C521 m2_66640_21120# a_64549_20015# 0 $ **FLOATING
C522 m2_66640_21220# a_64549_20015# 0 $ **FLOATING
C523 m2_66640_21320# a_64549_20015# 0 $ **FLOATING
C524 m2_67310_21410# a_64549_20015# 0 $ **FLOATING
C525 m2_67040_21440# a_64549_20015# 0 $ **FLOATING
C526 m2_66640_21420# a_64549_20015# 0 $ **FLOATING
C527 m2_67440_21860# a_64549_20015# 0 $ **FLOATING
C528 m2_66750_21550# a_64549_20015# 0 $ **FLOATING
C529 m2_66640_21520# a_64549_20015# 0 $ **FLOATING
C530 m2_66190_21130# a_64549_20015# 0 $ **FLOATING
C531 m2_65940_21160# a_64549_20015# 0 $ **FLOATING
C532 m2_65070_20850# a_64549_20015# 0 $ **FLOATING
C533 m2_64840_20880# a_64549_20015# 0 $ **FLOATING
C534 m2_66640_21620# a_64549_20015# 0 $ **FLOATING
C535 m2_66340_21580# a_64549_20015# 0 $ **FLOATING
C536 m2_65630_21270# a_64549_20015# 0 $ **FLOATING
C537 m2_65240_21300# a_64549_20015# 0 $ **FLOATING
C538 m2_64510_20990# a_64549_20015# 0 $ **FLOATING
C539 m2_66640_21720# a_64549_20015# 0 $ **FLOATING
C540 m2_66640_21820# a_64549_20015# 0 $ **FLOATING
C541 m2_67310_21970# a_64549_20015# 0 $ **FLOATING
C542 m2_66640_21920# a_64549_20015# 0 $ **FLOATING
C543 m2_66740_22000# a_64549_20015# 0 $ **FLOATING
C544 m2_66640_22020# a_64549_20015# 0 $ **FLOATING
C545 m2_66190_21690# a_64549_20015# 0 $ **FLOATING
C546 m2_65640_21720# a_64549_20015# 0 $ **FLOATING
C547 m2_65070_21410# a_64549_20015# 0 $ **FLOATING
C548 m2_64540_21440# a_64549_20015# 0 $ **FLOATING
C549 m2_66750_22110# a_64549_20015# 0 $ **FLOATING
C550 m2_66640_22120# a_64549_20015# 0 $ **FLOATING
C551 m2_66540_22140# a_64549_20015# 0 $ **FLOATING
C552 m2_66640_22220# a_64549_20015# 0 $ **FLOATING
C553 m2_65630_21830# a_64549_20015# 0 $ **FLOATING
C554 m2_65440_21860# a_64549_20015# 0 $ **FLOATING
C555 m2_64510_21550# a_64549_20015# 0 $ **FLOATING
C556 m2_66640_22320# a_64549_20015# 0 $ **FLOATING
C557 m2_66640_22420# a_64549_20015# 0 $ **FLOATING
C558 m2_67310_22530# a_64549_20015# 0 $ **FLOATING
C559 m2_66940_22560# a_64549_20015# 0 $ **FLOATING
C560 m2_66640_22520# a_64549_20015# 0 $ **FLOATING
C561 m2_67340_22980# a_64549_20015# 0 $ **FLOATING
C562 m2_66750_22670# a_64549_20015# 0 $ **FLOATING
C563 m2_66640_22620# a_64549_20015# 0 $ **FLOATING
C564 m2_66190_22250# a_64549_20015# 0 $ **FLOATING
C565 m2_65840_22280# a_64549_20015# 0 $ **FLOATING
C566 m2_65070_21970# a_64549_20015# 0 $ **FLOATING
C567 m2_64740_22000# a_64549_20015# 0 $ **FLOATING
C568 m2_66640_22720# a_64549_20015# 0 $ **FLOATING
C569 m2_66240_22700# a_64549_20015# 0 $ **FLOATING
C570 m2_65630_22390# a_64549_20015# 0 $ **FLOATING
C571 m2_65140_22420# a_64549_20015# 0 $ **FLOATING
C572 m2_64510_22110# a_64549_20015# 0 $ **FLOATING
C573 m2_66640_22820# a_64549_20015# 0 $ **FLOATING
C574 m2_66640_22920# a_64549_20015# 0 $ **FLOATING
C575 m2_66640_23020# a_64549_20015# 0 $ **FLOATING
C576 m2_67310_23090# a_64549_20015# 0 $ **FLOATING
C577 m2_67140_23120# a_64549_20015# 0 $ **FLOATING
C578 m2_66640_23120# a_64549_20015# 0 $ **FLOATING
C579 m2_66190_22810# a_64549_20015# 0 $ **FLOATING
C580 m2_66040_22840# a_64549_20015# 0 $ **FLOATING
C581 m2_65540_22840# a_64549_20015# 0 $ **FLOATING
C582 m2_65070_22530# a_64549_20015# 0 $ **FLOATING
C583 m2_64940_22560# a_64549_20015# 0 $ **FLOATING
C584 m2_64440_22560# a_64549_20015# 0 $ **FLOATING
C585 m2_66750_23230# a_64549_20015# 0 $ **FLOATING
C586 m2_66640_23220# a_64549_20015# 0 $ **FLOATING
C587 m2_66440_23260# a_64549_20015# 0 $ **FLOATING
C588 m2_65630_22950# a_64549_20015# 0 $ **FLOATING
C589 m2_65340_22980# a_64549_20015# 0 $ **FLOATING
C590 m2_64510_22670# a_64549_20015# 0 $ **FLOATING
C591 m2_65070_23090# a_64549_20015# 0 $ **FLOATING
C592 m2_64640_23120# a_64549_20015# 0 $ **FLOATING
C593 m2_64510_23230# a_64549_20015# 0 $ **FLOATING
C594 m2_22440_107200# a_64549_20015# 0 $ **FLOATING
C595 m2_22340_107200# a_64549_20015# 0 $ **FLOATING
C596 m2_22240_107200# a_64549_20015# 0 $ **FLOATING
C597 m2_21940_107200# a_64549_20015# 0 $ **FLOATING
C598 m2_21840_107200# a_64549_20015# 0 $ **FLOATING
C599 m2_21740_107200# a_64549_20015# 0 $ **FLOATING
C600 m2_21440_107200# a_64549_20015# 0 $ **FLOATING
C601 m2_21340_107200# a_64549_20015# 0 $ **FLOATING
C602 m2_21240_107200# a_64549_20015# 0 $ **FLOATING
C603 m2_20940_107200# a_64549_20015# 0 $ **FLOATING
C604 m2_20840_107200# a_64549_20015# 0 $ **FLOATING
C605 m2_20740_107200# a_64549_20015# 0 $ **FLOATING
C606 m2_20440_107200# a_64549_20015# 0 $ **FLOATING
C607 m2_20340_107200# a_64549_20015# 0 $ **FLOATING
C608 m2_20240_107200# a_64549_20015# 0 $ **FLOATING
C609 m2_20000_107326# a_64549_20015# 6.0877200000000016e-16
C610 m2_22400_107476# a_64549_20015# 0 $ **FLOATING
C611 m2_22244_107460# a_64549_20015# 0 $ **FLOATING
C612 m2_22140_107420# a_64549_20015# 0 $ **FLOATING
C613 m2_22040_107440# a_64549_20015# 0 $ **FLOATING
C614 m2_21940_107460# a_64549_20015# 0 $ **FLOATING
C615 m2_21640_107420# a_64549_20015# 0 $ **FLOATING
C616 m2_22400_107632# a_64549_20015# 0 $ **FLOATING
C617 m2_22244_107616# a_64549_20015# 0 $ **FLOATING
C618 m2_22088_107600# a_64549_20015# 0 $ **FLOATING
C619 m2_21932_107584# a_64549_20015# 0 $ **FLOATING
C620 m2_21776_107568# a_64549_20015# 0 $ **FLOATING
C621 m2_21620_107552# a_64549_20015# 0 $ **FLOATING
C622 m2_21464_107536# a_64549_20015# 0 $ **FLOATING
C623 m2_21340_107480# a_64549_20015# 0 $ **FLOATING
C624 m2_22440_107860# a_64549_20015# 0 $ **FLOATING
C625 m2_22244_107772# a_64549_20015# 0 $ **FLOATING
C626 m2_22088_107756# a_64549_20015# 0 $ **FLOATING
C627 m2_21932_107740# a_64549_20015# 0 $ **FLOATING
C628 m2_21776_107724# a_64549_20015# 0 $ **FLOATING
C629 m2_21620_107708# a_64549_20015# 0 $ **FLOATING
C630 m2_21464_107692# a_64549_20015# 0 $ **FLOATING
C631 m2_21308_107676# a_64549_20015# 0 $ **FLOATING
C632 m2_21152_107660# a_64549_20015# 0 $ **FLOATING
C633 m2_21040_107640# a_64549_20015# 0 $ **FLOATING
C634 m2_20940_107660# a_64549_20015# 0 $ **FLOATING
C635 m2_20640_107620# a_64549_20015# 0 $ **FLOATING
C636 m2_20840_107680# a_64549_20015# 0 $ **FLOATING
C637 m2_20540_107640# a_64549_20015# 0 $ **FLOATING
C638 m2_21040_107740# a_64549_20015# 0 $ **FLOATING
C639 m2_20940_107760# a_64549_20015# 0 $ **FLOATING
C640 m2_21440_107860# a_64549_20015# 0 $ **FLOATING
C641 m2_21140_107820# a_64549_20015# 0 $ **FLOATING
C642 m2_20840_107780# a_64549_20015# 0 $ **FLOATING
C643 m2_21040_107840# a_64549_20015# 0 $ **FLOATING
C644 m2_20940_107860# a_64549_20015# 0 $ **FLOATING
C645 m2_20684_107768# a_64549_20015# 0 $ **FLOATING
C646 m2_20528_107752# a_64549_20015# 0 $ **FLOATING
C647 m2_20372_107736# a_64549_20015# 0 $ **FLOATING
C648 m2_20216_107720# a_64549_20015# 0 $ **FLOATING
C649 m2_20060_107704# a_64549_20015# 0 $ **FLOATING
C650 m2_20000_107688# a_64549_20015# 0 $ **FLOATING
C651 m2_20000_107998# a_64549_20015# 1.9860200000000002e-16
C652 m2_20000_108190# a_64549_20015# 3.5008700000000003e-16
C653 m2_22340_108280# a_64549_20015# 0 $ **FLOATING
C654 m2_22400_108412# a_64549_20015# 0 $ **FLOATING
C655 m2_22244_108396# a_64549_20015# 0 $ **FLOATING
C656 m2_22088_108380# a_64549_20015# 0 $ **FLOATING
C657 m2_21932_108364# a_64549_20015# 0 $ **FLOATING
C658 m2_21776_108348# a_64549_20015# 0 $ **FLOATING
C659 m2_21620_108332# a_64549_20015# 0 $ **FLOATING
C660 m2_21340_108280# a_64549_20015# 0 $ **FLOATING
C661 m2_21240_108300# a_64549_20015# 0 $ **FLOATING
C662 m2_21140_108320# a_64549_20015# 0 $ **FLOATING
C663 m2_20840_108280# a_64549_20015# 0 $ **FLOATING
C664 m2_22400_108568# a_64549_20015# 0 $ **FLOATING
C665 m2_22244_108552# a_64549_20015# 0 $ **FLOATING
C666 m2_22088_108536# a_64549_20015# 0 $ **FLOATING
C667 m2_21932_108520# a_64549_20015# 0 $ **FLOATING
C668 m2_21776_108504# a_64549_20015# 0 $ **FLOATING
C669 m2_21620_108488# a_64549_20015# 0 $ **FLOATING
C670 m2_21464_108472# a_64549_20015# 0 $ **FLOATING
C671 m2_21308_108456# a_64549_20015# 0 $ **FLOATING
C672 m2_21152_108440# a_64549_20015# 0 $ **FLOATING
C673 m2_20996_108424# a_64549_20015# 0 $ **FLOATING
C674 m2_20840_108408# a_64549_20015# 0 $ **FLOATING
C675 m2_20684_108392# a_64549_20015# 0 $ **FLOATING
C676 m2_20528_108376# a_64549_20015# 0 $ **FLOATING
C677 m2_20372_108360# a_64549_20015# 0 $ **FLOATING
C678 m2_20216_108344# a_64549_20015# 0 $ **FLOATING
C679 m2_20060_108328# a_64549_20015# 0 $ **FLOATING
C680 m2_22400_108724# a_64549_20015# 0 $ **FLOATING
C681 m2_22244_108708# a_64549_20015# 0 $ **FLOATING
C682 m2_22088_108692# a_64549_20015# 0 $ **FLOATING
C683 m2_21932_108676# a_64549_20015# 0 $ **FLOATING
C684 m2_21776_108660# a_64549_20015# 0 $ **FLOATING
C685 m2_21620_108644# a_64549_20015# 0 $ **FLOATING
C686 m2_21464_108628# a_64549_20015# 0 $ **FLOATING
C687 m2_21308_108612# a_64549_20015# 0 $ **FLOATING
C688 m2_21152_108596# a_64549_20015# 0 $ **FLOATING
C689 m2_20996_108580# a_64549_20015# 0 $ **FLOATING
C690 m2_20840_108564# a_64549_20015# 0 $ **FLOATING
C691 m2_20684_108548# a_64549_20015# 0 $ **FLOATING
C692 m2_20528_108532# a_64549_20015# 0 $ **FLOATING
C693 m2_20372_108516# a_64549_20015# 0 $ **FLOATING
C694 m2_22400_108880# a_64549_20015# 0 $ **FLOATING
C695 m2_22244_108864# a_64549_20015# 0 $ **FLOATING
C696 m2_22088_108848# a_64549_20015# 0 $ **FLOATING
C697 m2_21932_108832# a_64549_20015# 0 $ **FLOATING
C698 m2_21776_108816# a_64549_20015# 0 $ **FLOATING
C699 m2_21620_108800# a_64549_20015# 0 $ **FLOATING
C700 m2_21464_108784# a_64549_20015# 0 $ **FLOATING
C701 m2_21308_108768# a_64549_20015# 0 $ **FLOATING
C702 m2_21152_108752# a_64549_20015# 0 $ **FLOATING
C703 m2_20996_108736# a_64549_20015# 0 $ **FLOATING
C704 m2_20840_108720# a_64549_20015# 0 $ **FLOATING
C705 m2_20684_108704# a_64549_20015# 0 $ **FLOATING
C706 m2_20528_108688# a_64549_20015# 0 $ **FLOATING
C707 m2_20372_108672# a_64549_20015# 0 $ **FLOATING
C708 m2_20240_108700# a_64549_20015# 0 $ **FLOATING
C709 m2_22400_109036# a_64549_20015# 0 $ **FLOATING
C710 m2_22244_109020# a_64549_20015# 0 $ **FLOATING
C711 m2_22088_109004# a_64549_20015# 0 $ **FLOATING
C712 m2_21932_108988# a_64549_20015# 0 $ **FLOATING
C713 m2_21464_108940# a_64549_20015# 0 $ **FLOATING
C714 m2_21308_108924# a_64549_20015# 0 $ **FLOATING
C715 m2_21152_108908# a_64549_20015# 0 $ **FLOATING
C716 m2_20996_108892# a_64549_20015# 0 $ **FLOATING
C717 m2_20840_108876# a_64549_20015# 0 $ **FLOATING
C718 m2_20684_108860# a_64549_20015# 0 $ **FLOATING
C719 m2_20528_108844# a_64549_20015# 0 $ **FLOATING
C720 m2_20372_108828# a_64549_20015# 0 $ **FLOATING
C721 m2_20216_108812# a_64549_20015# 0 $ **FLOATING
C722 m2_20060_108796# a_64549_20015# 0 $ **FLOATING
C723 m2_20000_108780# a_64549_20015# 0 $ **FLOATING
C724 m2_22400_109192# a_64549_20015# 0 $ **FLOATING
C725 m2_22244_109176# a_64549_20015# 0 $ **FLOATING
C726 m2_22088_109160# a_64549_20015# 0 $ **FLOATING
C727 m2_21932_109144# a_64549_20015# 0 $ **FLOATING
C728 m2_21464_109096# a_64549_20015# 0 $ **FLOATING
C729 m2_21308_109080# a_64549_20015# 0 $ **FLOATING
C730 m2_21152_109064# a_64549_20015# 0 $ **FLOATING
C731 m2_20996_109048# a_64549_20015# 0 $ **FLOATING
C732 m2_20840_109032# a_64549_20015# 0 $ **FLOATING
C733 m2_20684_109016# a_64549_20015# 0 $ **FLOATING
C734 m2_20528_109000# a_64549_20015# 0 $ **FLOATING
C735 m2_20060_108952# a_64549_20015# 0 $ **FLOATING
C736 m2_20000_108936# a_64549_20015# 0 $ **FLOATING
C737 m2_22400_109348# a_64549_20015# 0 $ **FLOATING
C738 m2_22244_109332# a_64549_20015# 0 $ **FLOATING
C739 m2_22088_109316# a_64549_20015# 0 $ **FLOATING
C740 m2_21932_109300# a_64549_20015# 0 $ **FLOATING
C741 m2_21464_109252# a_64549_20015# 0 $ **FLOATING
C742 m2_21308_109236# a_64549_20015# 0 $ **FLOATING
C743 m2_21152_109220# a_64549_20015# 0 $ **FLOATING
C744 m2_20996_109204# a_64549_20015# 0 $ **FLOATING
C745 m2_20840_109188# a_64549_20015# 0 $ **FLOATING
C746 m2_20684_109172# a_64549_20015# 0 $ **FLOATING
C747 m2_20528_109156# a_64549_20015# 0 $ **FLOATING
C748 m2_20060_109108# a_64549_20015# 0 $ **FLOATING
C749 m2_20000_109092# a_64549_20015# 0 $ **FLOATING
C750 m2_22400_109504# a_64549_20015# 0 $ **FLOATING
C751 m2_22244_109488# a_64549_20015# 0 $ **FLOATING
C752 m2_22088_109472# a_64549_20015# 0 $ **FLOATING
C753 m2_21932_109456# a_64549_20015# 0 $ **FLOATING
C754 m2_21464_109408# a_64549_20015# 0 $ **FLOATING
C755 m2_21308_109392# a_64549_20015# 0 $ **FLOATING
C756 m2_21152_109376# a_64549_20015# 0 $ **FLOATING
C757 m2_20996_109360# a_64549_20015# 0 $ **FLOATING
C758 m2_20840_109344# a_64549_20015# 0 $ **FLOATING
C759 m2_20684_109328# a_64549_20015# 0 $ **FLOATING
C760 m2_20528_109312# a_64549_20015# 0 $ **FLOATING
C761 m2_20060_109264# a_64549_20015# 0 $ **FLOATING
C762 m2_20000_109248# a_64549_20015# 0 $ **FLOATING
C763 m2_22400_109660# a_64549_20015# 0 $ **FLOATING
C764 m2_22244_109644# a_64549_20015# 0 $ **FLOATING
C765 m2_22088_109628# a_64549_20015# 0 $ **FLOATING
C766 m2_21932_109612# a_64549_20015# 0 $ **FLOATING
C767 m2_21776_109596# a_64549_20015# 0 $ **FLOATING
C768 m2_21620_109580# a_64549_20015# 0 $ **FLOATING
C769 m2_21464_109564# a_64549_20015# 0 $ **FLOATING
C770 m2_21308_109548# a_64549_20015# 0 $ **FLOATING
C771 m2_21152_109532# a_64549_20015# 0 $ **FLOATING
C772 m2_20996_109516# a_64549_20015# 0 $ **FLOATING
C773 m2_20840_109500# a_64549_20015# 0 $ **FLOATING
C774 m2_20684_109484# a_64549_20015# 0 $ **FLOATING
C775 m2_20528_109468# a_64549_20015# 0 $ **FLOATING
C776 m2_20060_109420# a_64549_20015# 0 $ **FLOATING
C777 m2_20000_109404# a_64549_20015# 0 $ **FLOATING
C778 m2_20996_109672# a_64549_20015# 0 $ **FLOATING
C779 m2_20840_109656# a_64549_20015# 0 $ **FLOATING
C780 m2_20684_109640# a_64549_20015# 0 $ **FLOATING
C781 m2_20528_109624# a_64549_20015# 0 $ **FLOATING
C782 m2_20372_109608# a_64549_20015# 0 $ **FLOATING
C783 m2_20216_109592# a_64549_20015# 0 $ **FLOATING
C784 m2_20060_109576# a_64549_20015# 0 $ **FLOATING
C785 m2_20000_109560# a_64549_20015# 0 $ **FLOATING
C786 m1_67310_20000# a_64549_20015# 0 $ **FLOATING
C787 m1_67060_20000# a_64549_20015# 0 $ **FLOATING
C788 m1_67430_20170# a_64549_20015# 0 $ **FLOATING
C789 m1_67330_20190# a_64549_20015# 0 $ **FLOATING
C790 m1_67060_20060# a_64549_20015# 0 $ **FLOATING
C791 m1_66820_20000# a_64549_20015# 0 $ **FLOATING
C792 m1_66634_20000# a_64549_20015# 0 $ **FLOATING
C793 m1_66634_20050# a_64549_20015# 0 $ **FLOATING
C794 m1_66478_20034# a_64549_20015# 0 $ **FLOATING
C795 m1_66322_20018# a_64549_20015# 0 $ **FLOATING
C796 m1_65854_20000# a_64549_20015# 0 $ **FLOATING
C797 m1_65730_20010# a_64549_20015# 0 $ **FLOATING
C798 m1_65430_20000# a_64549_20015# 0 $ **FLOATING
C799 m1_65230_20000# a_64549_20015# 0 $ **FLOATING
C800 m1_67310_20290# a_64549_20015# 0 $ **FLOATING
C801 m1_67060_20300# a_64549_20015# 0 $ **FLOATING
C802 m1_66820_20200# a_64549_20015# 0 $ **FLOATING
C803 m1_66634_20206# a_64549_20015# 0 $ **FLOATING
C804 m1_66478_20190# a_64549_20015# 0 $ **FLOATING
C805 m1_66322_20174# a_64549_20015# 0 $ **FLOATING
C806 m1_65854_20126# a_64549_20015# 0 $ **FLOATING
C807 m1_65730_20110# a_64549_20015# 0 $ **FLOATING
C808 m1_65430_20070# a_64549_20015# 0 $ **FLOATING
C809 m1_65730_20210# a_64549_20015# 0 $ **FLOATING
C810 m1_65430_20170# a_64549_20015# 0 $ **FLOATING
C811 m1_65230_20062# a_64549_20015# 0 $ **FLOATING
C812 m1_64762_20014# a_64549_20015# 0 $ **FLOATING
C813 m1_67060_20540# a_64549_20015# 0 $ **FLOATING
C814 m1_66820_20440# a_64549_20015# 0 $ **FLOATING
C815 m1_66634_20362# a_64549_20015# 0 $ **FLOATING
C816 m1_66478_20346# a_64549_20015# 0 $ **FLOATING
C817 m1_66322_20330# a_64549_20015# 0 $ **FLOATING
C818 m1_65854_20282# a_64549_20015# 0 $ **FLOATING
C819 m1_65730_20310# a_64549_20015# 0 $ **FLOATING
C820 m1_65430_20270# a_64549_20015# 0 $ **FLOATING
C821 m1_65230_20218# a_64549_20015# 0 $ **FLOATING
C822 m1_64762_20170# a_64549_20015# 0 $ **FLOATING
C823 m1_66634_20518# a_64549_20015# 0 $ **FLOATING
C824 m1_66478_20502# a_64549_20015# 0 $ **FLOATING
C825 m1_66322_20486# a_64549_20015# 0 $ **FLOATING
C826 m1_65854_20438# a_64549_20015# 0 $ **FLOATING
C827 m1_65730_20410# a_64549_20015# 0 $ **FLOATING
C828 m1_65430_20370# a_64549_20015# 0 $ **FLOATING
C829 m1_65730_20510# a_64549_20015# 0 $ **FLOATING
C830 m1_65430_20470# a_64549_20015# 0 $ **FLOATING
C831 m1_65230_20374# a_64549_20015# 0 $ **FLOATING
C832 m1_64762_20326# a_64549_20015# 0 $ **FLOATING
C833 m1_67530_20750# a_64549_20015# 0 $ **FLOATING
C834 m1_67310_20850# a_64549_20015# 0 $ **FLOATING
C835 m1_67060_20780# a_64549_20015# 0 $ **FLOATING
C836 m1_66820_20680# a_64549_20015# 0 $ **FLOATING
C837 m1_66634_20674# a_64549_20015# 0 $ **FLOATING
C838 m1_66478_20658# a_64549_20015# 0 $ **FLOATING
C839 m1_66322_20642# a_64549_20015# 0 $ **FLOATING
C840 m1_65854_20594# a_64549_20015# 0 $ **FLOATING
C841 m1_65730_20610# a_64549_20015# 0 $ **FLOATING
C842 m1_65430_20570# a_64549_20015# 0 $ **FLOATING
C843 m1_65230_20530# a_64549_20015# 0 $ **FLOATING
C844 m1_64762_20482# a_64549_20015# 0 $ **FLOATING
C845 m1_67060_21020# a_64549_20015# 0 $ **FLOATING
C846 m1_66820_20920# a_64549_20015# 0 $ **FLOATING
C847 m1_66634_20830# a_64549_20015# 0 $ **FLOATING
C848 m1_66478_20814# a_64549_20015# 0 $ **FLOATING
C849 m1_66322_20798# a_64549_20015# 0 $ **FLOATING
C850 m1_65854_20750# a_64549_20015# 0 $ **FLOATING
C851 m1_65730_20710# a_64549_20015# 0 $ **FLOATING
C852 m1_65430_20670# a_64549_20015# 0 $ **FLOATING
C853 m1_65730_20810# a_64549_20015# 0 $ **FLOATING
C854 m1_65430_20770# a_64549_20015# 0 $ **FLOATING
C855 m1_65230_20686# a_64549_20015# 0 $ **FLOATING
C856 m1_64762_20638# a_64549_20015# 0 $ **FLOATING
C857 m1_66634_20986# a_64549_20015# 0 $ **FLOATING
C858 m1_66478_20970# a_64549_20015# 0 $ **FLOATING
C859 m1_66322_20954# a_64549_20015# 0 $ **FLOATING
C860 m1_65854_20906# a_64549_20015# 0 $ **FLOATING
C861 m1_65730_20910# a_64549_20015# 0 $ **FLOATING
C862 m1_65430_20870# a_64549_20015# 0 $ **FLOATING
C863 m1_65230_20842# a_64549_20015# 0 $ **FLOATING
C864 m1_64762_20794# a_64549_20015# 0 $ **FLOATING
C865 m1_67330_21290# a_64549_20015# 0 $ **FLOATING
C866 m1_67310_21410# a_64549_20015# 0 $ **FLOATING
C867 m1_67060_21260# a_64549_20015# 0 $ **FLOATING
C868 m1_66820_21160# a_64549_20015# 0 $ **FLOATING
C869 m1_66634_21142# a_64549_20015# 0 $ **FLOATING
C870 m1_66478_21126# a_64549_20015# 0 $ **FLOATING
C871 m1_66322_21110# a_64549_20015# 0 $ **FLOATING
C872 m1_65854_21062# a_64549_20015# 0 $ **FLOATING
C873 m1_65730_21010# a_64549_20015# 0 $ **FLOATING
C874 m1_65430_20970# a_64549_20015# 0 $ **FLOATING
C875 m1_65730_21110# a_64549_20015# 0 $ **FLOATING
C876 m1_65430_21070# a_64549_20015# 0 $ **FLOATING
C877 m1_65230_20998# a_64549_20015# 0 $ **FLOATING
C878 m1_64762_20950# a_64549_20015# 0 $ **FLOATING
C879 m1_67060_21500# a_64549_20015# 0 $ **FLOATING
C880 m1_66820_21400# a_64549_20015# 0 $ **FLOATING
C881 m1_66634_21298# a_64549_20015# 0 $ **FLOATING
C882 m1_66478_21282# a_64549_20015# 0 $ **FLOATING
C883 m1_66322_21266# a_64549_20015# 0 $ **FLOATING
C884 m1_65854_21218# a_64549_20015# 0 $ **FLOATING
C885 m1_65730_21210# a_64549_20015# 0 $ **FLOATING
C886 m1_65430_21170# a_64549_20015# 0 $ **FLOATING
C887 m1_65230_21154# a_64549_20015# 0 $ **FLOATING
C888 m1_64762_21106# a_64549_20015# 0 $ **FLOATING
C889 m1_65730_21310# a_64549_20015# 0 $ **FLOATING
C890 m1_65430_21270# a_64549_20015# 0 $ **FLOATING
C891 m1_66634_21454# a_64549_20015# 0 $ **FLOATING
C892 m1_66478_21438# a_64549_20015# 0 $ **FLOATING
C893 m1_66322_21422# a_64549_20015# 0 $ **FLOATING
C894 m1_65854_21374# a_64549_20015# 0 $ **FLOATING
C895 m1_65730_21410# a_64549_20015# 0 $ **FLOATING
C896 m1_65430_21370# a_64549_20015# 0 $ **FLOATING
C897 m1_65230_21310# a_64549_20015# 0 $ **FLOATING
C898 m1_64762_21262# a_64549_20015# 0 $ **FLOATING
C899 m1_67530_21850# a_64549_20015# 0 $ **FLOATING
C900 m1_67430_21870# a_64549_20015# 0 $ **FLOATING
C901 m1_67060_21740# a_64549_20015# 0 $ **FLOATING
C902 m1_66820_21640# a_64549_20015# 0 $ **FLOATING
C903 m1_66634_21610# a_64549_20015# 0 $ **FLOATING
C904 m1_66478_21594# a_64549_20015# 0 $ **FLOATING
C905 m1_66322_21578# a_64549_20015# 0 $ **FLOATING
C906 m1_65854_21530# a_64549_20015# 0 $ **FLOATING
C907 m1_65730_21510# a_64549_20015# 0 $ **FLOATING
C908 m1_65430_21470# a_64549_20015# 0 $ **FLOATING
C909 m1_65730_21610# a_64549_20015# 0 $ **FLOATING
C910 m1_65430_21570# a_64549_20015# 0 $ **FLOATING
C911 m1_65230_21466# a_64549_20015# 0 $ **FLOATING
C912 m1_64762_21418# a_64549_20015# 0 $ **FLOATING
C913 m1_67310_21970# a_64549_20015# 0 $ **FLOATING
C914 m1_67060_21980# a_64549_20015# 0 $ **FLOATING
C915 m1_66820_21880# a_64549_20015# 0 $ **FLOATING
C916 m1_66634_21766# a_64549_20015# 0 $ **FLOATING
C917 m1_66478_21750# a_64549_20015# 0 $ **FLOATING
C918 m1_66322_21734# a_64549_20015# 0 $ **FLOATING
C919 m1_65854_21686# a_64549_20015# 0 $ **FLOATING
C920 m1_65730_21710# a_64549_20015# 0 $ **FLOATING
C921 m1_65430_21670# a_64549_20015# 0 $ **FLOATING
C922 m1_65230_21622# a_64549_20015# 0 $ **FLOATING
C923 m1_64762_21574# a_64549_20015# 0 $ **FLOATING
C924 m1_66634_21922# a_64549_20015# 0 $ **FLOATING
C925 m1_66478_21906# a_64549_20015# 0 $ **FLOATING
C926 m1_66322_21890# a_64549_20015# 0 $ **FLOATING
C927 m1_65854_21842# a_64549_20015# 0 $ **FLOATING
C928 m1_65730_21810# a_64549_20015# 0 $ **FLOATING
C929 m1_65430_21770# a_64549_20015# 0 $ **FLOATING
C930 m1_65730_21910# a_64549_20015# 0 $ **FLOATING
C931 m1_65430_21870# a_64549_20015# 0 $ **FLOATING
C932 m1_65230_21778# a_64549_20015# 0 $ **FLOATING
C933 m1_64762_21730# a_64549_20015# 0 $ **FLOATING
C934 m1_67060_22220# a_64549_20015# 0 $ **FLOATING
C935 m1_66820_22120# a_64549_20015# 0 $ **FLOATING
C936 m1_66634_22078# a_64549_20015# 0 $ **FLOATING
C937 m1_66478_22062# a_64549_20015# 0 $ **FLOATING
C938 m1_66322_22046# a_64549_20015# 0 $ **FLOATING
C939 m1_65854_21998# a_64549_20015# 0 $ **FLOATING
C940 m1_65730_22010# a_64549_20015# 0 $ **FLOATING
C941 m1_65430_21970# a_64549_20015# 0 $ **FLOATING
C942 m1_65230_21934# a_64549_20015# 0 $ **FLOATING
C943 m1_64762_21886# a_64549_20015# 0 $ **FLOATING
C944 m1_66634_22234# a_64549_20015# 0 $ **FLOATING
C945 m1_66478_22218# a_64549_20015# 0 $ **FLOATING
C946 m1_66322_22202# a_64549_20015# 0 $ **FLOATING
C947 m1_65854_22154# a_64549_20015# 0 $ **FLOATING
C948 m1_65730_22110# a_64549_20015# 0 $ **FLOATING
C949 m1_65430_22070# a_64549_20015# 0 $ **FLOATING
C950 m1_65730_22210# a_64549_20015# 0 $ **FLOATING
C951 m1_65430_22170# a_64549_20015# 0 $ **FLOATING
C952 m1_65230_22090# a_64549_20015# 0 $ **FLOATING
C953 m1_64762_22042# a_64549_20015# 0 $ **FLOATING
C954 m1_67310_22530# a_64549_20015# 0 $ **FLOATING
C955 m1_67060_22460# a_64549_20015# 0 $ **FLOATING
C956 m1_66820_22360# a_64549_20015# 0 $ **FLOATING
C957 m1_66634_22390# a_64549_20015# 0 $ **FLOATING
C958 m1_66478_22374# a_64549_20015# 0 $ **FLOATING
C959 m1_66322_22358# a_64549_20015# 0 $ **FLOATING
C960 m1_65854_22310# a_64549_20015# 0 $ **FLOATING
C961 m1_65730_22310# a_64549_20015# 0 $ **FLOATING
C962 m1_65430_22270# a_64549_20015# 0 $ **FLOATING
C963 m1_65230_22246# a_64549_20015# 0 $ **FLOATING
C964 m1_64762_22198# a_64549_20015# 0 $ **FLOATING
C965 m1_67060_22700# a_64549_20015# 0 $ **FLOATING
C966 m1_66820_22600# a_64549_20015# 0 $ **FLOATING
C967 m1_66634_22546# a_64549_20015# 0 $ **FLOATING
C968 m1_66478_22530# a_64549_20015# 0 $ **FLOATING
C969 m1_66322_22514# a_64549_20015# 0 $ **FLOATING
C970 m1_65854_22466# a_64549_20015# 0 $ **FLOATING
C971 m1_65730_22410# a_64549_20015# 0 $ **FLOATING
C972 m1_65430_22370# a_64549_20015# 0 $ **FLOATING
C973 m1_65730_22510# a_64549_20015# 0 $ **FLOATING
C974 m1_65430_22470# a_64549_20015# 0 $ **FLOATING
C975 m1_65230_22402# a_64549_20015# 0 $ **FLOATING
C976 m1_64762_22354# a_64549_20015# 0 $ **FLOATING
C977 m1_66634_22702# a_64549_20015# 0 $ **FLOATING
C978 m1_66478_22686# a_64549_20015# 0 $ **FLOATING
C979 m1_66322_22670# a_64549_20015# 0 $ **FLOATING
C980 m1_65854_22622# a_64549_20015# 0 $ **FLOATING
C981 m1_65730_22610# a_64549_20015# 0 $ **FLOATING
C982 m1_65430_22570# a_64549_20015# 0 $ **FLOATING
C983 m1_65730_22710# a_64549_20015# 0 $ **FLOATING
C984 m1_65430_22670# a_64549_20015# 0 $ **FLOATING
C985 m1_65230_22558# a_64549_20015# 0 $ **FLOATING
C986 m1_64762_22510# a_64549_20015# 0 $ **FLOATING
C987 m1_67430_22970# a_64549_20015# 0 $ **FLOATING
C988 m1_67330_22990# a_64549_20015# 0 $ **FLOATING
C989 m1_67310_23090# a_64549_20015# 0 $ **FLOATING
C990 m1_67060_22940# a_64549_20015# 0 $ **FLOATING
C991 m1_66820_22840# a_64549_20015# 0 $ **FLOATING
C992 m1_66634_22858# a_64549_20015# 0 $ **FLOATING
C993 m1_66478_22842# a_64549_20015# 0 $ **FLOATING
C994 m1_66322_22826# a_64549_20015# 0 $ **FLOATING
C995 m1_65854_22778# a_64549_20015# 0 $ **FLOATING
C996 m1_65730_22810# a_64549_20015# 0 $ **FLOATING
C997 m1_65430_22770# a_64549_20015# 0 $ **FLOATING
C998 m1_65230_22714# a_64549_20015# 0 $ **FLOATING
C999 m1_64762_22666# a_64549_20015# 0 $ **FLOATING
C1000 m1_67060_23180# a_64549_20015# 0 $ **FLOATING
C1001 m1_66820_23080# a_64549_20015# 0 $ **FLOATING
C1002 m1_66634_23014# a_64549_20015# 0 $ **FLOATING
C1003 m1_66478_22998# a_64549_20015# 0 $ **FLOATING
C1004 m1_66322_22982# a_64549_20015# 0 $ **FLOATING
C1005 m1_65854_22934# a_64549_20015# 0 $ **FLOATING
C1006 m1_65730_22910# a_64549_20015# 0 $ **FLOATING
C1007 m1_65430_22870# a_64549_20015# 0 $ **FLOATING
C1008 m1_65730_23010# a_64549_20015# 0 $ **FLOATING
C1009 m1_65430_22970# a_64549_20015# 0 $ **FLOATING
C1010 m1_65230_22870# a_64549_20015# 0 $ **FLOATING
C1011 m1_64762_22822# a_64549_20015# 0 $ **FLOATING
C1012 m1_66634_23170# a_64549_20015# 0 $ **FLOATING
C1013 m1_66478_23154# a_64549_20015# 0 $ **FLOATING
C1014 m1_66322_23138# a_64549_20015# 0 $ **FLOATING
C1015 m1_65854_23090# a_64549_20015# 0 $ **FLOATING
C1016 m1_65730_23110# a_64549_20015# 0 $ **FLOATING
C1017 m1_65430_23070# a_64549_20015# 0 $ **FLOATING
C1018 m1_65230_23026# a_64549_20015# 0 $ **FLOATING
C1019 m1_64762_22978# a_64549_20015# 0 $ **FLOATING
C1020 m1_66322_23294# a_64549_20015# 0 $ **FLOATING
C1021 m1_65854_23246# a_64549_20015# 0 $ **FLOATING
C1022 m1_65730_23210# a_64549_20015# 0 $ **FLOATING
C1023 m1_65430_23170# a_64549_20015# 0 $ **FLOATING
C1024 m1_65430_23270# a_64549_20015# 0 $ **FLOATING
C1025 m1_65230_23182# a_64549_20015# 0 $ **FLOATING
C1026 m1_64762_23134# a_64549_20015# 0 $ **FLOATING
C1027 m1_64762_23290# a_64549_20015# 0 $ **FLOATING
C1028 m1_22018_107202# a_64549_20015# 0 $ **FLOATING
C1029 m1_21830_107200# a_64549_20015# 0 $ **FLOATING
C1030 m1_21394_107200# a_64549_20015# 0 $ **FLOATING
C1031 m1_21830_107290# a_64549_20015# 0 $ **FLOATING
C1032 m1_22018_107358# a_64549_20015# 0 $ **FLOATING
C1033 m1_21830_107390# a_64549_20015# 0 $ **FLOATING
C1034 m1_21394_107294# a_64549_20015# 0 $ **FLOATING
C1035 m1_22018_107514# a_64549_20015# 0 $ **FLOATING
C1036 m1_21830_107490# a_64549_20015# 0 $ **FLOATING
C1037 m1_21830_107590# a_64549_20015# 0 $ **FLOATING
C1038 m1_21394_107450# a_64549_20015# 0 $ **FLOATING
C1039 m1_20770_107230# a_64549_20015# 0 $ **FLOATING
C1040 m1_20614_107214# a_64549_20015# 0 $ **FLOATING
C1041 m1_21172_107500# a_64549_20015# 1.31212e-16
C1042 m1_20770_107386# a_64549_20015# 0 $ **FLOATING
C1043 m1_20614_107370# a_64549_20015# 0 $ **FLOATING
C1044 m1_22018_107670# a_64549_20015# 0 $ **FLOATING
C1045 m1_21830_107690# a_64549_20015# 0 $ **FLOATING
C1046 m1_21394_107606# a_64549_20015# 0 $ **FLOATING
C1047 m1_20770_107542# a_64549_20015# 0 $ **FLOATING
C1048 m1_20614_107526# a_64549_20015# 0 $ **FLOATING
C1049 m1_22018_107826# a_64549_20015# 0 $ **FLOATING
C1050 m1_21830_107790# a_64549_20015# 0 $ **FLOATING
C1051 m1_21394_107762# a_64549_20015# 0 $ **FLOATING
C1052 m1_21238_107746# a_64549_20015# 0 $ **FLOATING
C1053 m1_20770_107698# a_64549_20015# 0 $ **FLOATING
C1054 m1_20614_107682# a_64549_20015# 0 $ **FLOATING
C1055 m1_21830_107890# a_64549_20015# 0 $ **FLOATING
C1056 m1_22018_107982# a_64549_20015# 0 $ **FLOATING
C1057 m1_21830_107990# a_64549_20015# 0 $ **FLOATING
C1058 m1_21394_107918# a_64549_20015# 0 $ **FLOATING
C1059 m1_21238_107902# a_64549_20015# 0 $ **FLOATING
C1060 m1_20770_107854# a_64549_20015# 0 $ **FLOATING
C1061 m1_20614_107838# a_64549_20015# 0 $ **FLOATING
C1062 m1_22018_108138# a_64549_20015# 0 $ **FLOATING
C1063 m1_21830_108090# a_64549_20015# 0 $ **FLOATING
C1064 m1_21830_108190# a_64549_20015# 0 $ **FLOATING
C1065 m1_21394_108074# a_64549_20015# 0 $ **FLOATING
C1066 m1_21238_108058# a_64549_20015# 0 $ **FLOATING
C1067 m1_20770_108010# a_64549_20015# 0 $ **FLOATING
C1068 m1_20614_107994# a_64549_20015# 0 $ **FLOATING
C1069 m1_22018_108294# a_64549_20015# 0 $ **FLOATING
C1070 m1_21830_108290# a_64549_20015# 0 $ **FLOATING
C1071 m1_21394_108230# a_64549_20015# 0 $ **FLOATING
C1072 m1_21238_108214# a_64549_20015# 0 $ **FLOATING
C1073 m1_20770_108166# a_64549_20015# 0 $ **FLOATING
C1074 m1_20614_108150# a_64549_20015# 0 $ **FLOATING
C1075 m1_21830_108390# a_64549_20015# 0 $ **FLOATING
C1076 m1_22018_108450# a_64549_20015# 0 $ **FLOATING
C1077 m1_21830_108490# a_64549_20015# 0 $ **FLOATING
C1078 m1_21394_108386# a_64549_20015# 0 $ **FLOATING
C1079 m1_21238_108370# a_64549_20015# 0 $ **FLOATING
C1080 m1_20770_108322# a_64549_20015# 0 $ **FLOATING
C1081 m1_20614_108306# a_64549_20015# 0 $ **FLOATING
C1082 m1_22018_108606# a_64549_20015# 0 $ **FLOATING
C1083 m1_21830_108590# a_64549_20015# 0 $ **FLOATING
C1084 m1_21394_108542# a_64549_20015# 0 $ **FLOATING
C1085 m1_21238_108526# a_64549_20015# 0 $ **FLOATING
C1086 m1_20770_108478# a_64549_20015# 0 $ **FLOATING
C1087 m1_20614_108462# a_64549_20015# 0 $ **FLOATING
C1088 m1_21830_108690# a_64549_20015# 0 $ **FLOATING
C1089 m1_22018_108762# a_64549_20015# 0 $ **FLOATING
C1090 m1_21830_108790# a_64549_20015# 0 $ **FLOATING
C1091 m1_22018_108918# a_64549_20015# 0 $ **FLOATING
C1092 m1_21830_108890# a_64549_20015# 0 $ **FLOATING
C1093 m1_21830_108990# a_64549_20015# 0 $ **FLOATING
C1094 m1_22018_109074# a_64549_20015# 0 $ **FLOATING
C1095 m1_21830_109090# a_64549_20015# 0 $ **FLOATING
C1096 m1_21394_108698# a_64549_20015# 0 $ **FLOATING
C1097 m1_21238_108682# a_64549_20015# 0 $ **FLOATING
C1098 m1_21394_108854# a_64549_20015# 0 $ **FLOATING
C1099 m1_21238_108838# a_64549_20015# 0 $ **FLOATING
C1100 m1_21394_109010# a_64549_20015# 0 $ **FLOATING
C1101 m1_21238_108994# a_64549_20015# 0 $ **FLOATING
C1102 m1_22018_109230# a_64549_20015# 0 $ **FLOATING
C1103 m1_21830_109190# a_64549_20015# 0 $ **FLOATING
C1104 m1_21394_109166# a_64549_20015# 0 $ **FLOATING
C1105 m1_21238_109150# a_64549_20015# 0 $ **FLOATING
C1106 m1_21830_109290# a_64549_20015# 0 $ **FLOATING
C1107 m1_22018_109386# a_64549_20015# 0 $ **FLOATING
C1108 m1_21830_109390# a_64549_20015# 0 $ **FLOATING
C1109 m1_21394_109322# a_64549_20015# 0 $ **FLOATING
C1110 m1_21238_109306# a_64549_20015# 0 $ **FLOATING
C1111 m1_22018_109542# a_64549_20015# 0 $ **FLOATING
C1112 m1_21830_109490# a_64549_20015# 0 $ **FLOATING
C1113 m1_21394_109478# a_64549_20015# 0 $ **FLOATING
C1114 m1_21238_109462# a_64549_20015# 0 $ **FLOATING
C1115 m1_22018_109698# a_64549_20015# 0 $ **FLOATING
C1116 m1_21862_109682# a_64549_20015# 0 $ **FLOATING
C1117 m1_21706_109666# a_64549_20015# 0 $ **FLOATING
C1118 m1_21550_109650# a_64549_20015# 0 $ **FLOATING
C1119 m1_21394_109634# a_64549_20015# 0 $ **FLOATING
C1120 m1_21238_109618# a_64549_20015# 0 $ **FLOATING
C1121 m1_20770_108634# a_64549_20015# 0 $ **FLOATING
C1122 m1_20614_108618# a_64549_20015# 0 $ **FLOATING
C1123 m1_20770_108790# a_64549_20015# 0 $ **FLOATING
C1124 m1_20614_108774# a_64549_20015# 0 $ **FLOATING
C1125 m1_20770_108946# a_64549_20015# 0 $ **FLOATING
C1126 m1_20614_108930# a_64549_20015# 0 $ **FLOATING
C1127 m1_20770_109102# a_64549_20015# 0 $ **FLOATING
C1128 m1_20614_109086# a_64549_20015# 0 $ **FLOATING
C1129 m1_20770_109258# a_64549_20015# 0 $ **FLOATING
C1130 m1_20614_109242# a_64549_20015# 0 $ **FLOATING
C1131 m1_20770_109414# a_64549_20015# 0 $ **FLOATING
C1132 m1_20614_109398# a_64549_20015# 0 $ **FLOATING
C1133 m1_20770_109570# a_64549_20015# 0 $ **FLOATING
C1134 m1_20614_109554# a_64549_20015# 0 $ **FLOATING
C1135 m1_20430_109570# a_64549_20015# 0 $ **FLOATING
C1136 m1_20330_109590# a_64549_20015# 0 $ **FLOATING
C1137 m1_20458_109694# a_64549_20015# 0 $ **FLOATING
C1138 m1_20330_109690# a_64549_20015# 0 $ **FLOATING
C1139 m1_20222_107200# a_64549_20015# 3.5300800000000001e-16
C1140 m1_20136_108556# a_64549_20015# 3.7989600000000005e-16
C1141 m1_20030_108750# a_64549_20015# 0 $ **FLOATING
C1142 m1_20000_108866# a_64549_20015# 0 $ **FLOATING
C1143 m1_20000_109022# a_64549_20015# 0 $ **FLOATING
C1144 m1_20000_109178# a_64549_20015# 0 $ **FLOATING
C1145 m1_20000_109334# a_64549_20015# 0 $ **FLOATING
C1146 m1_20000_109490# a_64549_20015# 0 $ **FLOATING
C1147 m1_20000_109646# a_64549_20015# 0 $ **FLOATING
C1148 li_66860_20030# a_64549_20015# 0 $ **FLOATING
C1149 li_66634_20078# a_64549_20015# 0 $ **FLOATING
C1150 li_66418_20002# a_64549_20015# 0 $ **FLOATING
C1151 li_66634_20294# a_64549_20015# 0 $ **FLOATING
C1152 li_66418_20218# a_64549_20015# 0 $ **FLOATING
C1153 li_66634_20510# a_64549_20015# 0 $ **FLOATING
C1154 li_66418_20434# a_64549_20015# 0 $ **FLOATING
C1155 li_66860_20810# a_64549_20015# 0 $ **FLOATING
C1156 li_66634_20726# a_64549_20015# 0 $ **FLOATING
C1157 li_66418_20650# a_64549_20015# 0 $ **FLOATING
C1158 li_66634_20942# a_64549_20015# 0 $ **FLOATING
C1159 li_66418_20866# a_64549_20015# 0 $ **FLOATING
C1160 li_66634_21158# a_64549_20015# 0 $ **FLOATING
C1161 li_66418_21082# a_64549_20015# 0 $ **FLOATING
C1162 li_66634_21374# a_64549_20015# 0 $ **FLOATING
C1163 li_66418_21298# a_64549_20015# 0 $ **FLOATING
C1164 li_66860_21590# a_64549_20015# 0 $ **FLOATING
C1165 li_66634_21590# a_64549_20015# 0 $ **FLOATING
C1166 li_66418_21514# a_64549_20015# 0 $ **FLOATING
C1167 li_66634_21806# a_64549_20015# 0 $ **FLOATING
C1168 li_66418_21730# a_64549_20015# 0 $ **FLOATING
C1169 li_66634_22022# a_64549_20015# 0 $ **FLOATING
C1170 li_66418_21946# a_64549_20015# 0 $ **FLOATING
C1171 li_66634_22238# a_64549_20015# 0 $ **FLOATING
C1172 li_66418_22162# a_64549_20015# 0 $ **FLOATING
C1173 li_66860_22370# a_64549_20015# 0 $ **FLOATING
C1174 li_66634_22454# a_64549_20015# 0 $ **FLOATING
C1175 li_66418_22378# a_64549_20015# 0 $ **FLOATING
C1176 li_66634_22670# a_64549_20015# 0 $ **FLOATING
C1177 li_66418_22594# a_64549_20015# 0 $ **FLOATING
C1178 li_66634_22886# a_64549_20015# 0 $ **FLOATING
C1179 li_66418_22810# a_64549_20015# 0 $ **FLOATING
C1180 li_66860_23150# a_64549_20015# 0 $ **FLOATING
C1181 li_66634_23102# a_64549_20015# 0 $ **FLOATING
C1182 li_66418_23026# a_64549_20015# 0 $ **FLOATING
C1183 li_66418_23242# a_64549_20015# 0 $ **FLOATING
C1184 li_22138_107238# a_64549_20015# 0 $ **FLOATING
C1185 li_21922_107200# a_64549_20015# 0 $ **FLOATING
C1186 li_21274_107200# a_64549_20015# 0 $ **FLOATING
C1187 li_20626_107200# a_64549_20015# 0 $ **FLOATING
C1188 li_22138_107454# a_64549_20015# 0 $ **FLOATING
C1189 li_21922_107378# a_64549_20015# 0 $ **FLOATING
C1190 li_21274_107366# a_64549_20015# 0 $ **FLOATING
C1191 li_20000_107200# a_64549_20015# 0 $ **FLOATING
C1192 li_22138_107670# a_64549_20015# 0 $ **FLOATING
C1193 li_21922_107594# a_64549_20015# 0 $ **FLOATING
C1194 li_20626_107354# a_64549_20015# 0 $ **FLOATING
C1195 li_20000_107342# a_64549_20015# 0 $ **FLOATING
C1196 li_21274_107582# a_64549_20015# 0 $ **FLOATING
C1197 li_20626_107570# a_64549_20015# 0 $ **FLOATING
C1198 li_22138_107886# a_64549_20015# 0 $ **FLOATING
C1199 li_21922_107810# a_64549_20015# 0 $ **FLOATING
C1200 li_20000_107558# a_64549_20015# 0 $ **FLOATING
C1201 li_21274_107798# a_64549_20015# 0 $ **FLOATING
C1202 li_22138_108102# a_64549_20015# 0 $ **FLOATING
C1203 li_21922_108026# a_64549_20015# 0 $ **FLOATING
C1204 li_20626_107786# a_64549_20015# 0 $ **FLOATING
C1205 li_21274_108014# a_64549_20015# 0 $ **FLOATING
C1206 li_20000_107774# a_64549_20015# 0 $ **FLOATING
C1207 li_20626_108002# a_64549_20015# 0 $ **FLOATING
C1208 li_20000_107990# a_64549_20015# 0 $ **FLOATING
C1209 li_22354_108826# a_64549_20015# 0 $ **FLOATING
C1210 li_22354_109042# a_64549_20015# 0 $ **FLOATING
C1211 li_22138_108966# a_64549_20015# 0 $ **FLOATING
C1212 li_21922_108890# a_64549_20015# 0 $ **FLOATING
C1213 li_21706_108814# a_64549_20015# 0 $ **FLOATING
C1214 li_21922_109106# a_64549_20015# 0 $ **FLOATING
C1215 li_21706_109030# a_64549_20015# 0 $ **FLOATING
C1216 li_21490_108954# a_64549_20015# 0 $ **FLOATING
C1217 li_21274_108878# a_64549_20015# 0 $ **FLOATING
C1218 li_21058_108802# a_64549_20015# 0 $ **FLOATING
C1219 li_22050_109330# a_64549_20015# 0 $ **FLOATING
C1220 li_21706_109246# a_64549_20015# 0 $ **FLOATING
C1221 li_21490_109170# a_64549_20015# 0 $ **FLOATING
C1222 li_21274_109094# a_64549_20015# 0 $ **FLOATING
C1223 li_21058_109018# a_64549_20015# 0 $ **FLOATING
C1224 li_20842_108942# a_64549_20015# 0 $ **FLOATING
C1225 li_20626_108866# a_64549_20015# 0 $ **FLOATING
C1226 li_20410_108790# a_64549_20015# 0 $ **FLOATING
C1227 li_20842_109158# a_64549_20015# 0 $ **FLOATING
C1228 li_20626_109082# a_64549_20015# 0 $ **FLOATING
C1229 li_20410_109006# a_64549_20015# 0 $ **FLOATING
C1230 li_20194_108930# a_64549_20015# 0 $ **FLOATING
C1231 li_20000_108854# a_64549_20015# 0 $ **FLOATING
C1232 li_20410_109222# a_64549_20015# 0 $ **FLOATING
C1233 li_20194_109146# a_64549_20015# 0 $ **FLOATING
C1234 li_20000_109070# a_64549_20015# 0 $ **FLOATING
C1235 li_20000_109286# a_64549_20015# 0 $ **FLOATING
C1236 li_21650_109470# a_64549_20015# 0 $ **FLOATING
C1237 li_20840_109410# a_64549_20015# 0 $ **FLOATING
C1238 li_20060_109550# a_64549_20015# 0 $ **FLOATING
C1239 a_66936_20000# a_64549_20015# 0 $ **FLOATING
C1240 a_66620_20000# a_64549_20015# 0 $ **FLOATING
C1241 a_66404_20000# a_64549_20015# 0 $ **FLOATING
C1242 a_67404_20152# a_64549_20015# 0 $ **FLOATING
C1243 a_67216_20142# a_64549_20015# 0 $ **FLOATING
C1244 a_67036_20190# a_64549_20015# 0 $ **FLOATING
C1245 a_66620_20156# a_64549_20015# 0 $ **FLOATING
C1246 a_66404_20204# a_64549_20015# 0 $ **FLOATING
C1247 a_66936_20372# a_64549_20015# 0 $ **FLOATING
C1248 a_66620_20372# a_64549_20015# 0 $ **FLOATING
C1249 a_66404_20420# a_64549_20015# 0 $ **FLOATING
C1250 a_66620_20588# a_64549_20015# 0 $ **FLOATING
C1251 a_66404_20636# a_64549_20015# 0 $ **FLOATING
C1252 a_66620_20804# a_64549_20015# 0 $ **FLOATING
C1253 a_66404_20852# a_64549_20015# 0 $ **FLOATING
C1254 a_66620_21020# a_64549_20015# 0 $ **FLOATING
C1255 a_66404_21068# a_64549_20015# 0 $ **FLOATING
C1256 a_67484_21260# a_64549_20015# 0 $ **FLOATING
C1257 a_67036_21270# a_64549_20015# 0 $ **FLOATING
C1258 a_66856_21318# a_64549_20015# 0 $ **FLOATING
C1259 a_66620_21236# a_64549_20015# 0 $ **FLOATING
C1260 a_66404_21284# a_64549_20015# 0 $ **FLOATING
C1261 a_66936_21508# a_64549_20015# 0 $ **FLOATING
C1262 a_66620_21452# a_64549_20015# 0 $ **FLOATING
C1263 a_66404_21500# a_64549_20015# 0 $ **FLOATING
C1264 a_66620_21668# a_64549_20015# 0 $ **FLOATING
C1265 a_64400_20000# a_64549_20015# 2.2618000000000006e-16 $ **FLOATING
C1266 a_66404_21716# a_64549_20015# 0 $ **FLOATING
C1267 a_66620_21884# a_64549_20015# 0 $ **FLOATING
C1268 a_66404_21932# a_64549_20015# 0 $ **FLOATING
C1269 a_66620_22100# a_64549_20015# 0 $ **FLOATING
C1270 a_66404_22148# a_64549_20015# 0 $ **FLOATING
C1271 a_67576_22386# a_64549_20015# 0 $ **FLOATING
C1272 a_67268_22388# a_64549_20015# 0 $ **FLOATING
C1273 a_67052_22436# a_64549_20015# 0 $ **FLOATING
C1274 a_66856_22398# a_64549_20015# 0 $ **FLOATING
C1275 a_66620_22316# a_64549_20015# 0 $ **FLOATING
C1276 a_66404_22364# a_64549_20015# 0 $ **FLOATING
C1277 a_66936_22644# a_64549_20015# 0 $ **FLOATING
C1278 a_66620_22532# a_64549_20015# 0 $ **FLOATING
C1279 a_66404_22580# a_64549_20015# 0 $ **FLOATING
C1280 a_66620_22748# a_64549_20015# 0 $ **FLOATING
C1281 a_66404_22796# a_64549_20015# 0 $ **FLOATING
C1282 a_66620_22964# a_64549_20015# 0 $ **FLOATING
C1283 a_66404_23012# a_64549_20015# 0 $ **FLOATING
C1284 a_64400_20751# a_64549_20015# 3.0544800000000003e-16 $ **FLOATING
C1285 a_66620_23180# a_64549_20015# 0 $ **FLOATING
C1286 a_66404_23228# a_64549_20015# 0 $ **FLOATING
C1287 a_64400_22039# a_64549_20015# 9.5162400000000014e-17 $ **FLOATING
C1288 a_64400_22591# a_64549_20015# 2.3011199999999999e-16 $ **FLOATING
C1289 a_22430_108402# a_64549_20015# 3.4029800000000001e-18 $ **FLOATING
C1290 a_20068_108389# a_64549_20015# 2.6014299999999998e-16 $ **FLOATING
C1291 a_21763_108389# a_64549_20015# 5.7413651728119439e-18 $ **FLOATING
C1292 a_20000_108402# a_64549_20015# 8.8156153308037068e-18 $ **FLOATING
C1293 a_20431_108389# a_64549_20015# 3.7713623455445042e-18 $ **FLOATING
C1294 a_22124_108884# a_64549_20015# 0 $ **FLOATING
C1295 a_22340_109052# a_64549_20015# 0 $ **FLOATING
C1296 a_21908_108932# a_64549_20015# 0 $ **FLOATING
C1297 a_22124_109100# a_64549_20015# 0 $ **FLOATING
C1298 a_21692_108980# a_64549_20015# 0 $ **FLOATING
C1299 a_21260_108860# a_64549_20015# 0 $ **FLOATING
C1300 a_22340_109268# a_64549_20015# 0 $ **FLOATING
C1301 a_21908_109148# a_64549_20015# 0 $ **FLOATING
C1302 a_21476_109028# a_64549_20015# 0 $ **FLOATING
C1303 a_21044_108908# a_64549_20015# 0 $ **FLOATING
C1304 a_22124_109316# a_64549_20015# 0 $ **FLOATING
C1305 a_21692_109196# a_64549_20015# 0 $ **FLOATING
C1306 a_21260_109076# a_64549_20015# 0 $ **FLOATING
C1307 a_20828_108956# a_64549_20015# 0 $ **FLOATING
C1308 a_22396_109494# a_64549_20015# 0 $ **FLOATING
C1309 a_21908_109364# a_64549_20015# 0 $ **FLOATING
C1310 a_21476_109244# a_64549_20015# 0 $ **FLOATING
C1311 a_21044_109124# a_64549_20015# 0 $ **FLOATING
C1312 a_20612_109004# a_64549_20015# 0 $ **FLOATING
C1313 a_20180_108884# a_64549_20015# 0 $ **FLOATING
C1314 a_21692_109412# a_64549_20015# 0 $ **FLOATING
C1315 a_21260_109292# a_64549_20015# 0 $ **FLOATING
C1316 a_20828_109172# a_64549_20015# 0 $ **FLOATING
C1317 a_20396_109052# a_64549_20015# 0 $ **FLOATING
C1318 a_21044_109340# a_64549_20015# 0 $ **FLOATING
C1319 a_20612_109220# a_64549_20015# 0 $ **FLOATING
C1320 a_20180_109100# a_64549_20015# 0 $ **FLOATING
C1321 a_22396_109674# a_64549_20015# 0 $ **FLOATING
C1322 a_21496_109636# a_64549_20015# 0 $ **FLOATING
C1323 a_21260_109508# a_64549_20015# 0 $ **FLOATING
C1324 a_20828_109388# a_64549_20015# 0 $ **FLOATING
C1325 a_20396_109268# a_64549_20015# 0 $ **FLOATING
C1326 a_21044_109556# a_64549_20015# 0 $ **FLOATING
C1327 a_20612_109436# a_64549_20015# 0 $ **FLOATING
C1328 a_20180_109316# a_64549_20015# 0 $ **FLOATING
C1329 a_20828_109604# a_64549_20015# 0 $ **FLOATING
C1330 a_20396_109484# a_64549_20015# 0 $ **FLOATING
C1331 a_20612_109652# a_64549_20015# 0 $ **FLOATING
C1332 a_20180_109532# a_64549_20015# 0 $ **FLOATING
C1333 a_20000_109044# a_64549_20015# 0 $ **FLOATING
C1334 w_65333_20000# a_64549_20015# 6.0082914894888347e-16 $ **FLOATING
C1335 w_64364_19964# a_64549_20015# 7.1780035069927476e-17 $ **FLOATING
C1336 w_22048_107200# a_64549_20015# 3.6528034128934614e-16 $ **FLOATING
C1337 w_20716_107200# a_64549_20015# 3.6528026291167593e-16 $ **FLOATING
C1338 w_20000_107200# a_64549_20015# 2.3743199999999998e-16
C1339 a_64549_20015# a_64549_20015# 0 $ **FLOATING
C1340 a_64549_20015.t30 a_64549_20015# 0 $ **FLOATING
C1341 a_64549_20015.n0 a_64549_20015# 0 $ **FLOATING
C1342 a_64549_20015.n1 a_64549_20015# 0 $ **FLOATING
C1343 a_64549_20015.n2 a_64549_20015# 0 $ **FLOATING
C1344 a_64549_20015.n3 a_64549_20015# 0 $ **FLOATING
C1345 a_64549_20015.t8 a_64549_20015# 0 $ **FLOATING
C1346 a_64549_20015.n4 a_64549_20015# 0 $ **FLOATING
C1347 a_64549_20015.t27 a_64549_20015# 0 $ **FLOATING
C1348 a_64549_20015.n5 a_64549_20015# 0 $ **FLOATING
C1349 a_64549_20015.n6 a_64549_20015# 0 $ **FLOATING
C1350 a_64549_20015.n7 a_64549_20015# 0 $ **FLOATING
C1351 a_64549_20015.n8 a_64549_20015# 0 $ **FLOATING
C1352 a_64549_20015.n9 a_64549_20015# 0 $ **FLOATING
C1353 a_64549_20015.t37 a_64549_20015# 0 $ **FLOATING
C1354 a_64549_20015.n10 a_64549_20015# 0 $ **FLOATING
C1355 a_64549_20015.n11 a_64549_20015# 0 $ **FLOATING
C1356 a_64549_20015.n12 a_64549_20015# 0 $ **FLOATING
C1357 a_64549_20015.n13 a_64549_20015# 0 $ **FLOATING
C1358 a_64549_20015.t4 a_64549_20015# 0 $ **FLOATING
C1359 a_64549_20015.n14 a_64549_20015# 0 $ **FLOATING
C1360 a_64549_20015.t28 a_64549_20015# 0 $ **FLOATING
C1361 a_64549_20015.n15 a_64549_20015# 0 $ **FLOATING
C1362 a_64549_20015.n16 a_64549_20015# 0 $ **FLOATING
C1363 a_64549_20015.n17 a_64549_20015# 0 $ **FLOATING
C1364 a_64549_20015.n18 a_64549_20015# 0 $ **FLOATING
C1365 a_64549_20015.n19 a_64549_20015# 0 $ **FLOATING
C1366 a_64549_20015.n20 a_64549_20015# 0 $ **FLOATING
C1367 a_64549_20015.n21 a_64549_20015# 0 $ **FLOATING
C1368 a_64549_20015.t36 a_64549_20015# 0 $ **FLOATING
C1369 a_64549_20015.n22 a_64549_20015# 0 $ **FLOATING
C1370 a_64549_20015.n23 a_64549_20015# 0 $ **FLOATING
C1371 a_64549_20015.n24 a_64549_20015# 0 $ **FLOATING
C1372 a_64549_20015.n25 a_64549_20015# 0 $ **FLOATING
C1373 a_64549_20015.n26 a_64549_20015# 0 $ **FLOATING
C1374 a_64549_20015.n27 a_64549_20015# 0 $ **FLOATING
C1375 a_64549_20015.n28 a_64549_20015# 0 $ **FLOATING
C1376 a_64549_20015.n29 a_64549_20015# 0 $ **FLOATING
C1377 a_64549_20015.n30 a_64549_20015# 0 $ **FLOATING
C1378 a_64549_20015.n31 a_64549_20015# 0 $ **FLOATING
C1379 a_64549_20015.n32 a_64549_20015# 0 $ **FLOATING
C1380 a_64549_20015.n33 a_64549_20015# 0 $ **FLOATING
C1381 a_64549_20015.n34 a_64549_20015# 0 $ **FLOATING
C1382 a_64549_20015.n35 a_64549_20015# 0 $ **FLOATING
C1383 a_64549_20015.n36 a_64549_20015# 0 $ **FLOATING
C1384 a_64549_20015.n37 a_64549_20015# 0 $ **FLOATING
C1385 a_64549_20015.n38 a_64549_20015# 0 $ **FLOATING
C1386 a_64549_20015.n39 a_64549_20015# 0 $ **FLOATING
C1387 a_64549_20015.n40 a_64549_20015# 0 $ **FLOATING
C1388 a_64549_20015.n41 a_64549_20015# 0 $ **FLOATING
C1389 a_64549_20015.n42 a_64549_20015# 0 $ **FLOATING
C1390 a_64549_20015.n43 a_64549_20015# 0 $ **FLOATING
C1391 a_64549_20015.n44 a_64549_20015# 0 $ **FLOATING
C1392 a_64549_20015.n45 a_64549_20015# 0 $ **FLOATING
C1393 a_64549_20015.n46 a_64549_20015# 0 $ **FLOATING
C1394 a_64549_20015.n47 a_64549_20015# 0 $ **FLOATING
C1395 a_64549_20015.n48 a_64549_20015# 0 $ **FLOATING
C1396 a_64549_20015.n49 a_64549_20015# 0 $ **FLOATING
C1397 a_64549_20015.n50 a_64549_20015# 0 $ **FLOATING
C1398 a_64549_20015.n51 a_64549_20015# 0 $ **FLOATING
C1399 a_64549_20015.n52 a_64549_20015# 0 $ **FLOATING
C1400 a_64549_20015.n53 a_64549_20015# 0 $ **FLOATING
C1401 a_64549_20015.n54 a_64549_20015# 0 $ **FLOATING
C1402 a_64549_20015.n55 a_64549_20015# 0 $ **FLOATING
C1403 a_64549_20015.n56 a_64549_20015# 0 $ **FLOATING
C1404 a_64549_20015.n57 a_64549_20015# 0 $ **FLOATING
C1405 a_64549_20015.t21 a_64549_20015# 0 $ **FLOATING
C1406 a_64549_20015.n58 a_64549_20015# 0 $ **FLOATING
C1407 a_64549_20015.t22 a_64549_20015# 0 $ **FLOATING
C1408 a_64549_20015.n59 a_64549_20015# 0 $ **FLOATING
C1409 a_64549_20015.t39 a_64549_20015# 0 $ **FLOATING
C1410 a_64549_20015.n60 a_64549_20015# 0 $ **FLOATING
C1411 a_64549_20015.t25 a_64549_20015# 0 $ **FLOATING
C1412 a_64549_20015.n61 a_64549_20015# 0 $ **FLOATING
C1413 a_64549_20015.t24 a_64549_20015# 0 $ **FLOATING
C1414 a_64549_20015.n62 a_64549_20015# 0 $ **FLOATING
C1415 a_64549_20015.n63 a_64549_20015# 0 $ **FLOATING
C1416 a_64549_20015.n64 a_64549_20015# 0 $ **FLOATING
C1417 a_64549_20015.n65 a_64549_20015# 0 $ **FLOATING
C1418 a_64549_20015.n66 a_64549_20015# 0 $ **FLOATING
C1419 a_64549_20015.n67 a_64549_20015# 0 $ **FLOATING
C1420 a_64549_20015.n68 a_64549_20015# 0 $ **FLOATING
C1421 a_64549_20015.n69 a_64549_20015# 0 $ **FLOATING
C1422 a_64549_20015.t38 a_64549_20015# 0 $ **FLOATING
C1423 a_64549_20015.n70 a_64549_20015# 0 $ **FLOATING
C1424 a_64549_20015.n71 a_64549_20015# 0 $ **FLOATING
C1425 a_64549_20015.n72 a_64549_20015# 0 $ **FLOATING
C1426 a_64549_20015.n73 a_64549_20015# 0 $ **FLOATING
C1427 a_64549_20015.n74 a_64549_20015# 0 $ **FLOATING
C1428 a_64549_20015.n75 a_64549_20015# 0 $ **FLOATING
C1429 a_64549_20015.n76 a_64549_20015# 0 $ **FLOATING
C1430 a_64549_20015.n77 a_64549_20015# 0 $ **FLOATING
C1431 a_64549_20015.n78 a_64549_20015# 0 $ **FLOATING
C1432 a_64549_20015.n79 a_64549_20015# 0 $ **FLOATING
C1433 a_64549_20015.n80 a_64549_20015# 0 $ **FLOATING
C1434 a_64549_20015.n81 a_64549_20015# 0 $ **FLOATING
C1435 a_64549_20015.n82 a_64549_20015# 0 $ **FLOATING
C1436 a_64549_20015.n83 a_64549_20015# 0 $ **FLOATING
C1437 a_64549_20015.n84 a_64549_20015# 0 $ **FLOATING
C1438 a_64549_20015.n85 a_64549_20015# 0 $ **FLOATING
C1439 a_64549_20015.n86 a_64549_20015# 0 $ **FLOATING
C1440 a_64549_20015.n87 a_64549_20015# 0 $ **FLOATING
C1441 a_64549_20015.n88 a_64549_20015# 0 $ **FLOATING
C1442 a_64549_20015.n89 a_64549_20015# 0 $ **FLOATING
C1443 a_64549_20015.n90 a_64549_20015# 0 $ **FLOATING
C1444 a_64549_20015.n91 a_64549_20015# 0 $ **FLOATING
C1445 a_64549_20015.n92 a_64549_20015# 0 $ **FLOATING
C1446 a_64549_20015.n93 a_64549_20015# 0 $ **FLOATING
C1447 a_64549_20015.n94 a_64549_20015# 0 $ **FLOATING
C1448 a_64549_20015.n95 a_64549_20015# 0 $ **FLOATING
C1449 a_64549_20015.n96 a_64549_20015# 0 $ **FLOATING
C1450 a_64549_20015.n97 a_64549_20015# 0 $ **FLOATING
C1451 a_64549_20015.n98 a_64549_20015# 0 $ **FLOATING
C1452 a_64549_20015.n99 a_64549_20015# 0 $ **FLOATING
C1453 a_64549_20015.n100 a_64549_20015# 0 $ **FLOATING
C1454 a_64549_20015.n101 a_64549_20015# 0 $ **FLOATING
C1455 a_64549_20015.n102 a_64549_20015# 0 $ **FLOATING
C1456 a_64549_20015.n103 a_64549_20015# 0 $ **FLOATING
C1457 a_64549_20015.n104 a_64549_20015# 0 $ **FLOATING
C1458 a_64549_20015.n105 a_64549_20015# 0 $ **FLOATING
C1459 a_64549_20015.t11 a_64549_20015# 0 $ **FLOATING
C1460 a_64549_20015.n106 a_64549_20015# 0 $ **FLOATING
C1461 a_64549_20015.n107 a_64549_20015# 0 $ **FLOATING
C1462 a_64549_20015.n108 a_64549_20015# 0 $ **FLOATING
C1463 a_64549_20015.n109 a_64549_20015# 0 $ **FLOATING
C1464 a_64549_20015.n110 a_64549_20015# 0 $ **FLOATING
C1465 a_64549_20015.n111 a_64549_20015# 0 $ **FLOATING
C1466 a_64549_20015.n112 a_64549_20015# 0 $ **FLOATING
C1467 a_64549_20015.t44 a_64549_20015# 0 $ **FLOATING
C1468 a_64549_20015.n113 a_64549_20015# 0 $ **FLOATING
C1469 a_64549_20015.t16 a_64549_20015# 0 $ **FLOATING
C1470 a_64549_20015.n114 a_64549_20015# 0 $ **FLOATING
C1471 a_64549_20015.t15 a_64549_20015# 0 $ **FLOATING
C1472 a_64549_20015.n115 a_64549_20015# 0 $ **FLOATING
C1473 a_64549_20015.n116 a_64549_20015# 0 $ **FLOATING
C1474 a_64549_20015.n117 a_64549_20015# 0 $ **FLOATING
C1475 a_64549_20015.n118 a_64549_20015# 0 $ **FLOATING
C1476 a_64549_20015.n119 a_64549_20015# 0 $ **FLOATING
C1477 a_64549_20015.n120 a_64549_20015# 0 $ **FLOATING
C1478 a_64549_20015.n121 a_64549_20015# 0 $ **FLOATING
C1479 a_64549_20015.n122 a_64549_20015# 0 $ **FLOATING
C1480 a_64549_20015.t42 a_64549_20015# 0 $ **FLOATING
C1481 a_64549_20015.n123 a_64549_20015# 0 $ **FLOATING
C1482 a_64549_20015.n124 a_64549_20015# 0 $ **FLOATING
C1483 a_64549_20015.t23 a_64549_20015# 0 $ **FLOATING
C1484 a_64549_20015.t20 a_64549_20015# 0 $ **FLOATING
C1485 a_64549_20015.t14 a_64549_20015# 0 $ **FLOATING
C1486 a_64549_20015.t10 a_64549_20015# 0 $ **FLOATING
C1487 a_64549_20015.n125 a_64549_20015# 0 $ **FLOATING
C1488 a_64549_20015.n126 a_64549_20015# 0 $ **FLOATING
C1489 a_64549_20015.t32 a_64549_20015# 0 $ **FLOATING
C1490 a_64549_20015.t9 a_64549_20015# 0 $ **FLOATING
C1491 a_64549_20015.t31 a_64549_20015# 0 $ **FLOATING
C1492 a_64549_20015.t33 a_64549_20015# 0 $ **FLOATING
C1493 a_64549_20015.t6 a_64549_20015# 0 $ **FLOATING
C1494 a_64549_20015.t29 a_64549_20015# 0 $ **FLOATING
C1495 a_64549_20015.t3 a_64549_20015# 0 $ **FLOATING
C1496 a_64549_20015.t26 a_64549_20015# 0 $ **FLOATING
C1497 a_64549_20015.t0 a_64549_20015# 0 $ **FLOATING
C1498 a_64549_20015.t17 a_64549_20015# 0 $ **FLOATING
C1499 a_64549_20015.t12 a_64549_20015# 0 $ **FLOATING
C1500 a_64549_20015.n127 a_64549_20015# 0 $ **FLOATING
C1501 a_64549_20015.n128 a_64549_20015# 0 $ **FLOATING
C1502 a_64549_20015.n129 a_64549_20015# 0 $ **FLOATING
C1503 a_64549_20015.n130 a_64549_20015# 0 $ **FLOATING
C1504 a_64549_20015.t5 a_64549_20015# 0 $ **FLOATING
C1505 a_64549_20015.n131 a_64549_20015# 0 $ **FLOATING
C1506 a_64549_20015.n132 a_64549_20015# 0 $ **FLOATING
C1507 a_64549_20015.n133 a_64549_20015# 0 $ **FLOATING
C1508 a_64549_20015.n134 a_64549_20015# 0 $ **FLOATING
C1509 a_64549_20015.n135 a_64549_20015# 0 $ **FLOATING
C1510 a_64549_20015.n136 a_64549_20015# 0 $ **FLOATING
C1511 a_64549_20015.n137 a_64549_20015# 0 $ **FLOATING
C1512 a_64549_20015.n138 a_64549_20015# 0 $ **FLOATING
C1513 a_64549_20015.n139 a_64549_20015# 0 $ **FLOATING
C1514 a_64549_20015.n140 a_64549_20015# 0 $ **FLOATING
C1515 a_64549_20015.n141 a_64549_20015# 0 $ **FLOATING
C1516 a_64549_20015.n142 a_64549_20015# 0 $ **FLOATING
C1517 a_64549_20015.n143 a_64549_20015# 0 $ **FLOATING
C1518 a_64549_20015.n144 a_64549_20015# 0 $ **FLOATING
C1519 a_64549_20015.n145 a_64549_20015# 0 $ **FLOATING
C1520 a_64549_20015.n146 a_64549_20015# 0 $ **FLOATING
C1521 a_64549_20015.t1 a_64549_20015# 0 $ **FLOATING
C1522 a_64549_20015.n147 a_64549_20015# 0 $ **FLOATING
C1523 a_64549_20015.n148 a_64549_20015# 0 $ **FLOATING
C1524 a_64549_20015.n149 a_64549_20015# 0 $ **FLOATING
C1525 a_64549_20015.n150 a_64549_20015# 0 $ **FLOATING
C1526 a_64549_20015.n151 a_64549_20015# 0 $ **FLOATING
C1527 a_64549_20015.n152 a_64549_20015# 0 $ **FLOATING
C1528 a_64549_20015.n153 a_64549_20015# 0 $ **FLOATING
C1529 a_64549_20015.n154 a_64549_20015# 0 $ **FLOATING
C1530 a_64549_20015.t40 a_64549_20015# 0 $ **FLOATING
C1531 a_64549_20015.n155 a_64549_20015# 0 $ **FLOATING
C1532 a_64549_20015.n156 a_64549_20015# 0 $ **FLOATING
C1533 a_64549_20015.n157 a_64549_20015# 0 $ **FLOATING
C1534 a_64549_20015.n158 a_64549_20015# 0 $ **FLOATING
C1535 a_64549_20015.n159 a_64549_20015# 0 $ **FLOATING
C1536 a_64549_20015.n160 a_64549_20015# 0 $ **FLOATING
C1537 a_64549_20015.n161 a_64549_20015# 0 $ **FLOATING
C1538 a_64549_20015.n162 a_64549_20015# 0 $ **FLOATING
C1539 a_64549_20015.n163 a_64549_20015# 0 $ **FLOATING
C1540 a_64549_20015.n164 a_64549_20015# 0 $ **FLOATING
C1541 a_64549_20015.n165 a_64549_20015# 0 $ **FLOATING
C1542 a_64549_20015.n166 a_64549_20015# 0 $ **FLOATING
C1543 a_64549_20015.n167 a_64549_20015# 0 $ **FLOATING
C1544 a_64549_20015.t19 a_64549_20015# 0 $ **FLOATING
C1545 a_64549_20015.t18 a_64549_20015# 0 $ **FLOATING
C1546 a_64549_20015.n168 a_64549_20015# 0 $ **FLOATING
C1547 a_64549_20015.n169 a_64549_20015# 0 $ **FLOATING
C1548 a_64549_20015.n170 a_64549_20015# 0 $ **FLOATING
C1549 a_64549_20015.n171 a_64549_20015# 0 $ **FLOATING
C1550 a_64549_20015.n172 a_64549_20015# 0 $ **FLOATING
C1551 a_64549_20015.n173 a_64549_20015# 0 $ **FLOATING
C1552 a_64549_20015.t41 a_64549_20015# 0 $ **FLOATING
C1553 a_64549_20015.n174 a_64549_20015# 0 $ **FLOATING
C1554 a_64549_20015.n175 a_64549_20015# 0 $ **FLOATING
C1555 a_64549_20015.t2 a_64549_20015# 0 $ **FLOATING
C1556 a_64549_20015.n176 a_64549_20015# 0 $ **FLOATING
C1557 a_64549_20015.n177 a_64549_20015# 0 $ **FLOATING
C1558 a_64549_20015.n178 a_64549_20015# 0 $ **FLOATING
C1559 a_64549_20015.n179 a_64549_20015# 0 $ **FLOATING
C1560 a_64549_20015.n180 a_64549_20015# 0 $ **FLOATING
C1561 a_64549_20015.n181 a_64549_20015# 0 $ **FLOATING
C1562 a_64549_20015.n182 a_64549_20015# 0 $ **FLOATING
C1563 a_64549_20015.n183 a_64549_20015# 0 $ **FLOATING
C1564 a_64549_20015.n184 a_64549_20015# 0 $ **FLOATING
C1565 a_64549_20015.n185 a_64549_20015# 0 $ **FLOATING
C1566 a_64549_20015.n186 a_64549_20015# 0 $ **FLOATING
C1567 a_64549_20015.n187 a_64549_20015# 0 $ **FLOATING
C1568 a_64549_20015.n188 a_64549_20015# 0 $ **FLOATING
C1569 a_64549_20015.n189 a_64549_20015# 0 $ **FLOATING
C1570 a_64549_20015.n190 a_64549_20015# 0 $ **FLOATING
C1571 a_64549_20015.t7 a_64549_20015# 0 $ **FLOATING
C1572 a_64549_20015.n191 a_64549_20015# 0 $ **FLOATING
C1573 a_64549_20015.n192 a_64549_20015# 0 $ **FLOATING
C1574 a_64549_20015.n193 a_64549_20015# 0 $ **FLOATING
C1575 a_64549_20015.n194 a_64549_20015# 0 $ **FLOATING
C1576 a_64549_20015.n195 a_64549_20015# 0 $ **FLOATING
C1577 a_64549_20015.n196 a_64549_20015# 0 $ **FLOATING
C1578 a_64549_20015.n197 a_64549_20015# 0 $ **FLOATING
C1579 a_64549_20015.n198 a_64549_20015# 0 $ **FLOATING
C1580 a_64549_20015.t34 a_64549_20015# 0 $ **FLOATING
C1581 a_64549_20015.n199 a_64549_20015# 0 $ **FLOATING
C1582 a_64549_20015.n200 a_64549_20015# 0 $ **FLOATING
C1583 a_64549_20015.n201 a_64549_20015# 0 $ **FLOATING
C1584 a_64549_20015.t35 a_64549_20015# 0 $ **FLOATING
C1585 a_64549_20015.n202 a_64549_20015# 0 $ **FLOATING
C1586 a_64549_20015.n203 a_64549_20015# 0 $ **FLOATING
C1587 a_64549_20015.t13 a_64549_20015# 0 $ **FLOATING
C1588 a_64549_20015.n204 a_64549_20015# 0 $ **FLOATING
C1589 a_64549_20015.n205 a_64549_20015# 0 $ **FLOATING
C1590 a_64549_20015.n206 a_64549_20015# 0 $ **FLOATING
C1591 a_64549_20015.n207 a_64549_20015# 0 $ **FLOATING
C1592 a_64549_20015.n208 a_64549_20015# 0 $ **FLOATING
C1593 a_64549_20015.n209 a_64549_20015# 0 $ **FLOATING
C1594 a_64549_20015.t43 a_64549_20015# 0 $ **FLOATING
C1595 a_64549_20015.n210 a_64549_20015# 0 $ **FLOATING
C1596 a_64549_20015.n211 a_64549_20015# 0 $ **FLOATING
C1597 a_64549_20015.n212 a_64549_20015# 0 $ **FLOATING
C1598 a_64549_20015.n213 a_64549_20015# 0 $ **FLOATING
C1599 w_20716_107200.t0 a_64549_20015# 1.5250450000000003e-15 $ **FLOATING
C1600 w_20716_107200.t1 a_64549_20015# 1.1597647370883241e-15 $ **FLOATING
C1601 w_22048_107200.t0 a_64549_20015# 7.462387224220498e-16 $ **FLOATING
C1602 w_22048_107200.t1 a_64549_20015# 9.816909362886043e-16 $ **FLOATING
C1603 w_64364_19964.t1 a_64549_20015# 1.4933721156149414e-17 $ **FLOATING
C1604 w_64364_19964.n0 a_64549_20015# 1.0477524295685508e-16 $ **FLOATING
C1605 w_64364_19964.n1 a_64549_20015# 4.3573595827465538e-17 $ **FLOATING
C1606 w_64364_19964.n2 a_64549_20015# 7.818462932568155e-17 $ **FLOATING
C1607 w_64364_19964.n3 a_64549_20015# 7.9539388506954007e-17 $ **FLOATING
C1608 w_64364_19964.n4 a_64549_20015# 3.5196978612457115e-17 $ **FLOATING
C1609 w_64364_19964.n5 a_64549_20015# 7.9539388506954007e-17 $ **FLOATING
C1610 w_64364_19964.n6 a_64549_20015# 6.0386244165857965e-17 $ **FLOATING
C1611 w_64364_19964.n7 a_64549_20015# 1.4755366134516834e-16 $ **FLOATING
C1612 w_64364_19964.n8 a_64549_20015# 1.6577309751949351e-16 $ **FLOATING
C1613 w_64364_19964.t19 a_64549_20015# 3.3818825419338509e-16 $ **FLOATING
C1614 w_64364_19964.n9 a_64549_20015# 1.8756766787870398e-16 $ **FLOATING
C1615 w_64364_19964.t13 a_64549_20015# 6.1580832796157917e-18 $ **FLOATING
C1616 w_64364_19964.n10 a_64549_20015# 6.0448339806341924e-17 $ **FLOATING
C1617 w_64364_19964.n11 a_64549_20015# 1.1066350269227092e-16 $ **FLOATING
C1618 w_64364_19964.n12 a_64549_20015# 1.054030047814405e-16 $ **FLOATING
C1619 w_64364_19964.n13 a_64549_20015# 1.1066350269227092e-16 $ **FLOATING
C1620 w_64364_19964.n14 a_64549_20015# 3.2701418984613307e-17 $ **FLOATING
C1621 w_64364_19964.n15 a_64549_20015# 3.1988667614496341e-17 $ **FLOATING
C1622 w_64364_19964.n16 a_64549_20015# 7.3866825482268463e-16 $ **FLOATING
C1623 w_64364_19964.n17 a_64549_20015# 1.2338146653572811e-16 $ **FLOATING
C1624 w_64364_19964.n18 a_64549_20015# 4.3616045777539584e-17 $ **FLOATING
C1625 w_64364_19964.n19 a_64549_20015# 1.1962010646454563e-16 $ **FLOATING
C1626 w_64364_19964.n20 a_64549_20015# 3.2701418984613307e-17 $ **FLOATING
C1627 w_64364_19964.n21 a_64549_20015# 1.1962010646454563e-16 $ **FLOATING
C1628 w_64364_19964.n22 a_64549_20015# 3.2701418984613307e-17 $ **FLOATING
C1629 w_64364_19964.n23 a_64549_20015# 5.163679370853846e-17 $ **FLOATING
C1630 w_64364_19964.n24 a_64549_20015# 3.2701418984613307e-17 $ **FLOATING
C1631 w_64364_19964.n25 a_64549_20015# 6.3766042967611337e-17 $ **FLOATING
C1632 w_64364_19964.n26 a_64549_20015# 3.2701418984613307e-17 $ **FLOATING
C1633 w_64364_19964.n27 a_64549_20015# 9.8559682204513093e-17 $ **FLOATING
C1634 w_64364_19964.n28 a_64549_20015# 3.2701418984613307e-17 $ **FLOATING
C1635 w_64364_19964.n29 a_64549_20015# 9.1643208994711849e-17 $ **FLOATING
C1636 w_64364_19964.n30 a_64549_20015# 3.2701418984613307e-17 $ **FLOATING
C1637 w_64364_19964.n31 a_64549_20015# 1.1066350269227092e-16 $ **FLOATING
C1638 w_64364_19964.n32 a_64549_20015# 3.2701418984613307e-17 $ **FLOATING
C1639 w_64364_19964.n33 a_64549_20015# 1.1066350269227092e-16 $ **FLOATING
C1640 w_64364_19964.n34 a_64549_20015# 3.2701418984613307e-17 $ **FLOATING
C1641 w_64364_19964.n35 a_64549_20015# 3.1988667614496341e-17 $ **FLOATING
C1642 w_64364_19964.n36 a_64549_20015# 4.3616045777539584e-17 $ **FLOATING
C1643 w_64364_19964.n37 a_64549_20015# 1.0477524295685508e-16 $ **FLOATING
C1644 w_64364_19964.n38 a_64549_20015# 4.3573595827465538e-17 $ **FLOATING
C1645 w_64364_19964.t0 a_64549_20015# 4.7915669537194327e-16 $ **FLOATING
C1646 w_64364_19964.t5 a_64549_20015# 6.7662724080216082e-16 $ **FLOATING
C1647 w_64364_19964.n39 a_64549_20015# 1.4311493770507771e-15 $ **FLOATING
C1648 w_64364_19964.t14 a_64549_20015# 5.9742668132697146e-16 $ **FLOATING
C1649 w_64364_19964.t9 a_64549_20015# 2.7347820337665204e-16 $ **FLOATING
C1650 w_64364_19964.t2 a_64549_20015# 1.8640976080415712e-15 $ **FLOATING
C1651 w_64364_19964.n40 a_64549_20015# 2.4667675143306004e-16 $ **FLOATING
C1652 w_64364_19964.n41 a_64549_20015# 4.3616045777539584e-17 $ **FLOATING
C1653 w_64364_19964.n42 a_64549_20015# 1.0544585146001992e-16 $ **FLOATING
C1654 w_64364_19964.n43 a_64549_20015# 4.3616045777539584e-17 $ **FLOATING
C1655 w_64364_19964.n44 a_64549_20015# 4.2738348809271385e-17 $ **FLOATING
C1656 w_64364_19964.n45 a_64549_20015# 7.5996694506776644e-17 $ **FLOATING
C1657 w_64364_19964.n46 a_64549_20015# 8.1375882905260199e-17 $ **FLOATING
C1658 w_64364_19964.n47 a_64549_20015# 8.7782765979314448e-17 $ **FLOATING
C1659 w_64364_19964.n48 a_64549_20015# 8.7040509833959546e-17 $ **FLOATING
C1660 w_64364_19964.n49 a_64549_20015# 2.2028946879028039e-16 $ **FLOATING
C1661 w_64364_19964.t7 a_64549_20015# 3.0312285593030821e-17 $ **FLOATING
C1662 w_64364_19964.t6 a_64549_20015# 1.4934826464653545e-17 $ **FLOATING
C1663 w_64364_19964.n50 a_64549_20015# 4.0551396656356677e-16 $ **FLOATING
C1664 w_64364_19964.n51 a_64549_20015# 2.6849675819297986e-16 $ **FLOATING
C1665 w_64364_19964.t10 a_64549_20015# 1.4521661382870366e-17 $ **FLOATING
C1666 w_64364_19964.t8 a_64549_20015# 2.7786500212184527e-17 $ **FLOATING
C1667 w_64364_19964.n52 a_64549_20015# 1.0230307505203913e-16 $ **FLOATING
C1668 w_64364_19964.t11 a_64549_20015# 1.4523204427874406e-17 $ **FLOATING
C1669 w_64364_19964.n53 a_64549_20015# 1.0499467196729359e-16 $ **FLOATING
C1670 w_64364_19964.t3 a_64549_20015# 2.809333156411268e-17 $ **FLOATING
C1671 w_64364_19964.t15 a_64549_20015# 1.4933722109823706e-17 $ **FLOATING
C1672 w_64364_19964.n54 a_64549_20015# 7.818462932568155e-17 $ **FLOATING
C1673 w_64364_19964.n55 a_64549_20015# 7.9539388506954007e-17 $ **FLOATING
C1674 w_64364_19964.n56 a_64549_20015# 3.5196978612457115e-17 $ **FLOATING
C1675 w_64364_19964.n57 a_64549_20015# 7.9539388506954007e-17 $ **FLOATING
C1676 w_64364_19964.n58 a_64549_20015# 6.0386244165857965e-17 $ **FLOATING
C1677 w_64364_19964.n59 a_64549_20015# 7.9539388506954007e-17 $ **FLOATING
C1678 w_64364_19964.n60 a_64549_20015# 1.6577309751949351e-16 $ **FLOATING
C1679 w_64364_19964.t18 a_64549_20015# 3.3818825419338509e-16 $ **FLOATING
C1680 w_64364_19964.n61 a_64549_20015# 8.5085462277098227e-17 $ **FLOATING
C1681 w_64364_19964.n62 a_64549_20015# 6.6343496514235674e-17 $ **FLOATING
C1682 w_64364_19964.t4 a_64549_20015# 2.7676787614313858e-17 $ **FLOATING
C1683 w_64364_19964.t16 a_64549_20015# 1.4430073364914267e-17 $ **FLOATING
C1684 w_64364_19964.n63 a_64549_20015# 6.2991430560886195e-17 $ **FLOATING
C1685 w_64364_19964.n64 a_64549_20015# 6.7650518575160633e-17 $ **FLOATING
C1686 w_64364_19964.t12 a_64549_20015# 2.7676787614313858e-17 $ **FLOATING
C1687 w_64364_19964.n65 a_64549_20015# 1.2322343889088916e-16 $ **FLOATING
C1688 w_64364_19964.n66 a_64549_20015# 6.6006635866209113e-17 $ **FLOATING
C1689 w_64364_19964.n67 a_64549_20015# 1.3376588094002276e-16 $ **FLOATING
C1690 w_64364_19964.t17 a_64549_20015# 4.6483101214867736e-16 $ **FLOATING
C1691 w_64364_19964.n68 a_64549_20015# 2.2375975983822869e-16 $ **FLOATING
C1692 w_64364_19964.n69 a_64549_20015# 4.3616045777539584e-17 $ **FLOATING
C1693 w_64364_19964.n70 a_64549_20015# 1.1824508361192225e-16 $ **FLOATING
C1694 w_65333_20000.t1 a_64549_20015# 3.2022585533379905e-17 $ **FLOATING
C1695 w_65333_20000.n0 a_64549_20015# 8.1275862428156839e-17 $ **FLOATING
C1696 w_65333_20000.n1 a_64549_20015# 1.8439509510933693e-16 $ **FLOATING
C1697 w_65333_20000.t5 a_64549_20015# 3.2022585533379905e-17 $ **FLOATING
C1698 w_65333_20000.n2 a_64549_20015# 8.1275862428156839e-17 $ **FLOATING
C1699 w_65333_20000.n3 a_64549_20015# 1.0841913696880353e-16 $ **FLOATING
C1700 w_65333_20000.n4 a_64549_20015# 3.9736068807744972e-16 $ **FLOATING
C1701 w_65333_20000.n5 a_64549_20015# 4.6721229423350085e-17 $ **FLOATING
C1702 w_65333_20000.t2 a_64549_20015# 3.2022585533379905e-17 $ **FLOATING
C1703 w_65333_20000.n6 a_64549_20015# 1.134923719270265e-16 $ **FLOATING
C1704 w_65333_20000.n7 a_64549_20015# 4.0203074764987095e-17 $ **FLOATING
C1705 w_65333_20000.n8 a_64549_20015# 8.7929641029101021e-17 $ **FLOATING
C1706 w_65333_20000.n9 a_64549_20015# 1.0331674246238238e-16 $ **FLOATING
C1707 w_65333_20000.t16 a_64549_20015# 2.7142940373139882e-16 $ **FLOATING
C1708 w_65333_20000.n10 a_64549_20015# 5.8262219255687664e-18 $ **FLOATING
C1709 w_65333_20000.n11 a_64549_20015# 5.0464603589433324e-17 $ **FLOATING
C1710 w_65333_20000.n12 a_64549_20015# 1.8771562149426814e-16 $ **FLOATING
C1711 w_65333_20000.n13 a_64549_20015# 1.0583304057343622e-15 $ **FLOATING
C1712 w_65333_20000.n14 a_64549_20015# 3.3029646617443792e-17 $ **FLOATING
C1713 w_65333_20000.n15 a_64549_20015# 1.7963143506566634e-15 $ **FLOATING
C1714 w_65333_20000.n16 a_64549_20015# 6.2878001785254009e-16 $ **FLOATING
C1715 w_65333_20000.n17 a_64549_20015# 6.5185002699625165e-17 $ **FLOATING
C1716 w_65333_20000.n18 a_64549_20015# 2.626883752099774e-16 $ **FLOATING
C1717 w_65333_20000.n19 a_64549_20015# 1.0332537893767288e-16 $ **FLOATING
C1718 w_65333_20000.n20 a_64549_20015# 1.5403074334931726e-16 $ **FLOATING
C1719 w_65333_20000.n21 a_64549_20015# 9.9676201098598838e-17 $ **FLOATING
C1720 w_65333_20000.n22 a_64549_20015# 1.8523959285660514e-16 $ **FLOATING
C1721 w_65333_20000.n23 a_64549_20015# 3.7836173180608476e-17 $ **FLOATING
C1722 w_65333_20000.n24 a_64549_20015# 1.8523959285660514e-16 $ **FLOATING
C1723 w_65333_20000.n25 a_64549_20015# 3.7836173180608476e-17 $ **FLOATING
C1724 w_65333_20000.n26 a_64549_20015# 1.8523959285660514e-16 $ **FLOATING
C1725 w_65333_20000.n27 a_64549_20015# 3.7836173180608476e-17 $ **FLOATING
C1726 w_65333_20000.n28 a_64549_20015# 1.7919917184798071e-16 $ **FLOATING
C1727 w_65333_20000.n29 a_64549_20015# 3.7836173180608476e-17 $ **FLOATING
C1728 w_65333_20000.n30 a_64549_20015# 1.060976722471393e-16 $ **FLOATING
C1729 w_65333_20000.t8 a_64549_20015# 3.2022581718682341e-17 $ **FLOATING
C1730 w_65333_20000.t11 a_64549_20015# 3.2022574089287201e-17 $ **FLOATING
C1731 w_65333_20000.n31 a_64549_20015# 3.1440532875169705e-16 $ **FLOATING
C1732 w_65333_20000.t13 a_64549_20015# 3.2022581718682341e-17 $ **FLOATING
C1733 w_65333_20000.t10 a_64549_20015# 3.2022574089287201e-17 $ **FLOATING
C1734 w_65333_20000.t22 a_64549_20015# 3.9504144350976912e-16 $ **FLOATING
C1735 w_65333_20000.t21 a_64549_20015# 3.9504144350976912e-16 $ **FLOATING
C1736 w_65333_20000.n32 a_64549_20015# 5.890952613047014e-16 $ **FLOATING
C1737 w_65333_20000.n33 a_64549_20015# 3.9962902932080311e-16 $ **FLOATING
C1738 w_65333_20000.t19 a_64549_20015# 5.3930363140115694e-16 $ **FLOATING
C1739 w_65333_20000.n34 a_64549_20015# 8.5079175411223196e-16 $ **FLOATING
C1740 w_65333_20000.t9 a_64549_20015# 3.2022585533379905e-17 $ **FLOATING
C1741 w_65333_20000.t20 a_64549_20015# 5.3930375347147897e-16 $ **FLOATING
C1742 w_65333_20000.n35 a_64549_20015# 8.507915710067488e-16 $ **FLOATING
C1743 w_65333_20000.t12 a_64549_20015# 3.2022585533379905e-17 $ **FLOATING
C1744 w_65333_20000.n36 a_64549_20015# 6.5066678410507975e-17 $ **FLOATING
C1745 w_65333_20000.n37 a_64549_20015# 3.7836173180608476e-17 $ **FLOATING
C1746 w_65333_20000.n38 a_64549_20015# 8.5152271120113143e-16 $ **FLOATING
C1747 w_65333_20000.t15 a_64549_20015# 4.4924350466936003e-16 $ **FLOATING
C1748 w_65333_20000.n39 a_64549_20015# 7.7637249775462929e-16 $ **FLOATING
C1749 w_65333_20000.t14 a_64549_20015# 3.2022585533379905e-17 $ **FLOATING
C1750 w_65333_20000.n40 a_64549_20015# 1.9298983760847886e-16 $ **FLOATING
C1751 w_65333_20000.n41 a_64549_20015# 3.6234176441712859e-16 $ **FLOATING
C1752 w_65333_20000.n42 a_64549_20015# 9.1231711907205572e-17 $ **FLOATING
C1753 w_65333_20000.n43 a_64549_20015# 4.0723578803841108e-17 $ **FLOATING
C1754 w_65333_20000.n44 a_64549_20015# 2.0717361176790073e-17 $ **FLOATING
C1755 w_65333_20000.n45 a_64549_20015# 9.9359726159088232e-17 $ **FLOATING
C1756 w_65333_20000.n46 a_64549_20015# 2.4578220017056107e-16 $ **FLOATING
C1757 w_65333_20000.t17 a_64549_20015# 3.912903140635332e-16 $ **FLOATING
C1758 w_65333_20000.n47 a_64549_20015# 4.4568782506764051e-17 $ **FLOATING
C1759 w_65333_20000.t4 a_64549_20015# 3.5002444166833837e-17 $ **FLOATING
C1760 w_65333_20000.n48 a_64549_20015# 3.7836173180608476e-17 $ **FLOATING
C1761 w_65333_20000.n49 a_64549_20015# 1.63844409894789e-15 $ **FLOATING
C1762 w_65333_20000.t0 a_64549_20015# 7.3325573410017643e-16 $ **FLOATING
C1763 w_65333_20000.t3 a_64549_20015# 2.2137094031071613e-15 $ **FLOATING
C1764 w_65333_20000.n50 a_64549_20015# 4.1908099618697823e-17 $ **FLOATING
C1765 w_65333_20000.n51 a_64549_20015# 1.7568365338224114e-16 $ **FLOATING
C1766 w_65333_20000.t6 a_64549_20015# 3.2283972425332938e-17 $ **FLOATING
C1767 w_65333_20000.n52 a_64549_20015# 8.6883673844556576e-17 $ **FLOATING
C1768 w_65333_20000.n53 a_64549_20015# 0 $ **FLOATING
C1769 w_65333_20000.t7 a_64549_20015# 3.2283972425332938e-17 $ **FLOATING
C1770 w_65333_20000.t18 a_64549_20015# 9.4807433929939419e-17 $ **FLOATING
C1771 w_65333_20000.n54 a_64549_20015# 1.1317436347909417e-16 $ **FLOATING
C1772 w_65333_20000.n55 a_64549_20015# 1.5677595230606165e-16 $ **FLOATING
C1773 a_20431_108389.t2 a_64549_20015# 2.3170408499917682e-17 $ **FLOATING
C1774 a_20431_108389.t0 a_64549_20015# 2.3170398963174414e-17 $ **FLOATING
C1775 a_20431_108389.n0 a_64549_20015# 2.6561725141271727e-16 $ **FLOATING
C1776 a_20431_108389.n1 a_64549_20015# 4.1891275478242643e-16 $ **FLOATING
C1777 a_20431_108389.t4 a_64549_20015# 7.0534577180151044e-17 $ **FLOATING
C1778 a_20431_108389.n2 a_64549_20015# 7.8524353878036288e-17 $ **FLOATING
C1779 a_20431_108389.t3 a_64549_20015# 2.0479273064269161e-17 $ **FLOATING
C1780 a_20431_108389.t5 a_64549_20015# 7.4306000560852455e-17 $ **FLOATING
C1781 a_20431_108389.n3 a_64549_20015# 7.8524346248641679e-17 $ **FLOATING
C1782 a_20431_108389.t1 a_64549_20015# 2.0479273064269161e-17 $ **FLOATING
C1783 a_20000_108402.t0 a_64549_20015# 6.8766152721894e-18 $ **FLOATING
C1784 a_20000_108402.t6 a_64549_20015# 6.8766152721894e-18 $ **FLOATING
C1785 a_20000_108402.n0 a_64549_20015# 5.7403501313507325e-17 $ **FLOATING
C1786 a_20000_108402.t9 a_64549_20015# 9.7939472422638818e-17 $ **FLOATING
C1787 a_20000_108402.t10 a_64549_20015# 9.7939472422638818e-17 $ **FLOATING
C1788 a_20000_108402.n1 a_64549_20015# 2.6537621097420632e-16 $ **FLOATING
C1789 a_20000_108402.n2 a_64549_20015# 3.1297594830386628e-17 $ **FLOATING
C1790 a_20000_108402.n3 a_64549_20015# 5.7179643442075481e-17 $ **FLOATING
C1791 a_20000_108402.t7 a_64549_20015# 8.6114432038894187e-18 $ **FLOATING
C1792 a_20000_108402.t1 a_64549_20015# 8.6114432038894187e-18 $ **FLOATING
C1793 a_20000_108402.n4 a_64549_20015# 1.2739642629877642e-16 $ **FLOATING
C1794 a_20000_108402.n5 a_64549_20015# 7.9667488992163557e-18 $ **FLOATING
C1795 a_20000_108402.n6 a_64549_20015# 1.0918421345021633e-17 $ **FLOATING
C1796 a_20000_108402.n7 a_64549_20015# 5.2601769426249473e-18 $ **FLOATING
C1797 a_20000_108402.n8 a_64549_20015# 1.0918421345021633e-17 $ **FLOATING
C1798 a_20000_108402.n9 a_64549_20015# 5.2601769426249473e-18 $ **FLOATING
C1799 a_20000_108402.n10 a_64549_20015# 3.3074118355345651e-17 $ **FLOATING
C1800 a_20000_108402.n11 a_64549_20015# 5.2601769426249473e-18 $ **FLOATING
C1801 a_20000_108402.n12 a_64549_20015# 1.0652161207688235e-17 $ **FLOATING
C1802 a_20000_108402.n13 a_64549_20015# 7.7012869872565231e-18 $ **FLOATING
C1803 a_20000_108402.n14 a_64549_20015# 9.3830181496628779e-18 $ **FLOATING
C1804 a_20000_108402.n15 a_64549_20015# 4.2081416494673852e-18 $ **FLOATING
C1805 a_20000_108402.n16 a_64549_20015# 9.3830181496628779e-18 $ **FLOATING
C1806 a_20000_108402.n17 a_64549_20015# 4.2081416494673852e-18 $ **FLOATING
C1807 a_20000_108402.n18 a_64549_20015# 9.3830181496628779e-18 $ **FLOATING
C1808 a_20000_108402.n19 a_64549_20015# 9.1995254958674151e-18 $ **FLOATING
C1809 a_20000_108402.n20 a_64549_20015# 9.0719591629586572e-18 $ **FLOATING
C1810 a_20000_108402.n21 a_64549_20015# 1.0307102893617175e-15 $ **FLOATING
C1811 a_20000_108402.n22 a_64549_20015# 9.1484428866561635e-18 $ **FLOATING
C1812 a_20000_108402.n23 a_64549_20015# 7.4637643748095193e-16 $ **FLOATING
C1813 a_20000_108402.n24 a_64549_20015# 9.1995264495416982e-18 $ **FLOATING
C1814 a_20000_108402.n25 a_64549_20015# 9.3830181496628779e-18 $ **FLOATING
C1815 a_20000_108402.n26 a_64549_20015# 9.3830181496628779e-18 $ **FLOATING
C1816 a_20000_108402.n27 a_64549_20015# 0 $ **FLOATING
C1817 a_20000_108402.n28 a_64549_20015# 9.3830181496628779e-18 $ **FLOATING
C1818 a_20000_108402.n29 a_64549_20015# 7.8902656523559894e-18 $ **FLOATING
C1819 a_20000_108402.n30 a_64549_20015# 7.7012869872565231e-18 $ **FLOATING
C1820 a_20000_108402.n31 a_64549_20015# 4.2081416494673852e-18 $ **FLOATING
C1821 a_20000_108402.n32 a_64549_20015# 1.2739642629877642e-16 $ **FLOATING
C1822 a_20000_108402.n33 a_64549_20015# 1.0918421345021633e-17 $ **FLOATING
C1823 a_20000_108402.n34 a_64549_20015# 5.2601769426249473e-18 $ **FLOATING
C1824 a_20000_108402.n35 a_64549_20015# 1.0918421345021633e-17 $ **FLOATING
C1825 a_20000_108402.n36 a_64549_20015# 5.2601769426249473e-18 $ **FLOATING
C1826 a_20000_108402.n37 a_64549_20015# 3.3074118355345651e-17 $ **FLOATING
C1827 a_20000_108402.n38 a_64549_20015# 5.2601769426249473e-18 $ **FLOATING
C1828 a_20000_108402.n39 a_64549_20015# 1.0652161207688235e-17 $ **FLOATING
C1829 a_20000_108402.n40 a_64549_20015# 2.6537624149178332e-16 $ **FLOATING
C1830 a_20000_108402.n41 a_64549_20015# 3.1297594830386628e-17 $ **FLOATING
C1831 a_20000_108402.t2 a_64549_20015# 6.8766152721894e-18 $ **FLOATING
C1832 a_20000_108402.n42 a_64549_20015# 6.3359696926446945e-17 $ **FLOATING
C1833 a_20000_108402.t4 a_64549_20015# 6.8766152721894e-18 $ **FLOATING
C1834 a_20000_108402.n43 a_64549_20015# 5.7403501313507325e-17 $ **FLOATING
C1835 a_20000_108402.t8 a_64549_20015# 9.7939472422638818e-17 $ **FLOATING
C1836 a_20000_108402.n44 a_64549_20015# 5.7179643442075481e-17 $ **FLOATING
C1837 a_20000_108402.t3 a_64549_20015# 8.6114432038894187e-18 $ **FLOATING
C1838 a_20000_108402.t5 a_64549_20015# 8.6114432038894187e-18 $ **FLOATING
C1839 a_20000_108402.n45 a_64549_20015# 4.2081416494673852e-18 $ **FLOATING
C1840 a_20000_108402.n46 a_64549_20015# 5.7403501313507325e-17 $ **FLOATING
C1841 a_21763_108389.t0 a_64549_20015# 6.7038157134764828e-18 $ **FLOATING
C1842 a_21763_108389.t2 a_64549_20015# 3.5273652455692019e-17 $ **FLOATING
C1843 a_21763_108389.n0 a_64549_20015# 3.7469889721283462e-16 $ **FLOATING
C1844 a_21763_108389.n1 a_64549_20015# 6.4585250242777128e-16 $ **FLOATING
C1845 a_21763_108389.t4 a_64549_20015# 1.073789103067952e-16 $ **FLOATING
C1846 a_21763_108389.n2 a_64549_20015# 1.195422103268738e-16 $ **FLOATING
C1847 a_21763_108389.t3 a_64549_20015# 3.1176793322640441e-17 $ **FLOATING
C1848 a_21763_108389.t1 a_64549_20015# 6.9518530611042156e-18 $ **FLOATING
.ends
