* NGSPICE file created from RotatedCrop.ext - technology: sky130A

.subckt RotatedCrop
* OPENPLL_ORIGIN X0 sky130_fd_pr__pfet_01v8_hvt 65395 22591 65396 22592
X0 w_65333_20000# a_64549_20015# w_65333_20000# w_65333_20000# sky130_fd_pr__pfet_01v8_hvt ad=0.2262 pd=2.26 as=0 ps=0 w=0.87 l=3.11
* OPENPLL_ORIGIN X1 sky130_fd_pr__nfet_01v8 64915 21119 64916 21120
X1 a_64549_20015# w_64364_19964# a_64549_20015# a_64549_20015# sky130_fd_pr__nfet_01v8 ad=0.143 pd=1.62 as=0 ps=0 w=0.55 l=4.73
* OPENPLL_ORIGIN X2 sky130_fd_pr__nfet_01v8 64915 20015 64916 20016
X2 a_64549_20015# w_64364_19964# a_64549_20015# a_64549_20015# sky130_fd_pr__nfet_01v8 ad=0.143 pd=1.62 as=0 ps=0 w=0.55 l=4.73
* OPENPLL_ORIGIN X3 sky130_fd_pr__pfet_01v8_hvt 65395 20000 65396 20001
X3 w_65333_20000# a_64549_20015# w_65333_20000# w_65333_20000# sky130_fd_pr__pfet_01v8_hvt ad=0.2262 pd=2.26 as=0 ps=0 w=0.87 l=2.53
* OPENPLL_ORIGIN X4 sky130_fd_pr__pfet_01v8_hvt 64575 22223 64576 22224
X4 w_64364_19964# a_64549_20015# w_64364_19964# w_64364_19964# sky130_fd_pr__pfet_01v8_hvt ad=0.2262 pd=2.26 as=0 ps=0 w=0.87 l=4.73
* OPENPLL_ORIGIN X5 sky130_fd_pr__nfet_01v8 65119 22591 65120 22592
X5 a_64549_20015# w_65333_20000# a_64549_20015# a_64549_20015# sky130_fd_pr__nfet_01v8 ad=0.143 pd=1.62 as=0 ps=0 w=0.55 l=3.27
* OPENPLL_ORIGIN X6 sky130_fd_pr__pfet_01v8_hvt 65395 22039 65396 22040
X6 w_65333_20000# a_64549_20015# w_65333_20000# w_65333_20000# sky130_fd_pr__pfet_01v8_hvt ad=0.2262 pd=2.26 as=0 ps=0 w=0.87 l=1.97
* OPENPLL_ORIGIN X7 sky130_fd_pr__nfet_01v8 65119 20000 65120 20001
X7 a_64549_20015# w_65333_20000# a_64549_20015# a_64549_20015# sky130_fd_pr__nfet_01v8 ad=0.143 pd=1.62 as=0 ps=0 w=0.55 l=2.69
* OPENPLL_ORIGIN X8 sky130_fd_pr__pfet_01v8_hvt 65663 20000 65664 20001
X8 w_65333_20000# a_64549_20015# w_65333_20000# w_65333_20000# sky130_fd_pr__pfet_01v8_hvt ad=0.2262 pd=2.26 as=0 ps=0 w=0.87 l=2.53
* OPENPLL_ORIGIN X9 sky130_fd_pr__nfet_01v8_lvt 21547 108389 21548 108390
X9 a_20000_108402# a_20431_108389# a_20000_108402# a_64549_20015# sky130_fd_pr__nfet_01v8_lvt ad=0.1113 pd=1.37 as=0 ps=0 w=0.42 l=1
* OPENPLL_ORIGIN X10 sky130_fd_pr__nfet_01v8 65119 22039 65120 22040
X10 a_64549_20015# w_65333_20000# a_64549_20015# a_64549_20015# sky130_fd_pr__nfet_01v8 ad=0.143 pd=1.62 as=0 ps=0 w=0.55 l=1.97
* OPENPLL_ORIGIN X11 sky130_fd_pr__pfet_01v8 22456 108402 22457 108403
X11 a_21763_108389# a_22430_108402# a_21763_108389# w_22048_107200# sky130_fd_pr__pfet_01v8 ad=0.0605 pd=0.99 as=0 ps=0 w=0.22 l=1
* OPENPLL_ORIGIN X12 sky130_fd_pr__pfet_01v8 22108 108402 22109 108403
X12 a_21763_108389# a_20000_108402# a_21763_108389# w_22048_107200# sky130_fd_pr__pfet_01v8 ad=0.275 pd=2.55 as=0 ps=0 w=1 l=1
* OPENPLL_ORIGIN X13 sky130_fd_pr__nfet_01v8 66003 20000 66004 20001
X13 a_64549_20015# w_65333_20000# a_64549_20015# a_64549_20015# sky130_fd_pr__nfet_01v8 ad=0.143 pd=1.62 as=0 ps=0 w=0.55 l=2.69
* OPENPLL_ORIGIN X14 sky130_fd_pr__nfet_01v8_lvt 20469 108389 20470 108390
X14 a_20000_108402# a_20431_108389# a_20000_108402# a_64549_20015# sky130_fd_pr__nfet_01v8_lvt ad=0.1113 pd=1.37 as=0 ps=0 w=0.42 l=1
* OPENPLL_ORIGIN X15 sky130_fd_pr__pfet_01v8_hvt 64400 20751 64401 20752
X15 w_64364_19964# a_64400_20751# w_64364_19964# w_64364_19964# sky130_fd_pr__pfet_01v8_hvt ad=0.1053 pd=1.33 as=0 ps=0 w=0.405 l=4.73
* OPENPLL_ORIGIN X16 sky130_fd_pr__nfet_01v8 64915 22223 64916 22224
X16 a_64549_20015# w_64364_19964# a_64549_20015# a_64549_20015# sky130_fd_pr__nfet_01v8 ad=0.143 pd=1.62 as=0 ps=0 w=0.55 l=4.73
* OPENPLL_ORIGIN X17 sky130_fd_pr__pfet_01v8_hvt 65663 21947 65664 21948
X17 w_65333_20000# a_64549_20015# w_65333_20000# w_65333_20000# sky130_fd_pr__pfet_01v8_hvt ad=0.2262 pd=2.26 as=0 ps=0 w=0.87 l=0.59
* OPENPLL_ORIGIN X18 sky130_fd_pr__pfet_01v8 20776 108402 20777 108403
X18 a_20431_108389# a_20000_108402# a_20431_108389# w_20716_107200# sky130_fd_pr__pfet_01v8 ad=0.275 pd=2.55 as=0 ps=0 w=1 l=1
* OPENPLL_ORIGIN X19 sky130_fd_pr__nfet_01v8 66003 21947 66004 21948
X19 a_64549_20015# w_65333_20000# a_64549_20015# a_64549_20015# sky130_fd_pr__nfet_01v8 ad=0.143 pd=1.62 as=0 ps=0 w=0.55 l=0.59
* OPENPLL_ORIGIN X20 sky130_fd_pr__pfet_01v8_hvt 64400 22591 64401 22592
X20 w_64364_19964# a_64400_22591# w_64364_19964# w_64364_19964# sky130_fd_pr__pfet_01v8_hvt ad=0.1053 pd=1.33 as=0 ps=0 w=0.405 l=1.57
* OPENPLL_ORIGIN X21 sky130_fd_pr__pfet_01v8_hvt 64400 20000 64401 20001
X21 w_64364_19964# a_64400_20000# w_64364_19964# w_64364_19964# sky130_fd_pr__pfet_01v8_hvt ad=0.1053 pd=1.33 as=0 ps=0 w=0.405 l=1.28
* OPENPLL_ORIGIN X22 sky130_fd_pr__pfet_01v8_hvt 65395 20751 65396 20752
X22 w_65333_20000# a_64549_20015# w_65333_20000# w_65333_20000# sky130_fd_pr__pfet_01v8_hvt ad=0.2262 pd=2.26 as=0 ps=0 w=0.87 l=4.73
* OPENPLL_ORIGIN X23 sky130_fd_pr__pfet_01v8_hvt 64400 22039 64401 22040
X23 w_64364_19964# a_64400_22039# w_64364_19964# w_64364_19964# sky130_fd_pr__pfet_01v8_hvt ad=0.1053 pd=1.33 as=0 ps=0 w=0.405 l=1.97
* OPENPLL_ORIGIN X24 sky130_fd_pr__pfet_01v8_hvt 64575 20015 64576 20016
X24 w_64364_19964# a_64549_20015# w_64364_19964# w_64364_19964# sky130_fd_pr__pfet_01v8_hvt ad=0.2262 pd=2.26 as=0 ps=0 w=0.87 l=4.73
* OPENPLL_ORIGIN X25 sky130_fd_pr__nfet_01v8 65119 20751 65120 20752
X25 a_64549_20015# w_65333_20000# a_64549_20015# a_64549_20015# sky130_fd_pr__nfet_01v8 ad=0.143 pd=1.62 as=0 ps=0 w=0.55 l=4.73
* OPENPLL_ORIGIN X26 sky130_fd_pr__pfet_01v8_hvt 65663 20751 65664 20752
X26 w_65333_20000# a_64549_20015# w_65333_20000# w_65333_20000# sky130_fd_pr__pfet_01v8_hvt ad=0.2262 pd=2.26 as=0 ps=0 w=0.87 l=4.73
* OPENPLL_ORIGIN X27 sky130_fd_pr__nfet_01v8_lvt 20215 108389 20216 108390
X27 a_20000_108402# a_20068_108389# a_20000_108402# a_64549_20015# sky130_fd_pr__nfet_01v8_lvt ad=0.1113 pd=1.37 as=0 ps=0 w=0.42 l=1
* OPENPLL_ORIGIN X28 sky130_fd_pr__pfet_01v8_hvt 64575 21119 64576 21120
X28 w_64364_19964# a_64549_20015# w_64364_19964# w_64364_19964# sky130_fd_pr__pfet_01v8_hvt ad=0.2262 pd=2.26 as=0 ps=0 w=0.87 l=4.73
* OPENPLL_ORIGIN X29 sky130_fd_pr__pfet_01v8 21124 108402 21125 108403
X29 a_20431_108389# a_20000_108402# a_20431_108389# w_20716_107200# sky130_fd_pr__pfet_01v8 ad=0.275 pd=2.55 as=0 ps=0 w=1 l=1
* OPENPLL_ORIGIN X30 sky130_fd_pr__pfet_01v8_hvt 65663 22223 65664 22224
X30 w_65333_20000# a_64549_20015# w_65333_20000# w_65333_20000# sky130_fd_pr__pfet_01v8_hvt ad=0.2262 pd=2.26 as=0 ps=0 w=0.87 l=4.73
* OPENPLL_ORIGIN X31 sky130_fd_pr__nfet_01v8 66003 20751 66004 20752
X31 a_64549_20015# w_65333_20000# a_64549_20015# a_64549_20015# sky130_fd_pr__nfet_01v8 ad=0.143 pd=1.62 as=0 ps=0 w=0.55 l=4.73
* OPENPLL_ORIGIN X32 sky130_fd_pr__nfet_01v8_lvt 21801 108389 21802 108390
X32 a_20000_108402# a_21763_108389# a_20000_108402# a_64549_20015# sky130_fd_pr__nfet_01v8_lvt ad=0.1113 pd=1.37 as=0 ps=0 w=0.42 l=1
* OPENPLL_ORIGIN X33 sky130_fd_pr__nfet_01v8 66003 22223 66004 22224
X33 a_64549_20015# w_65333_20000# a_64549_20015# a_64549_20015# sky130_fd_pr__nfet_01v8 ad=0.143 pd=1.62 as=0 ps=0 w=0.55 l=4.73
C0 a_21763_108389# m4_20000_107214# 4.5276800000000007e-18
C1 w_64364_19964# a_64400_20751# 4.4880300000000007e-16
C2 m5_20864_107200# m4_20000_107214# 1.6045500000000004e-16
C3 w_20716_107200# m2_20000_107326# 5.2978499999999999e-17
C4 a_20068_108389# m1_21172_107500# 1.6522900000000002e-19
C5 m3_21536_107398# a_21763_108389# 1.61041e-18
C6 a_21763_108389# m2_20000_107998# 7.6047300000000016e-17
C7 w_22048_107200# m1_21172_107500# 3.8351200000000004e-19
C8 a_20431_108389# m2_20000_107326# 7.4594999999999995e-17
C9 a_22430_108402# m4_20000_107598# 1.0612000000000001e-20
C10 m3_21536_107398# m5_20864_107200# 1.7783400000000002e-16
C11 m1_20222_107200# m2_20000_108190# 2.4562000000000002e-17
C12 m5_20864_107200# m2_20000_107998# 8.0638400000000022e-18
C13 m5_20864_107200# a_20068_108389# 3.5281500000000001e-19
C14 a_21763_108389# w_22048_107200# 5.3274900000000011e-16
C15 m5_20864_107200# w_22048_107200# 4.8700000000000003e-18
C16 m1_20222_107200# m4_20000_107214# 1.4477500000000001e-18
C17 m3_21536_107398# m1_20222_107200# 1.5272800000000001e-18
C18 w_20716_107200# m4_20000_107982# 1.1378399999999999e-17
C19 m1_20222_107200# m2_20000_107998# 2.3884200000000004e-17
C20 w_20716_107200# m1_20136_108556# 8.5384699999999998e-20
C21 a_20431_108389# m4_20000_107982# 1.6397200000000001e-17
C22 m2_20000_107326# m4_20000_107598# 1.5639100000000002e-17
C23 a_22430_108402# m2_20000_108190# 2.0855700000000003e-18
C24 a_20431_108389# m1_20136_108556# 4.434400000000001e-19
C25 m2_20000_107326# w_20000_107200# 3.5987800000000002e-18
C26 a_20068_108389# m1_20222_107200# 1.7539699999999999e-17
C27 a_20000_108402# m1_21172_107500# 1.08716e-16
C28 a_22430_108402# m4_20000_107214# 9.3524300000000013e-22
C29 a_20000_108402# a_21763_108389# 6.3810599999999996e-16
C30 a_20000_108402# m5_20864_107200# 7.4302000000000009e-16
C31 a_22430_108402# m2_20000_107998# 3.1880400000000006e-20
C32 a_64400_20000# w_65333_20000# 4.0955600000000003e-19
C33 m4_20000_107598# m4_20000_107982# 5.3652999999999996e-16
C34 w_65333_20000# a_64400_22591# 3.5767900000000004e-18
C35 m1_20136_108556# m4_20000_107598# 1.6285e-18
C36 w_20000_107200# m4_20000_107982# 2.5581000000000003e-18
C37 a_21763_108389# m1_21172_107500# 6.1075300000000006e-20
C38 m5_20864_107200# m1_21172_107500# 1.1621500000000001e-17
C39 m1_20136_108556# w_20000_107200# 1.4178000000000003e-17
C40 a_22430_108402# w_22048_107200# 5.2726700000000005e-17
C41 m2_20000_107326# m4_20000_107214# 2.5023100000000001e-17
C42 a_20000_108402# m1_20222_107200# 8.5240000000000001e-16
C43 a_21763_108389# m5_20864_107200# 5.1755800000000002e-18
C44 m3_21536_107398# m2_20000_107326# 5.1122700000000006e-17
C45 m2_20000_107326# m2_20000_107998# 1.3387800000000001e-16
C46 m2_20000_108190# m4_20000_107982# 1.4945500000000001e-17
C47 m1_20222_107200# m1_21172_107500# 2.3896500000000002e-17
C48 m1_20136_108556# m2_20000_108190# 4.8298300000000001e-17
C49 w_64364_19964# a_64400_20000# 2.63403e-16
C50 a_20068_108389# m2_20000_107326# 1.10534e-19
C51 w_64364_19964# a_64400_22591# 3.3554199999999996e-16
C52 w_22048_107200# m2_20000_107326# 3.1349100000000002e-17
C53 w_20716_107200# a_20431_108389# 7.2327600000000002e-16
C54 a_64400_22039# a_64400_20751# 1.2163700000000001e-18
C55 m5_20864_107200# m1_20222_107200# 2.3707300000000004e-18
C56 a_20000_108402# a_22430_108402# 3.35961e-17
C57 w_64364_19964# w_65333_20000# 8.8069700000000004e-16
C58 m1_20136_108556# m4_20000_107214# 1.7991299999999999e-18
C59 m3_21536_107398# m4_20000_107982# 2.0485600000000002e-19
C60 m2_20000_107998# m4_20000_107982# 2.66712e-17
C61 m3_21536_107398# m1_20136_108556# 1.6020600000000002e-18
C62 m1_20136_108556# m2_20000_107998# 2.49988e-17
C63 a_20068_108389# m4_20000_107982# 1.9722600000000002e-18
C64 w_22048_107200# m4_20000_107982# 8.1896100000000012e-18
C65 m1_20136_108556# a_20068_108389# 4.1616900000000002e-17
C66 w_20716_107200# m4_20000_107598# 9.0080500000000004e-18
C67 a_21763_108389# a_22430_108402# 5.9348399999999998e-17
C68 a_20431_108389# m4_20000_107598# 8.8562999999999996e-18
C69 m5_20864_107200# a_22430_108402# -1.0281100000000001e-34
C70 a_20000_108402# m2_20000_107326# 1.5127600000000004e-16
C71 m1_21172_107500# m2_20000_107326# 1.6445500000000003e-16
C72 w_20716_107200# m2_20000_108190# 3.0487600000000004e-17
C73 a_21763_108389# m2_20000_107326# 7.3327300000000006e-17
C74 a_20000_108402# m4_20000_107982# 2.27618e-16
C75 a_20431_108389# m2_20000_108190# 1.1764e-16
C76 m5_20864_107200# m2_20000_107326# 1.2434900000000002e-17
C77 a_20000_108402# m1_20136_108556# 7.302050000000001e-17
C78 w_20000_107200# m4_20000_107598# 1.08472e-18
C79 w_20716_107200# m4_20000_107214# 8.2920700000000015e-18
C80 m1_21172_107500# m4_20000_107982# 4.7e-19
C81 a_20431_108389# m4_20000_107214# 7.7190600000000003e-18
C82 m1_20136_108556# m1_21172_107500# 2.4991099999999999e-17
C83 m3_21536_107398# w_20716_107200# 1.6701200000000002e-17
C84 w_20716_107200# m2_20000_107998# 4.7071100000000005e-17
C85 m3_21536_107398# a_20431_108389# 1.24753e-17
C86 m1_20222_107200# m2_20000_107326# 2.3529000000000002e-17
C87 a_20431_108389# m2_20000_107998# 7.9094400000000003e-17
C88 a_21763_108389# m4_20000_107982# 1.6507000000000003e-17
C89 m5_20864_107200# m4_20000_107982# 2.4036099999999999e-16
C90 m1_20136_108556# m5_20864_107200# 1.4143500000000001e-18
C91 w_20000_107200# m2_20000_108190# 3.3428399999999998e-18
C92 a_20431_108389# a_20068_108389# 3.4042600000000001e-17
C93 a_64400_22039# a_64400_22591# 2.6329100000000002e-18
C94 m4_20000_107214# m4_20000_107598# 3.6473300000000006e-16
C95 w_20000_107200# m4_20000_107214# 9.3597800000000002e-19
C96 a_64400_22039# w_65333_20000# 4.3139900000000006e-18
C97 m1_20222_107200# m4_20000_107982# 3.8046000000000005e-18
C98 a_22430_108402# m2_20000_107326# 7.8486300000000013e-21
C99 m3_21536_107398# m4_20000_107598# 6.140160000000001e-16
C100 m2_20000_107998# m4_20000_107598# 1.0179600000000001e-17
C101 m1_20136_108556# m1_20222_107200# 6.5872900000000004e-16
C102 m3_21536_107398# w_20000_107200# 8.4649000000000005e-19
C103 m2_20000_107998# w_20000_107200# 2.9277600000000006e-18
C104 a_20068_108389# m4_20000_107598# 1.2061800000000001e-19
C105 w_22048_107200# m4_20000_107598# 6.5861000000000007e-18
C106 a_20068_108389# w_20000_107200# 2.2428400000000003e-17
C107 w_20716_107200# a_20000_108402# 4.0230400000000002e-16
C108 a_20000_108402# a_20431_108389# 1.2376300000000002e-15
C109 a_22430_108402# m4_20000_107982# 2.8074700000000005e-19
C110 w_20716_107200# m1_21172_107500# 8.1488200000000022e-17
C111 m3_21536_107398# m2_20000_108190# 8.4636000000000015e-20
C112 m2_20000_107998# m2_20000_108190# 5.5803600000000002e-16
C113 a_20431_108389# m1_21172_107500# 2.0253100000000003e-16
C114 w_64364_19964# a_64400_22039# 2.1416300000000004e-16
C115 a_20068_108389# m2_20000_108190# 1.1578200000000001e-17
C116 m3_21536_107398# m4_20000_107214# 3.5329800000000001e-16
C117 w_22048_107200# m2_20000_108190# 1.8931300000000003e-17
C118 w_20716_107200# m5_20864_107200# 2.0536599999999999e-17
C119 a_20431_108389# a_21763_108389# 4.1809300000000004e-17
C120 a_20431_108389# m5_20864_107200# 2.8862400000000001e-17
C121 a_20000_108402# m4_20000_107598# 1.6941400000000004e-17
C122 m3_21536_107398# m2_20000_107998# 1.5491500000000002e-18
C123 a_20000_108402# w_20000_107200# 6.0162100000000004e-17
C124 a_20068_108389# m4_20000_107214# 1.0530900000000002e-19
C125 m2_20000_107326# m4_20000_107982# 1.1895700000000002e-18
C126 w_22048_107200# m4_20000_107214# 4.0374999999999995e-18
C127 m1_20136_108556# m2_20000_107326# 2.4623200000000003e-17
C128 m1_21172_107500# m4_20000_107598# 1.4423900000000002e-17
C129 m3_21536_107398# a_20068_108389# 9.1782600000000015e-20
C130 a_20068_108389# m2_20000_107998# 5.5591599999999995e-19
C131 m3_21536_107398# w_22048_107200# 4.9466100000000001e-18
C132 w_22048_107200# m2_20000_107998# 3.3636200000000009e-17
C133 m1_21172_107500# w_20000_107200# 3.2119600000000002e-18
C134 a_20431_108389# m1_20222_107200# 1.1850400000000001e-17
C135 a_64400_20000# a_64400_20751# 2.6329100000000002e-18
C136 a_21763_108389# m4_20000_107598# 9.049500000000001e-18
C137 m5_20864_107200# m4_20000_107598# 1.98648e-16
C138 a_20000_108402# m2_20000_108190# 2.3021e-16
C139 m5_20864_107200# w_20000_107200# 1.5137900000000001e-18
C140 a_64400_20751# w_65333_20000# 4.3139900000000006e-18
C141 m1_20136_108556# m4_20000_107982# 2.9948400000000002e-18
C142 m1_21172_107500# m2_20000_108190# 4.0203900000000004e-20
C143 a_20000_108402# m4_20000_107214# 1.7684100000000003e-17
C144 m1_20222_107200# m4_20000_107598# 2.5642200000000004e-18
C145 m3_21536_107398# a_20000_108402# 2.8119599999999999e-17
C146 a_20000_108402# m2_20000_107998# 1.5544400000000001e-16
C147 m1_20222_107200# w_20000_107200# 1.4063000000000002e-18
C148 a_21763_108389# m2_20000_108190# 1.01416e-16
C149 m1_21172_107500# m4_20000_107214# 8.8940900000000013e-18
C150 m5_20864_107200# m2_20000_108190# 1.3326700000000002e-17
C151 a_20000_108402# a_20068_108389# 2.1590700000000004e-16
C152 m3_21536_107398# m1_21172_107500# 1.9391000000000001e-17
C153 m1_21172_107500# m2_20000_107998# 1.2037300000000002e-16
C154 a_20000_108402# w_22048_107200# 2.0189100000000001e-16
C155 m5_66900_20000# a_64549_20015# 0 $ **FLOATING
C156 m5_64900_20000# a_64549_20015# 0 $ **FLOATING
C157 m5_64400_20000# a_64549_20015# 0 $ **FLOATING
C158 m5_66900_20600# a_64549_20015# 0 $ **FLOATING
C159 m5_64900_20600# a_64549_20015# 0 $ **FLOATING
C160 m5_64400_20600# a_64549_20015# 0 $ **FLOATING
C161 m5_66900_22600# a_64549_20015# 0 $ **FLOATING
C162 m5_64900_22600# a_64549_20015# 0 $ **FLOATING
C163 m5_64400_22600# a_64549_20015# 0 $ **FLOATING
C164 m5_21584_107200# a_64549_20015# 0 $ **FLOATING
C165 m5_21584_108600# a_64549_20015# 0 $ **FLOATING
C166 m5_20864_107200# a_64549_20015# 8.8871e-16
C167 m5_20000_107200# a_64549_20015# 0 $ **FLOATING
C168 m5_20000_108600# a_64549_20015# 0 $ **FLOATING
C169 m4_67310_20000# a_64549_20015# 0 $ **FLOATING
C170 m4_66750_20000# a_64549_20015# 0 $ **FLOATING
C171 m4_67310_20290# a_64549_20015# 0 $ **FLOATING
C172 m4_66190_20010# a_64549_20015# 0 $ **FLOATING
C173 m4_65070_20000# a_64549_20015# 0 $ **FLOATING
C174 m4_66750_20430# a_64549_20015# 0 $ **FLOATING
C175 m4_65630_20150# a_64549_20015# 0 $ **FLOATING
C176 m4_64510_20000# a_64549_20015# 0 $ **FLOATING
C177 m4_67310_20850# a_64549_20015# 0 $ **FLOATING
C178 m4_66190_20570# a_64549_20015# 0 $ **FLOATING
C179 m4_65070_20290# a_64549_20015# 0 $ **FLOATING
C180 m4_66750_20990# a_64549_20015# 0 $ **FLOATING
C181 m4_65630_20710# a_64549_20015# 0 $ **FLOATING
C182 m4_64510_20430# a_64549_20015# 0 $ **FLOATING
C183 m4_67310_21410# a_64549_20015# 0 $ **FLOATING
C184 m4_66190_21130# a_64549_20015# 0 $ **FLOATING
C185 m4_65070_20850# a_64549_20015# 0 $ **FLOATING
C186 m4_66750_21550# a_64549_20015# 0 $ **FLOATING
C187 m4_65630_21270# a_64549_20015# 0 $ **FLOATING
C188 m4_64510_20990# a_64549_20015# 0 $ **FLOATING
C189 m4_67310_21970# a_64549_20015# 0 $ **FLOATING
C190 m4_66190_21690# a_64549_20015# 0 $ **FLOATING
C191 m4_65070_21410# a_64549_20015# 0 $ **FLOATING
C192 m4_66750_22110# a_64549_20015# 0 $ **FLOATING
C193 m4_65630_21830# a_64549_20015# 0 $ **FLOATING
C194 m4_64510_21550# a_64549_20015# 0 $ **FLOATING
C195 m4_67310_22530# a_64549_20015# 0 $ **FLOATING
C196 m4_66190_22250# a_64549_20015# 0 $ **FLOATING
C197 m4_65070_21970# a_64549_20015# 0 $ **FLOATING
C198 m4_66750_22670# a_64549_20015# 0 $ **FLOATING
C199 m4_65630_22390# a_64549_20015# 0 $ **FLOATING
C200 m4_64510_22110# a_64549_20015# 0 $ **FLOATING
C201 m4_67310_23090# a_64549_20015# 0 $ **FLOATING
C202 m4_66190_22810# a_64549_20015# 0 $ **FLOATING
C203 m4_65070_22530# a_64549_20015# 0 $ **FLOATING
C204 m4_66750_23230# a_64549_20015# 0 $ **FLOATING
C205 m4_65630_22950# a_64549_20015# 0 $ **FLOATING
C206 m4_64510_22670# a_64549_20015# 0 $ **FLOATING
C207 m4_65070_23090# a_64549_20015# 0 $ **FLOATING
C208 m4_64510_23230# a_64549_20015# 0 $ **FLOATING
C209 m4_20000_107214# a_64549_20015# 5.3096900000000011e-16
C210 m4_22056_107380# a_64549_20015# 0 $ **FLOATING
C211 m4_21770_107380# a_64549_20015# 0 $ **FLOATING
C212 m4_20000_107598# a_64549_20015# 1.1617500000000001e-16
C213 m4_22410_107740# a_64549_20015# 0 $ **FLOATING
C214 m4_22250_107770# a_64549_20015# 0 $ **FLOATING
C215 m4_22090_107800# a_64549_20015# 0 $ **FLOATING
C216 m4_21352_107764# a_64549_20015# 0 $ **FLOATING
C217 m4_20650_107750# a_64549_20015# 0 $ **FLOATING
C218 m4_20472_107760# a_64549_20015# 0 $ **FLOATING
C219 m4_20000_107982# a_64549_20015# 2.46726e-16
C220 m4_22408_108156# a_64549_20015# 0 $ **FLOATING
C221 m4_22408_108332# a_64549_20015# 0 $ **FLOATING
C222 m4_22232_108296# a_64549_20015# 0 $ **FLOATING
C223 m4_22056_108260# a_64549_20015# 0 $ **FLOATING
C224 m4_21880_108224# a_64549_20015# 0 $ **FLOATING
C225 m4_21704_108188# a_64549_20015# 0 $ **FLOATING
C226 m4_21528_108152# a_64549_20015# 0 $ **FLOATING
C227 m4_22408_108508# a_64549_20015# 0 $ **FLOATING
C228 m4_22232_108472# a_64549_20015# 0 $ **FLOATING
C229 m4_22056_108436# a_64549_20015# 0 $ **FLOATING
C230 m4_21880_108400# a_64549_20015# 0 $ **FLOATING
C231 m4_21704_108364# a_64549_20015# 0 $ **FLOATING
C232 m4_21528_108328# a_64549_20015# 0 $ **FLOATING
C233 m4_21352_108292# a_64549_20015# 0 $ **FLOATING
C234 m4_21176_108256# a_64549_20015# 0 $ **FLOATING
C235 m4_21000_108220# a_64549_20015# 0 $ **FLOATING
C236 m4_20824_108184# a_64549_20015# 0 $ **FLOATING
C237 m4_20648_108148# a_64549_20015# 0 $ **FLOATING
C238 m4_22408_108684# a_64549_20015# 0 $ **FLOATING
C239 m4_22232_108648# a_64549_20015# 0 $ **FLOATING
C240 m4_22056_108612# a_64549_20015# 0 $ **FLOATING
C241 m4_21880_108576# a_64549_20015# 0 $ **FLOATING
C242 m4_21704_108540# a_64549_20015# 0 $ **FLOATING
C243 m4_21528_108504# a_64549_20015# 0 $ **FLOATING
C244 m4_21352_108468# a_64549_20015# 0 $ **FLOATING
C245 m4_21176_108432# a_64549_20015# 0 $ **FLOATING
C246 m4_21000_108396# a_64549_20015# 0 $ **FLOATING
C247 m4_20824_108360# a_64549_20015# 0 $ **FLOATING
C248 m4_20648_108324# a_64549_20015# 0 $ **FLOATING
C249 m4_20472_108288# a_64549_20015# 0 $ **FLOATING
C250 m4_20296_108252# a_64549_20015# 0 $ **FLOATING
C251 m4_20120_108216# a_64549_20015# 0 $ **FLOATING
C252 m4_20000_108180# a_64549_20015# 0 $ **FLOATING
C253 m4_22408_108860# a_64549_20015# 0 $ **FLOATING
C254 m4_22232_108824# a_64549_20015# 0 $ **FLOATING
C255 m4_22056_108788# a_64549_20015# 0 $ **FLOATING
C256 m4_21880_108752# a_64549_20015# 0 $ **FLOATING
C257 m4_21704_108716# a_64549_20015# 0 $ **FLOATING
C258 m4_21528_108680# a_64549_20015# 0 $ **FLOATING
C259 m4_21352_108644# a_64549_20015# 0 $ **FLOATING
C260 m4_21176_108608# a_64549_20015# 0 $ **FLOATING
C261 m4_21000_108572# a_64549_20015# 0 $ **FLOATING
C262 m4_20824_108536# a_64549_20015# 0 $ **FLOATING
C263 m4_20648_108500# a_64549_20015# 0 $ **FLOATING
C264 m4_20472_108464# a_64549_20015# 0 $ **FLOATING
C265 m4_20296_108428# a_64549_20015# 0 $ **FLOATING
C266 m4_20120_108392# a_64549_20015# 0 $ **FLOATING
C267 m4_20000_108356# a_64549_20015# 0 $ **FLOATING
C268 m4_21528_108856# a_64549_20015# 0 $ **FLOATING
C269 m4_21352_108820# a_64549_20015# 0 $ **FLOATING
C270 m4_21176_108784# a_64549_20015# 0 $ **FLOATING
C271 m4_21000_108748# a_64549_20015# 0 $ **FLOATING
C272 m4_20824_108712# a_64549_20015# 0 $ **FLOATING
C273 m4_20648_108676# a_64549_20015# 0 $ **FLOATING
C274 m4_20472_108640# a_64549_20015# 0 $ **FLOATING
C275 m4_20296_108604# a_64549_20015# 0 $ **FLOATING
C276 m4_20120_108568# a_64549_20015# 0 $ **FLOATING
C277 m4_20000_108532# a_64549_20015# 0 $ **FLOATING
C278 m4_20648_108852# a_64549_20015# 0 $ **FLOATING
C279 m4_20472_108816# a_64549_20015# 0 $ **FLOATING
C280 m4_20296_108780# a_64549_20015# 0 $ **FLOATING
C281 m4_20120_108744# a_64549_20015# 0 $ **FLOATING
C282 m4_20000_108708# a_64549_20015# 0 $ **FLOATING
C283 m4_22410_109660# a_64549_20015# 0 $ **FLOATING
C284 m4_22250_109690# a_64549_20015# 0 $ **FLOATING
C285 m4_22056_109668# a_64549_20015# 0 $ **FLOATING
C286 m4_21880_109632# a_64549_20015# 0 $ **FLOATING
C287 m4_21704_109596# a_64549_20015# 0 $ **FLOATING
C288 m4_21450_109680# a_64549_20015# 0 $ **FLOATING
C289 m4_21176_109664# a_64549_20015# 0 $ **FLOATING
C290 m4_21000_109628# a_64549_20015# 0 $ **FLOATING
C291 m4_20824_109592# a_64549_20015# 0 $ **FLOATING
C292 m4_20650_109670# a_64549_20015# 0 $ **FLOATING
C293 m3_67310_20000# a_64549_20015# 0 $ **FLOATING
C294 m3_66750_20000# a_64549_20015# 0 $ **FLOATING
C295 m3_67310_20290# a_64549_20015# 0 $ **FLOATING
C296 m3_66190_20010# a_64549_20015# 0 $ **FLOATING
C297 m3_65070_20000# a_64549_20015# 0 $ **FLOATING
C298 m3_66750_20430# a_64549_20015# 0 $ **FLOATING
C299 m3_65630_20150# a_64549_20015# 0 $ **FLOATING
C300 m3_64510_20000# a_64549_20015# 0 $ **FLOATING
C301 m3_67310_20850# a_64549_20015# 0 $ **FLOATING
C302 m3_66190_20570# a_64549_20015# 0 $ **FLOATING
C303 m3_65070_20290# a_64549_20015# 0 $ **FLOATING
C304 m3_66750_20990# a_64549_20015# 0 $ **FLOATING
C305 m3_65630_20710# a_64549_20015# 0 $ **FLOATING
C306 m3_64510_20430# a_64549_20015# 0 $ **FLOATING
C307 m3_67310_21410# a_64549_20015# 0 $ **FLOATING
C308 m3_66190_21130# a_64549_20015# 0 $ **FLOATING
C309 m3_65070_20850# a_64549_20015# 0 $ **FLOATING
C310 m3_66750_21550# a_64549_20015# 0 $ **FLOATING
C311 m3_65630_21270# a_64549_20015# 0 $ **FLOATING
C312 m3_64510_20990# a_64549_20015# 0 $ **FLOATING
C313 m3_67310_21970# a_64549_20015# 0 $ **FLOATING
C314 m3_66190_21690# a_64549_20015# 0 $ **FLOATING
C315 m3_65070_21410# a_64549_20015# 0 $ **FLOATING
C316 m3_66750_22110# a_64549_20015# 0 $ **FLOATING
C317 m3_65630_21830# a_64549_20015# 0 $ **FLOATING
C318 m3_64510_21550# a_64549_20015# 0 $ **FLOATING
C319 m3_67310_22530# a_64549_20015# 0 $ **FLOATING
C320 m3_66190_22250# a_64549_20015# 0 $ **FLOATING
C321 m3_65070_21970# a_64549_20015# 0 $ **FLOATING
C322 m3_66750_22670# a_64549_20015# 0 $ **FLOATING
C323 m3_65630_22390# a_64549_20015# 0 $ **FLOATING
C324 m3_64510_22110# a_64549_20015# 0 $ **FLOATING
C325 m3_67310_23090# a_64549_20015# 0 $ **FLOATING
C326 m3_66190_22810# a_64549_20015# 0 $ **FLOATING
C327 m3_65070_22530# a_64549_20015# 0 $ **FLOATING
C328 m3_66750_23230# a_64549_20015# 0 $ **FLOATING
C329 m3_65630_22950# a_64549_20015# 0 $ **FLOATING
C330 m3_64510_22670# a_64549_20015# 0 $ **FLOATING
C331 m3_65070_23090# a_64549_20015# 0 $ **FLOATING
C332 m3_64510_23230# a_64549_20015# 0 $ **FLOATING
C333 m3_22338_107200# a_64549_20015# 0 $ **FLOATING
C334 m3_22162_107200# a_64549_20015# 0 $ **FLOATING
C335 m3_21986_107200# a_64549_20015# 0 $ **FLOATING
C336 m3_22338_107346# a_64549_20015# 0 $ **FLOATING
C337 m3_22162_107310# a_64549_20015# 0 $ **FLOATING
C338 m3_21986_107274# a_64549_20015# 0 $ **FLOATING
C339 m3_21810_107238# a_64549_20015# 0 $ **FLOATING
C340 m3_21282_107200# a_64549_20015# 0 $ **FLOATING
C341 m3_21106_107200# a_64549_20015# 0 $ **FLOATING
C342 m3_22162_107486# a_64549_20015# 0 $ **FLOATING
C343 m3_21986_107450# a_64549_20015# 0 $ **FLOATING
C344 m3_21810_107414# a_64549_20015# 0 $ **FLOATING
C345 m3_21282_107306# a_64549_20015# 0 $ **FLOATING
C346 m3_21106_107270# a_64549_20015# 0 $ **FLOATING
C347 m3_20930_107234# a_64549_20015# 0 $ **FLOATING
C348 m3_20754_107200# a_64549_20015# 0 $ **FLOATING
C349 m3_20578_107200# a_64549_20015# 0 $ **FLOATING
C350 m3_20402_107200# a_64549_20015# 0 $ **FLOATING
C351 m3_20226_107200# a_64549_20015# 0 $ **FLOATING
C352 m3_21536_107398# a_64549_20015# 1.5996000000000004e-16
C353 m3_22162_107662# a_64549_20015# 0 $ **FLOATING
C354 m3_21986_107626# a_64549_20015# 0 $ **FLOATING
C355 m3_21810_107590# a_64549_20015# 0 $ **FLOATING
C356 m3_21282_107482# a_64549_20015# 0 $ **FLOATING
C357 m3_21106_107446# a_64549_20015# 0 $ **FLOATING
C358 m3_20930_107410# a_64549_20015# 0 $ **FLOATING
C359 m3_20754_107374# a_64549_20015# 0 $ **FLOATING
C360 m3_20578_107338# a_64549_20015# 0 $ **FLOATING
C361 m3_20402_107302# a_64549_20015# 0 $ **FLOATING
C362 m3_20226_107266# a_64549_20015# 0 $ **FLOATING
C363 m3_20050_107230# a_64549_20015# 0 $ **FLOATING
C364 m3_22162_107838# a_64549_20015# 0 $ **FLOATING
C365 m3_21986_107802# a_64549_20015# 0 $ **FLOATING
C366 m3_21810_107766# a_64549_20015# 0 $ **FLOATING
C367 m3_21634_107730# a_64549_20015# 0 $ **FLOATING
C368 m3_21458_107694# a_64549_20015# 0 $ **FLOATING
C369 m3_21282_107658# a_64549_20015# 0 $ **FLOATING
C370 m3_21106_107622# a_64549_20015# 0 $ **FLOATING
C371 m3_20930_107586# a_64549_20015# 0 $ **FLOATING
C372 m3_20754_107550# a_64549_20015# 0 $ **FLOATING
C373 m3_20226_107442# a_64549_20015# 0 $ **FLOATING
C374 m3_20050_107406# a_64549_20015# 0 $ **FLOATING
C375 m3_22162_108014# a_64549_20015# 0 $ **FLOATING
C376 m3_21810_107942# a_64549_20015# 0 $ **FLOATING
C377 m3_21634_107906# a_64549_20015# 0 $ **FLOATING
C378 m3_21458_107870# a_64549_20015# 0 $ **FLOATING
C379 m3_21282_107834# a_64549_20015# 0 $ **FLOATING
C380 m3_21106_107798# a_64549_20015# 0 $ **FLOATING
C381 m3_20930_107762# a_64549_20015# 0 $ **FLOATING
C382 m3_20754_107726# a_64549_20015# 0 $ **FLOATING
C383 m3_22390_108240# a_64549_20015# 0 $ **FLOATING
C384 m3_22390_108400# a_64549_20015# 0 $ **FLOATING
C385 m3_22090_108240# a_64549_20015# 0 $ **FLOATING
C386 m3_21830_108120# a_64549_20015# 0 $ **FLOATING
C387 m3_21634_108082# a_64549_20015# 0 $ **FLOATING
C388 m3_21106_107974# a_64549_20015# 0 $ **FLOATING
C389 m3_20930_107938# a_64549_20015# 0 $ **FLOATING
C390 m3_20754_107902# a_64549_20015# 0 $ **FLOATING
C391 m3_20270_107650# a_64549_20015# 0 $ **FLOATING
C392 m3_20050_107582# a_64549_20015# 0 $ **FLOATING
C393 m3_20050_107758# a_64549_20015# 0 $ **FLOATING
C394 m3_20050_107934# a_64549_20015# 0 $ **FLOATING
C395 m3_21570_108260# a_64549_20015# 0 $ **FLOATING
C396 m3_21310_108140# a_64549_20015# 0 $ **FLOATING
C397 m3_21050_108280# a_64549_20015# 0 $ **FLOATING
C398 m3_20790_108160# a_64549_20015# 0 $ **FLOATING
C399 m3_20578_108218# a_64549_20015# 0 $ **FLOATING
C400 m3_20270_108180# a_64549_20015# 0 $ **FLOATING
C401 m3_20050_108110# a_64549_20015# 0 $ **FLOATING
C402 m3_22338_108578# a_64549_20015# 0 $ **FLOATING
C403 m3_22162_108542# a_64549_20015# 0 $ **FLOATING
C404 m3_21986_108506# a_64549_20015# 0 $ **FLOATING
C405 m3_20754_108430# a_64549_20015# 0 $ **FLOATING
C406 m3_20578_108394# a_64549_20015# 0 $ **FLOATING
C407 m3_20050_108286# a_64549_20015# 0 $ **FLOATING
C408 m3_22338_108754# a_64549_20015# 0 $ **FLOATING
C409 m3_22162_108718# a_64549_20015# 0 $ **FLOATING
C410 m3_21986_108682# a_64549_20015# 0 $ **FLOATING
C411 m3_21810_108646# a_64549_20015# 0 $ **FLOATING
C412 m3_21634_108610# a_64549_20015# 0 $ **FLOATING
C413 m3_21458_108574# a_64549_20015# 0 $ **FLOATING
C414 m3_22338_108930# a_64549_20015# 0 $ **FLOATING
C415 m3_22162_108894# a_64549_20015# 0 $ **FLOATING
C416 m3_21986_108858# a_64549_20015# 0 $ **FLOATING
C417 m3_21810_108822# a_64549_20015# 0 $ **FLOATING
C418 m3_21634_108786# a_64549_20015# 0 $ **FLOATING
C419 m3_21458_108750# a_64549_20015# 0 $ **FLOATING
C420 m3_21282_108714# a_64549_20015# 0 $ **FLOATING
C421 m3_21106_108678# a_64549_20015# 0 $ **FLOATING
C422 m3_20930_108642# a_64549_20015# 0 $ **FLOATING
C423 m3_20754_108606# a_64549_20015# 0 $ **FLOATING
C424 m3_20578_108570# a_64549_20015# 0 $ **FLOATING
C425 m3_20402_108534# a_64549_20015# 0 $ **FLOATING
C426 m3_20226_108498# a_64549_20015# 0 $ **FLOATING
C427 m3_20050_108462# a_64549_20015# 0 $ **FLOATING
C428 m3_22338_109106# a_64549_20015# 0 $ **FLOATING
C429 m3_22162_109070# a_64549_20015# 0 $ **FLOATING
C430 m3_21986_109034# a_64549_20015# 0 $ **FLOATING
C431 m3_21458_108926# a_64549_20015# 0 $ **FLOATING
C432 m3_21282_108890# a_64549_20015# 0 $ **FLOATING
C433 m3_21106_108854# a_64549_20015# 0 $ **FLOATING
C434 m3_20930_108818# a_64549_20015# 0 $ **FLOATING
C435 m3_20754_108782# a_64549_20015# 0 $ **FLOATING
C436 m3_20578_108746# a_64549_20015# 0 $ **FLOATING
C437 m3_20402_108710# a_64549_20015# 0 $ **FLOATING
C438 m3_20226_108674# a_64549_20015# 0 $ **FLOATING
C439 m3_20050_108638# a_64549_20015# 0 $ **FLOATING
C440 m3_22338_109282# a_64549_20015# 0 $ **FLOATING
C441 m3_22162_109246# a_64549_20015# 0 $ **FLOATING
C442 m3_21986_109210# a_64549_20015# 0 $ **FLOATING
C443 m3_21458_109102# a_64549_20015# 0 $ **FLOATING
C444 m3_21282_109066# a_64549_20015# 0 $ **FLOATING
C445 m3_21106_109030# a_64549_20015# 0 $ **FLOATING
C446 m3_20930_108994# a_64549_20015# 0 $ **FLOATING
C447 m3_20754_108958# a_64549_20015# 0 $ **FLOATING
C448 m3_20578_108922# a_64549_20015# 0 $ **FLOATING
C449 m3_20226_108850# a_64549_20015# 0 $ **FLOATING
C450 m3_20050_108814# a_64549_20015# 0 $ **FLOATING
C451 m3_22338_109458# a_64549_20015# 0 $ **FLOATING
C452 m3_22162_109422# a_64549_20015# 0 $ **FLOATING
C453 m3_21986_109386# a_64549_20015# 0 $ **FLOATING
C454 m3_21458_109278# a_64549_20015# 0 $ **FLOATING
C455 m3_21282_109242# a_64549_20015# 0 $ **FLOATING
C456 m3_21106_109206# a_64549_20015# 0 $ **FLOATING
C457 m3_20930_109170# a_64549_20015# 0 $ **FLOATING
C458 m3_20754_109134# a_64549_20015# 0 $ **FLOATING
C459 m3_20578_109098# a_64549_20015# 0 $ **FLOATING
C460 m3_20050_108990# a_64549_20015# 0 $ **FLOATING
C461 m3_22338_109634# a_64549_20015# 0 $ **FLOATING
C462 m3_22162_109598# a_64549_20015# 0 $ **FLOATING
C463 m3_21986_109562# a_64549_20015# 0 $ **FLOATING
C464 m3_21458_109454# a_64549_20015# 0 $ **FLOATING
C465 m3_21282_109418# a_64549_20015# 0 $ **FLOATING
C466 m3_21106_109382# a_64549_20015# 0 $ **FLOATING
C467 m3_20930_109346# a_64549_20015# 0 $ **FLOATING
C468 m3_20754_109310# a_64549_20015# 0 $ **FLOATING
C469 m3_20578_109274# a_64549_20015# 0 $ **FLOATING
C470 m3_20050_109166# a_64549_20015# 0 $ **FLOATING
C471 m3_21634_109666# a_64549_20015# 0 $ **FLOATING
C472 m3_21458_109630# a_64549_20015# 0 $ **FLOATING
C473 m3_21282_109594# a_64549_20015# 0 $ **FLOATING
C474 m3_21106_109558# a_64549_20015# 0 $ **FLOATING
C475 m3_20930_109522# a_64549_20015# 0 $ **FLOATING
C476 m3_20754_109486# a_64549_20015# 0 $ **FLOATING
C477 m3_20578_109450# a_64549_20015# 0 $ **FLOATING
C478 m3_20050_109342# a_64549_20015# 0 $ **FLOATING
C479 m3_20754_109662# a_64549_20015# 0 $ **FLOATING
C480 m3_20578_109626# a_64549_20015# 0 $ **FLOATING
C481 m3_20050_109518# a_64549_20015# 0 $ **FLOATING
C482 m3_20050_109694# a_64549_20015# 0 $ **FLOATING
C483 m2_67310_20000# a_64549_20015# 0 $ **FLOATING
C484 m2_67340_20180# a_64549_20015# 0 $ **FLOATING
C485 m2_66750_20000# a_64549_20015# 0 $ **FLOATING
C486 m2_66640_20020# a_64549_20015# 0 $ **FLOATING
C487 m2_66640_20120# a_64549_20015# 0 $ **FLOATING
C488 m2_66640_20220# a_64549_20015# 0 $ **FLOATING
C489 m2_67310_20290# a_64549_20015# 0 $ **FLOATING
C490 m2_67140_20320# a_64549_20015# 0 $ **FLOATING
C491 m2_66640_20320# a_64549_20015# 0 $ **FLOATING
C492 m2_66190_20010# a_64549_20015# 0 $ **FLOATING
C493 m2_66040_20040# a_64549_20015# 0 $ **FLOATING
C494 m2_65540_20040# a_64549_20015# 0 $ **FLOATING
C495 m2_65070_20000# a_64549_20015# 0 $ **FLOATING
C496 m2_67540_20740# a_64549_20015# 0 $ **FLOATING
C497 m2_66750_20430# a_64549_20015# 0 $ **FLOATING
C498 m2_66640_20420# a_64549_20015# 0 $ **FLOATING
C499 m2_66440_20460# a_64549_20015# 0 $ **FLOATING
C500 m2_66640_20520# a_64549_20015# 0 $ **FLOATING
C501 m2_65630_20150# a_64549_20015# 0 $ **FLOATING
C502 m2_65340_20180# a_64549_20015# 0 $ **FLOATING
C503 m2_64510_20000# a_64549_20015# 0 $ **FLOATING
C504 m2_66640_20620# a_64549_20015# 0 $ **FLOATING
C505 m2_66640_20720# a_64549_20015# 0 $ **FLOATING
C506 m2_67310_20850# a_64549_20015# 0 $ **FLOATING
C507 m2_66640_20820# a_64549_20015# 0 $ **FLOATING
C508 m2_66840_20880# a_64549_20015# 0 $ **FLOATING
C509 m2_66640_20920# a_64549_20015# 0 $ **FLOATING
C510 m2_66190_20570# a_64549_20015# 0 $ **FLOATING
C511 m2_65740_20600# a_64549_20015# 0 $ **FLOATING
C512 m2_65070_20290# a_64549_20015# 0 $ **FLOATING
C513 m2_64640_20320# a_64549_20015# 0 $ **FLOATING
C514 m2_67240_21300# a_64549_20015# 0 $ **FLOATING
C515 m2_66750_20990# a_64549_20015# 0 $ **FLOATING
C516 m2_66640_21020# a_64549_20015# 0 $ **FLOATING
C517 m2_66140_21020# a_64549_20015# 0 $ **FLOATING
C518 m2_65630_20710# a_64549_20015# 0 $ **FLOATING
C519 m2_65040_20740# a_64549_20015# 0 $ **FLOATING
C520 m2_64510_20430# a_64549_20015# 0 $ **FLOATING
C521 m2_66640_21120# a_64549_20015# 0 $ **FLOATING
C522 m2_66640_21220# a_64549_20015# 0 $ **FLOATING
C523 m2_66640_21320# a_64549_20015# 0 $ **FLOATING
C524 m2_67310_21410# a_64549_20015# 0 $ **FLOATING
C525 m2_67040_21440# a_64549_20015# 0 $ **FLOATING
C526 m2_66640_21420# a_64549_20015# 0 $ **FLOATING
C527 m2_67440_21860# a_64549_20015# 0 $ **FLOATING
C528 m2_66750_21550# a_64549_20015# 0 $ **FLOATING
C529 m2_66640_21520# a_64549_20015# 0 $ **FLOATING
C530 m2_66190_21130# a_64549_20015# 0 $ **FLOATING
C531 m2_65940_21160# a_64549_20015# 0 $ **FLOATING
C532 m2_65070_20850# a_64549_20015# 0 $ **FLOATING
C533 m2_64840_20880# a_64549_20015# 0 $ **FLOATING
C534 m2_66640_21620# a_64549_20015# 0 $ **FLOATING
C535 m2_66340_21580# a_64549_20015# 0 $ **FLOATING
C536 m2_65630_21270# a_64549_20015# 0 $ **FLOATING
C537 m2_65240_21300# a_64549_20015# 0 $ **FLOATING
C538 m2_64510_20990# a_64549_20015# 0 $ **FLOATING
C539 m2_66640_21720# a_64549_20015# 0 $ **FLOATING
C540 m2_66640_21820# a_64549_20015# 0 $ **FLOATING
C541 m2_67310_21970# a_64549_20015# 0 $ **FLOATING
C542 m2_66640_21920# a_64549_20015# 0 $ **FLOATING
C543 m2_66740_22000# a_64549_20015# 0 $ **FLOATING
C544 m2_66640_22020# a_64549_20015# 0 $ **FLOATING
C545 m2_66190_21690# a_64549_20015# 0 $ **FLOATING
C546 m2_65640_21720# a_64549_20015# 0 $ **FLOATING
C547 m2_65070_21410# a_64549_20015# 0 $ **FLOATING
C548 m2_64540_21440# a_64549_20015# 0 $ **FLOATING
C549 m2_66750_22110# a_64549_20015# 0 $ **FLOATING
C550 m2_66640_22120# a_64549_20015# 0 $ **FLOATING
C551 m2_66540_22140# a_64549_20015# 0 $ **FLOATING
C552 m2_66640_22220# a_64549_20015# 0 $ **FLOATING
C553 m2_65630_21830# a_64549_20015# 0 $ **FLOATING
C554 m2_65440_21860# a_64549_20015# 0 $ **FLOATING
C555 m2_64510_21550# a_64549_20015# 0 $ **FLOATING
C556 m2_66640_22320# a_64549_20015# 0 $ **FLOATING
C557 m2_66640_22420# a_64549_20015# 0 $ **FLOATING
C558 m2_67310_22530# a_64549_20015# 0 $ **FLOATING
C559 m2_66940_22560# a_64549_20015# 0 $ **FLOATING
C560 m2_66640_22520# a_64549_20015# 0 $ **FLOATING
C561 m2_67340_22980# a_64549_20015# 0 $ **FLOATING
C562 m2_66750_22670# a_64549_20015# 0 $ **FLOATING
C563 m2_66640_22620# a_64549_20015# 0 $ **FLOATING
C564 m2_66190_22250# a_64549_20015# 0 $ **FLOATING
C565 m2_65840_22280# a_64549_20015# 0 $ **FLOATING
C566 m2_65070_21970# a_64549_20015# 0 $ **FLOATING
C567 m2_64740_22000# a_64549_20015# 0 $ **FLOATING
C568 m2_66640_22720# a_64549_20015# 0 $ **FLOATING
C569 m2_66240_22700# a_64549_20015# 0 $ **FLOATING
C570 m2_65630_22390# a_64549_20015# 0 $ **FLOATING
C571 m2_65140_22420# a_64549_20015# 0 $ **FLOATING
C572 m2_64510_22110# a_64549_20015# 0 $ **FLOATING
C573 m2_66640_22820# a_64549_20015# 0 $ **FLOATING
C574 m2_66640_22920# a_64549_20015# 0 $ **FLOATING
C575 m2_66640_23020# a_64549_20015# 0 $ **FLOATING
C576 m2_67310_23090# a_64549_20015# 0 $ **FLOATING
C577 m2_67140_23120# a_64549_20015# 0 $ **FLOATING
C578 m2_66640_23120# a_64549_20015# 0 $ **FLOATING
C579 m2_66190_22810# a_64549_20015# 0 $ **FLOATING
C580 m2_66040_22840# a_64549_20015# 0 $ **FLOATING
C581 m2_65540_22840# a_64549_20015# 0 $ **FLOATING
C582 m2_65070_22530# a_64549_20015# 0 $ **FLOATING
C583 m2_64940_22560# a_64549_20015# 0 $ **FLOATING
C584 m2_64440_22560# a_64549_20015# 0 $ **FLOATING
C585 m2_66750_23230# a_64549_20015# 0 $ **FLOATING
C586 m2_66640_23220# a_64549_20015# 0 $ **FLOATING
C587 m2_66440_23260# a_64549_20015# 0 $ **FLOATING
C588 m2_65630_22950# a_64549_20015# 0 $ **FLOATING
C589 m2_65340_22980# a_64549_20015# 0 $ **FLOATING
C590 m2_64510_22670# a_64549_20015# 0 $ **FLOATING
C591 m2_65070_23090# a_64549_20015# 0 $ **FLOATING
C592 m2_64640_23120# a_64549_20015# 0 $ **FLOATING
C593 m2_64510_23230# a_64549_20015# 0 $ **FLOATING
C594 m2_22440_107200# a_64549_20015# 0 $ **FLOATING
C595 m2_22340_107200# a_64549_20015# 0 $ **FLOATING
C596 m2_22240_107200# a_64549_20015# 0 $ **FLOATING
C597 m2_21940_107200# a_64549_20015# 0 $ **FLOATING
C598 m2_21840_107200# a_64549_20015# 0 $ **FLOATING
C599 m2_21740_107200# a_64549_20015# 0 $ **FLOATING
C600 m2_21440_107200# a_64549_20015# 0 $ **FLOATING
C601 m2_21340_107200# a_64549_20015# 0 $ **FLOATING
C602 m2_21240_107200# a_64549_20015# 0 $ **FLOATING
C603 m2_20940_107200# a_64549_20015# 0 $ **FLOATING
C604 m2_20840_107200# a_64549_20015# 0 $ **FLOATING
C605 m2_20740_107200# a_64549_20015# 0 $ **FLOATING
C606 m2_20440_107200# a_64549_20015# 0 $ **FLOATING
C607 m2_20340_107200# a_64549_20015# 0 $ **FLOATING
C608 m2_20240_107200# a_64549_20015# 0 $ **FLOATING
C609 m2_20000_107326# a_64549_20015# 6.0877200000000016e-16
C610 m2_22400_107476# a_64549_20015# 0 $ **FLOATING
C611 m2_22244_107460# a_64549_20015# 0 $ **FLOATING
C612 m2_22140_107420# a_64549_20015# 0 $ **FLOATING
C613 m2_22040_107440# a_64549_20015# 0 $ **FLOATING
C614 m2_21940_107460# a_64549_20015# 0 $ **FLOATING
C615 m2_21640_107420# a_64549_20015# 0 $ **FLOATING
C616 m2_22400_107632# a_64549_20015# 0 $ **FLOATING
C617 m2_22244_107616# a_64549_20015# 0 $ **FLOATING
C618 m2_22088_107600# a_64549_20015# 0 $ **FLOATING
C619 m2_21932_107584# a_64549_20015# 0 $ **FLOATING
C620 m2_21776_107568# a_64549_20015# 0 $ **FLOATING
C621 m2_21620_107552# a_64549_20015# 0 $ **FLOATING
C622 m2_21464_107536# a_64549_20015# 0 $ **FLOATING
C623 m2_21340_107480# a_64549_20015# 0 $ **FLOATING
C624 m2_22440_107860# a_64549_20015# 0 $ **FLOATING
C625 m2_22244_107772# a_64549_20015# 0 $ **FLOATING
C626 m2_22088_107756# a_64549_20015# 0 $ **FLOATING
C627 m2_21932_107740# a_64549_20015# 0 $ **FLOATING
C628 m2_21776_107724# a_64549_20015# 0 $ **FLOATING
C629 m2_21620_107708# a_64549_20015# 0 $ **FLOATING
C630 m2_21464_107692# a_64549_20015# 0 $ **FLOATING
C631 m2_21308_107676# a_64549_20015# 0 $ **FLOATING
C632 m2_21152_107660# a_64549_20015# 0 $ **FLOATING
C633 m2_21040_107640# a_64549_20015# 0 $ **FLOATING
C634 m2_20940_107660# a_64549_20015# 0 $ **FLOATING
C635 m2_20640_107620# a_64549_20015# 0 $ **FLOATING
C636 m2_20840_107680# a_64549_20015# 0 $ **FLOATING
C637 m2_20540_107640# a_64549_20015# 0 $ **FLOATING
C638 m2_21040_107740# a_64549_20015# 0 $ **FLOATING
C639 m2_20940_107760# a_64549_20015# 0 $ **FLOATING
C640 m2_21440_107860# a_64549_20015# 0 $ **FLOATING
C641 m2_21140_107820# a_64549_20015# 0 $ **FLOATING
C642 m2_20840_107780# a_64549_20015# 0 $ **FLOATING
C643 m2_21040_107840# a_64549_20015# 0 $ **FLOATING
C644 m2_20940_107860# a_64549_20015# 0 $ **FLOATING
C645 m2_20684_107768# a_64549_20015# 0 $ **FLOATING
C646 m2_20528_107752# a_64549_20015# 0 $ **FLOATING
C647 m2_20372_107736# a_64549_20015# 0 $ **FLOATING
C648 m2_20216_107720# a_64549_20015# 0 $ **FLOATING
C649 m2_20060_107704# a_64549_20015# 0 $ **FLOATING
C650 m2_20000_107688# a_64549_20015# 0 $ **FLOATING
C651 m2_20000_107998# a_64549_20015# 1.9860200000000002e-16
C652 m2_20000_108190# a_64549_20015# 3.5008700000000003e-16
C653 m2_22340_108280# a_64549_20015# 0 $ **FLOATING
C654 m2_22400_108412# a_64549_20015# 0 $ **FLOATING
C655 m2_22244_108396# a_64549_20015# 0 $ **FLOATING
C656 m2_22088_108380# a_64549_20015# 0 $ **FLOATING
C657 m2_21932_108364# a_64549_20015# 0 $ **FLOATING
C658 m2_21776_108348# a_64549_20015# 0 $ **FLOATING
C659 m2_21620_108332# a_64549_20015# 0 $ **FLOATING
C660 m2_21340_108280# a_64549_20015# 0 $ **FLOATING
C661 m2_21240_108300# a_64549_20015# 0 $ **FLOATING
C662 m2_21140_108320# a_64549_20015# 0 $ **FLOATING
C663 m2_20840_108280# a_64549_20015# 0 $ **FLOATING
C664 m2_22400_108568# a_64549_20015# 0 $ **FLOATING
C665 m2_22244_108552# a_64549_20015# 0 $ **FLOATING
C666 m2_22088_108536# a_64549_20015# 0 $ **FLOATING
C667 m2_21932_108520# a_64549_20015# 0 $ **FLOATING
C668 m2_21776_108504# a_64549_20015# 0 $ **FLOATING
C669 m2_21620_108488# a_64549_20015# 0 $ **FLOATING
C670 m2_21464_108472# a_64549_20015# 0 $ **FLOATING
C671 m2_21308_108456# a_64549_20015# 0 $ **FLOATING
C672 m2_21152_108440# a_64549_20015# 0 $ **FLOATING
C673 m2_20996_108424# a_64549_20015# 0 $ **FLOATING
C674 m2_20840_108408# a_64549_20015# 0 $ **FLOATING
C675 m2_20684_108392# a_64549_20015# 0 $ **FLOATING
C676 m2_20528_108376# a_64549_20015# 0 $ **FLOATING
C677 m2_20372_108360# a_64549_20015# 0 $ **FLOATING
C678 m2_20216_108344# a_64549_20015# 0 $ **FLOATING
C679 m2_20060_108328# a_64549_20015# 0 $ **FLOATING
C680 m2_22400_108724# a_64549_20015# 0 $ **FLOATING
C681 m2_22244_108708# a_64549_20015# 0 $ **FLOATING
C682 m2_22088_108692# a_64549_20015# 0 $ **FLOATING
C683 m2_21932_108676# a_64549_20015# 0 $ **FLOATING
C684 m2_21776_108660# a_64549_20015# 0 $ **FLOATING
C685 m2_21620_108644# a_64549_20015# 0 $ **FLOATING
C686 m2_21464_108628# a_64549_20015# 0 $ **FLOATING
C687 m2_21308_108612# a_64549_20015# 0 $ **FLOATING
C688 m2_21152_108596# a_64549_20015# 0 $ **FLOATING
C689 m2_20996_108580# a_64549_20015# 0 $ **FLOATING
C690 m2_20840_108564# a_64549_20015# 0 $ **FLOATING
C691 m2_20684_108548# a_64549_20015# 0 $ **FLOATING
C692 m2_20528_108532# a_64549_20015# 0 $ **FLOATING
C693 m2_20372_108516# a_64549_20015# 0 $ **FLOATING
C694 m2_22400_108880# a_64549_20015# 0 $ **FLOATING
C695 m2_22244_108864# a_64549_20015# 0 $ **FLOATING
C696 m2_22088_108848# a_64549_20015# 0 $ **FLOATING
C697 m2_21932_108832# a_64549_20015# 0 $ **FLOATING
C698 m2_21776_108816# a_64549_20015# 0 $ **FLOATING
C699 m2_21620_108800# a_64549_20015# 0 $ **FLOATING
C700 m2_21464_108784# a_64549_20015# 0 $ **FLOATING
C701 m2_21308_108768# a_64549_20015# 0 $ **FLOATING
C702 m2_21152_108752# a_64549_20015# 0 $ **FLOATING
C703 m2_20996_108736# a_64549_20015# 0 $ **FLOATING
C704 m2_20840_108720# a_64549_20015# 0 $ **FLOATING
C705 m2_20684_108704# a_64549_20015# 0 $ **FLOATING
C706 m2_20528_108688# a_64549_20015# 0 $ **FLOATING
C707 m2_20372_108672# a_64549_20015# 0 $ **FLOATING
C708 m2_20240_108700# a_64549_20015# 0 $ **FLOATING
C709 m2_22400_109036# a_64549_20015# 0 $ **FLOATING
C710 m2_22244_109020# a_64549_20015# 0 $ **FLOATING
C711 m2_22088_109004# a_64549_20015# 0 $ **FLOATING
C712 m2_21932_108988# a_64549_20015# 0 $ **FLOATING
C713 m2_21464_108940# a_64549_20015# 0 $ **FLOATING
C714 m2_21308_108924# a_64549_20015# 0 $ **FLOATING
C715 m2_21152_108908# a_64549_20015# 0 $ **FLOATING
C716 m2_20996_108892# a_64549_20015# 0 $ **FLOATING
C717 m2_20840_108876# a_64549_20015# 0 $ **FLOATING
C718 m2_20684_108860# a_64549_20015# 0 $ **FLOATING
C719 m2_20528_108844# a_64549_20015# 0 $ **FLOATING
C720 m2_20372_108828# a_64549_20015# 0 $ **FLOATING
C721 m2_20216_108812# a_64549_20015# 0 $ **FLOATING
C722 m2_20060_108796# a_64549_20015# 0 $ **FLOATING
C723 m2_20000_108780# a_64549_20015# 0 $ **FLOATING
C724 m2_22400_109192# a_64549_20015# 0 $ **FLOATING
C725 m2_22244_109176# a_64549_20015# 0 $ **FLOATING
C726 m2_22088_109160# a_64549_20015# 0 $ **FLOATING
C727 m2_21932_109144# a_64549_20015# 0 $ **FLOATING
C728 m2_21464_109096# a_64549_20015# 0 $ **FLOATING
C729 m2_21308_109080# a_64549_20015# 0 $ **FLOATING
C730 m2_21152_109064# a_64549_20015# 0 $ **FLOATING
C731 m2_20996_109048# a_64549_20015# 0 $ **FLOATING
C732 m2_20840_109032# a_64549_20015# 0 $ **FLOATING
C733 m2_20684_109016# a_64549_20015# 0 $ **FLOATING
C734 m2_20528_109000# a_64549_20015# 0 $ **FLOATING
C735 m2_20060_108952# a_64549_20015# 0 $ **FLOATING
C736 m2_20000_108936# a_64549_20015# 0 $ **FLOATING
C737 m2_22400_109348# a_64549_20015# 0 $ **FLOATING
C738 m2_22244_109332# a_64549_20015# 0 $ **FLOATING
C739 m2_22088_109316# a_64549_20015# 0 $ **FLOATING
C740 m2_21932_109300# a_64549_20015# 0 $ **FLOATING
C741 m2_21464_109252# a_64549_20015# 0 $ **FLOATING
C742 m2_21308_109236# a_64549_20015# 0 $ **FLOATING
C743 m2_21152_109220# a_64549_20015# 0 $ **FLOATING
C744 m2_20996_109204# a_64549_20015# 0 $ **FLOATING
C745 m2_20840_109188# a_64549_20015# 0 $ **FLOATING
C746 m2_20684_109172# a_64549_20015# 0 $ **FLOATING
C747 m2_20528_109156# a_64549_20015# 0 $ **FLOATING
C748 m2_20060_109108# a_64549_20015# 0 $ **FLOATING
C749 m2_20000_109092# a_64549_20015# 0 $ **FLOATING
C750 m2_22400_109504# a_64549_20015# 0 $ **FLOATING
C751 m2_22244_109488# a_64549_20015# 0 $ **FLOATING
C752 m2_22088_109472# a_64549_20015# 0 $ **FLOATING
C753 m2_21932_109456# a_64549_20015# 0 $ **FLOATING
C754 m2_21464_109408# a_64549_20015# 0 $ **FLOATING
C755 m2_21308_109392# a_64549_20015# 0 $ **FLOATING
C756 m2_21152_109376# a_64549_20015# 0 $ **FLOATING
C757 m2_20996_109360# a_64549_20015# 0 $ **FLOATING
C758 m2_20840_109344# a_64549_20015# 0 $ **FLOATING
C759 m2_20684_109328# a_64549_20015# 0 $ **FLOATING
C760 m2_20528_109312# a_64549_20015# 0 $ **FLOATING
C761 m2_20060_109264# a_64549_20015# 0 $ **FLOATING
C762 m2_20000_109248# a_64549_20015# 0 $ **FLOATING
C763 m2_22400_109660# a_64549_20015# 0 $ **FLOATING
C764 m2_22244_109644# a_64549_20015# 0 $ **FLOATING
C765 m2_22088_109628# a_64549_20015# 0 $ **FLOATING
C766 m2_21932_109612# a_64549_20015# 0 $ **FLOATING
C767 m2_21776_109596# a_64549_20015# 0 $ **FLOATING
C768 m2_21620_109580# a_64549_20015# 0 $ **FLOATING
C769 m2_21464_109564# a_64549_20015# 0 $ **FLOATING
C770 m2_21308_109548# a_64549_20015# 0 $ **FLOATING
C771 m2_21152_109532# a_64549_20015# 0 $ **FLOATING
C772 m2_20996_109516# a_64549_20015# 0 $ **FLOATING
C773 m2_20840_109500# a_64549_20015# 0 $ **FLOATING
C774 m2_20684_109484# a_64549_20015# 0 $ **FLOATING
C775 m2_20528_109468# a_64549_20015# 0 $ **FLOATING
C776 m2_20060_109420# a_64549_20015# 0 $ **FLOATING
C777 m2_20000_109404# a_64549_20015# 0 $ **FLOATING
C778 m2_20996_109672# a_64549_20015# 0 $ **FLOATING
C779 m2_20840_109656# a_64549_20015# 0 $ **FLOATING
C780 m2_20684_109640# a_64549_20015# 0 $ **FLOATING
C781 m2_20528_109624# a_64549_20015# 0 $ **FLOATING
C782 m2_20372_109608# a_64549_20015# 0 $ **FLOATING
C783 m2_20216_109592# a_64549_20015# 0 $ **FLOATING
C784 m2_20060_109576# a_64549_20015# 0 $ **FLOATING
C785 m2_20000_109560# a_64549_20015# 0 $ **FLOATING
C786 m1_67310_20000# a_64549_20015# 0 $ **FLOATING
C787 m1_67060_20000# a_64549_20015# 0 $ **FLOATING
C788 m1_67430_20170# a_64549_20015# 0 $ **FLOATING
C789 m1_67330_20190# a_64549_20015# 0 $ **FLOATING
C790 m1_67060_20060# a_64549_20015# 0 $ **FLOATING
C791 m1_66820_20000# a_64549_20015# 0 $ **FLOATING
C792 m1_66634_20000# a_64549_20015# 0 $ **FLOATING
C793 m1_66634_20050# a_64549_20015# 0 $ **FLOATING
C794 m1_66478_20034# a_64549_20015# 0 $ **FLOATING
C795 m1_66322_20018# a_64549_20015# 0 $ **FLOATING
C796 m1_65854_20000# a_64549_20015# 0 $ **FLOATING
C797 m1_65730_20010# a_64549_20015# 0 $ **FLOATING
C798 m1_65430_20000# a_64549_20015# 0 $ **FLOATING
C799 m1_65230_20000# a_64549_20015# 0 $ **FLOATING
C800 m1_67310_20290# a_64549_20015# 0 $ **FLOATING
C801 m1_67060_20300# a_64549_20015# 0 $ **FLOATING
C802 m1_66820_20200# a_64549_20015# 0 $ **FLOATING
C803 m1_66634_20206# a_64549_20015# 0 $ **FLOATING
C804 m1_66478_20190# a_64549_20015# 0 $ **FLOATING
C805 m1_66322_20174# a_64549_20015# 0 $ **FLOATING
C806 m1_65854_20126# a_64549_20015# 0 $ **FLOATING
C807 m1_65730_20110# a_64549_20015# 0 $ **FLOATING
C808 m1_65430_20070# a_64549_20015# 0 $ **FLOATING
C809 m1_65730_20210# a_64549_20015# 0 $ **FLOATING
C810 m1_65430_20170# a_64549_20015# 0 $ **FLOATING
C811 m1_65230_20062# a_64549_20015# 0 $ **FLOATING
C812 m1_64762_20014# a_64549_20015# 0 $ **FLOATING
C813 m1_67060_20540# a_64549_20015# 0 $ **FLOATING
C814 m1_66820_20440# a_64549_20015# 0 $ **FLOATING
C815 m1_66634_20362# a_64549_20015# 0 $ **FLOATING
C816 m1_66478_20346# a_64549_20015# 0 $ **FLOATING
C817 m1_66322_20330# a_64549_20015# 0 $ **FLOATING
C818 m1_65854_20282# a_64549_20015# 0 $ **FLOATING
C819 m1_65730_20310# a_64549_20015# 0 $ **FLOATING
C820 m1_65430_20270# a_64549_20015# 0 $ **FLOATING
C821 m1_65230_20218# a_64549_20015# 0 $ **FLOATING
C822 m1_64762_20170# a_64549_20015# 0 $ **FLOATING
C823 m1_66634_20518# a_64549_20015# 0 $ **FLOATING
C824 m1_66478_20502# a_64549_20015# 0 $ **FLOATING
C825 m1_66322_20486# a_64549_20015# 0 $ **FLOATING
C826 m1_65854_20438# a_64549_20015# 0 $ **FLOATING
C827 m1_65730_20410# a_64549_20015# 0 $ **FLOATING
C828 m1_65430_20370# a_64549_20015# 0 $ **FLOATING
C829 m1_65730_20510# a_64549_20015# 0 $ **FLOATING
C830 m1_65430_20470# a_64549_20015# 0 $ **FLOATING
C831 m1_65230_20374# a_64549_20015# 0 $ **FLOATING
C832 m1_64762_20326# a_64549_20015# 0 $ **FLOATING
C833 m1_67530_20750# a_64549_20015# 0 $ **FLOATING
C834 m1_67310_20850# a_64549_20015# 0 $ **FLOATING
C835 m1_67060_20780# a_64549_20015# 0 $ **FLOATING
C836 m1_66820_20680# a_64549_20015# 0 $ **FLOATING
C837 m1_66634_20674# a_64549_20015# 0 $ **FLOATING
C838 m1_66478_20658# a_64549_20015# 0 $ **FLOATING
C839 m1_66322_20642# a_64549_20015# 0 $ **FLOATING
C840 m1_65854_20594# a_64549_20015# 0 $ **FLOATING
C841 m1_65730_20610# a_64549_20015# 0 $ **FLOATING
C842 m1_65430_20570# a_64549_20015# 0 $ **FLOATING
C843 m1_65230_20530# a_64549_20015# 0 $ **FLOATING
C844 m1_64762_20482# a_64549_20015# 0 $ **FLOATING
C845 m1_67060_21020# a_64549_20015# 0 $ **FLOATING
C846 m1_66820_20920# a_64549_20015# 0 $ **FLOATING
C847 m1_66634_20830# a_64549_20015# 0 $ **FLOATING
C848 m1_66478_20814# a_64549_20015# 0 $ **FLOATING
C849 m1_66322_20798# a_64549_20015# 0 $ **FLOATING
C850 m1_65854_20750# a_64549_20015# 0 $ **FLOATING
C851 m1_65730_20710# a_64549_20015# 0 $ **FLOATING
C852 m1_65430_20670# a_64549_20015# 0 $ **FLOATING
C853 m1_65730_20810# a_64549_20015# 0 $ **FLOATING
C854 m1_65430_20770# a_64549_20015# 0 $ **FLOATING
C855 m1_65230_20686# a_64549_20015# 0 $ **FLOATING
C856 m1_64762_20638# a_64549_20015# 0 $ **FLOATING
C857 m1_66634_20986# a_64549_20015# 0 $ **FLOATING
C858 m1_66478_20970# a_64549_20015# 0 $ **FLOATING
C859 m1_66322_20954# a_64549_20015# 0 $ **FLOATING
C860 m1_65854_20906# a_64549_20015# 0 $ **FLOATING
C861 m1_65730_20910# a_64549_20015# 0 $ **FLOATING
C862 m1_65430_20870# a_64549_20015# 0 $ **FLOATING
C863 m1_65230_20842# a_64549_20015# 0 $ **FLOATING
C864 m1_64762_20794# a_64549_20015# 0 $ **FLOATING
C865 m1_67330_21290# a_64549_20015# 0 $ **FLOATING
C866 m1_67310_21410# a_64549_20015# 0 $ **FLOATING
C867 m1_67060_21260# a_64549_20015# 0 $ **FLOATING
C868 m1_66820_21160# a_64549_20015# 0 $ **FLOATING
C869 m1_66634_21142# a_64549_20015# 0 $ **FLOATING
C870 m1_66478_21126# a_64549_20015# 0 $ **FLOATING
C871 m1_66322_21110# a_64549_20015# 0 $ **FLOATING
C872 m1_65854_21062# a_64549_20015# 0 $ **FLOATING
C873 m1_65730_21010# a_64549_20015# 0 $ **FLOATING
C874 m1_65430_20970# a_64549_20015# 0 $ **FLOATING
C875 m1_65730_21110# a_64549_20015# 0 $ **FLOATING
C876 m1_65430_21070# a_64549_20015# 0 $ **FLOATING
C877 m1_65230_20998# a_64549_20015# 0 $ **FLOATING
C878 m1_64762_20950# a_64549_20015# 0 $ **FLOATING
C879 m1_67060_21500# a_64549_20015# 0 $ **FLOATING
C880 m1_66820_21400# a_64549_20015# 0 $ **FLOATING
C881 m1_66634_21298# a_64549_20015# 0 $ **FLOATING
C882 m1_66478_21282# a_64549_20015# 0 $ **FLOATING
C883 m1_66322_21266# a_64549_20015# 0 $ **FLOATING
C884 m1_65854_21218# a_64549_20015# 0 $ **FLOATING
C885 m1_65730_21210# a_64549_20015# 0 $ **FLOATING
C886 m1_65430_21170# a_64549_20015# 0 $ **FLOATING
C887 m1_65230_21154# a_64549_20015# 0 $ **FLOATING
C888 m1_64762_21106# a_64549_20015# 0 $ **FLOATING
C889 m1_65730_21310# a_64549_20015# 0 $ **FLOATING
C890 m1_65430_21270# a_64549_20015# 0 $ **FLOATING
C891 m1_66634_21454# a_64549_20015# 0 $ **FLOATING
C892 m1_66478_21438# a_64549_20015# 0 $ **FLOATING
C893 m1_66322_21422# a_64549_20015# 0 $ **FLOATING
C894 m1_65854_21374# a_64549_20015# 0 $ **FLOATING
C895 m1_65730_21410# a_64549_20015# 0 $ **FLOATING
C896 m1_65430_21370# a_64549_20015# 0 $ **FLOATING
C897 m1_65230_21310# a_64549_20015# 0 $ **FLOATING
C898 m1_64762_21262# a_64549_20015# 0 $ **FLOATING
C899 m1_67530_21850# a_64549_20015# 0 $ **FLOATING
C900 m1_67430_21870# a_64549_20015# 0 $ **FLOATING
C901 m1_67060_21740# a_64549_20015# 0 $ **FLOATING
C902 m1_66820_21640# a_64549_20015# 0 $ **FLOATING
C903 m1_66634_21610# a_64549_20015# 0 $ **FLOATING
C904 m1_66478_21594# a_64549_20015# 0 $ **FLOATING
C905 m1_66322_21578# a_64549_20015# 0 $ **FLOATING
C906 m1_65854_21530# a_64549_20015# 0 $ **FLOATING
C907 m1_65730_21510# a_64549_20015# 0 $ **FLOATING
C908 m1_65430_21470# a_64549_20015# 0 $ **FLOATING
C909 m1_65730_21610# a_64549_20015# 0 $ **FLOATING
C910 m1_65430_21570# a_64549_20015# 0 $ **FLOATING
C911 m1_65230_21466# a_64549_20015# 0 $ **FLOATING
C912 m1_64762_21418# a_64549_20015# 0 $ **FLOATING
C913 m1_67310_21970# a_64549_20015# 0 $ **FLOATING
C914 m1_67060_21980# a_64549_20015# 0 $ **FLOATING
C915 m1_66820_21880# a_64549_20015# 0 $ **FLOATING
C916 m1_66634_21766# a_64549_20015# 0 $ **FLOATING
C917 m1_66478_21750# a_64549_20015# 0 $ **FLOATING
C918 m1_66322_21734# a_64549_20015# 0 $ **FLOATING
C919 m1_65854_21686# a_64549_20015# 0 $ **FLOATING
C920 m1_65730_21710# a_64549_20015# 0 $ **FLOATING
C921 m1_65430_21670# a_64549_20015# 0 $ **FLOATING
C922 m1_65230_21622# a_64549_20015# 0 $ **FLOATING
C923 m1_64762_21574# a_64549_20015# 0 $ **FLOATING
C924 m1_66634_21922# a_64549_20015# 0 $ **FLOATING
C925 m1_66478_21906# a_64549_20015# 0 $ **FLOATING
C926 m1_66322_21890# a_64549_20015# 0 $ **FLOATING
C927 m1_65854_21842# a_64549_20015# 0 $ **FLOATING
C928 m1_65730_21810# a_64549_20015# 0 $ **FLOATING
C929 m1_65430_21770# a_64549_20015# 0 $ **FLOATING
C930 m1_65730_21910# a_64549_20015# 0 $ **FLOATING
C931 m1_65430_21870# a_64549_20015# 0 $ **FLOATING
C932 m1_65230_21778# a_64549_20015# 0 $ **FLOATING
C933 m1_64762_21730# a_64549_20015# 0 $ **FLOATING
C934 m1_67060_22220# a_64549_20015# 0 $ **FLOATING
C935 m1_66820_22120# a_64549_20015# 0 $ **FLOATING
C936 m1_66634_22078# a_64549_20015# 0 $ **FLOATING
C937 m1_66478_22062# a_64549_20015# 0 $ **FLOATING
C938 m1_66322_22046# a_64549_20015# 0 $ **FLOATING
C939 m1_65854_21998# a_64549_20015# 0 $ **FLOATING
C940 m1_65730_22010# a_64549_20015# 0 $ **FLOATING
C941 m1_65430_21970# a_64549_20015# 0 $ **FLOATING
C942 m1_65230_21934# a_64549_20015# 0 $ **FLOATING
C943 m1_64762_21886# a_64549_20015# 0 $ **FLOATING
C944 m1_66634_22234# a_64549_20015# 0 $ **FLOATING
C945 m1_66478_22218# a_64549_20015# 0 $ **FLOATING
C946 m1_66322_22202# a_64549_20015# 0 $ **FLOATING
C947 m1_65854_22154# a_64549_20015# 0 $ **FLOATING
C948 m1_65730_22110# a_64549_20015# 0 $ **FLOATING
C949 m1_65430_22070# a_64549_20015# 0 $ **FLOATING
C950 m1_65730_22210# a_64549_20015# 0 $ **FLOATING
C951 m1_65430_22170# a_64549_20015# 0 $ **FLOATING
C952 m1_65230_22090# a_64549_20015# 0 $ **FLOATING
C953 m1_64762_22042# a_64549_20015# 0 $ **FLOATING
C954 m1_67310_22530# a_64549_20015# 0 $ **FLOATING
C955 m1_67060_22460# a_64549_20015# 0 $ **FLOATING
C956 m1_66820_22360# a_64549_20015# 0 $ **FLOATING
C957 m1_66634_22390# a_64549_20015# 0 $ **FLOATING
C958 m1_66478_22374# a_64549_20015# 0 $ **FLOATING
C959 m1_66322_22358# a_64549_20015# 0 $ **FLOATING
C960 m1_65854_22310# a_64549_20015# 0 $ **FLOATING
C961 m1_65730_22310# a_64549_20015# 0 $ **FLOATING
C962 m1_65430_22270# a_64549_20015# 0 $ **FLOATING
C963 m1_65230_22246# a_64549_20015# 0 $ **FLOATING
C964 m1_64762_22198# a_64549_20015# 0 $ **FLOATING
C965 m1_67060_22700# a_64549_20015# 0 $ **FLOATING
C966 m1_66820_22600# a_64549_20015# 0 $ **FLOATING
C967 m1_66634_22546# a_64549_20015# 0 $ **FLOATING
C968 m1_66478_22530# a_64549_20015# 0 $ **FLOATING
C969 m1_66322_22514# a_64549_20015# 0 $ **FLOATING
C970 m1_65854_22466# a_64549_20015# 0 $ **FLOATING
C971 m1_65730_22410# a_64549_20015# 0 $ **FLOATING
C972 m1_65430_22370# a_64549_20015# 0 $ **FLOATING
C973 m1_65730_22510# a_64549_20015# 0 $ **FLOATING
C974 m1_65430_22470# a_64549_20015# 0 $ **FLOATING
C975 m1_65230_22402# a_64549_20015# 0 $ **FLOATING
C976 m1_64762_22354# a_64549_20015# 0 $ **FLOATING
C977 m1_66634_22702# a_64549_20015# 0 $ **FLOATING
C978 m1_66478_22686# a_64549_20015# 0 $ **FLOATING
C979 m1_66322_22670# a_64549_20015# 0 $ **FLOATING
C980 m1_65854_22622# a_64549_20015# 0 $ **FLOATING
C981 m1_65730_22610# a_64549_20015# 0 $ **FLOATING
C982 m1_65430_22570# a_64549_20015# 0 $ **FLOATING
C983 m1_65730_22710# a_64549_20015# 0 $ **FLOATING
C984 m1_65430_22670# a_64549_20015# 0 $ **FLOATING
C985 m1_65230_22558# a_64549_20015# 0 $ **FLOATING
C986 m1_64762_22510# a_64549_20015# 0 $ **FLOATING
C987 m1_67430_22970# a_64549_20015# 0 $ **FLOATING
C988 m1_67330_22990# a_64549_20015# 0 $ **FLOATING
C989 m1_67310_23090# a_64549_20015# 0 $ **FLOATING
C990 m1_67060_22940# a_64549_20015# 0 $ **FLOATING
C991 m1_66820_22840# a_64549_20015# 0 $ **FLOATING
C992 m1_66634_22858# a_64549_20015# 0 $ **FLOATING
C993 m1_66478_22842# a_64549_20015# 0 $ **FLOATING
C994 m1_66322_22826# a_64549_20015# 0 $ **FLOATING
C995 m1_65854_22778# a_64549_20015# 0 $ **FLOATING
C996 m1_65730_22810# a_64549_20015# 0 $ **FLOATING
C997 m1_65430_22770# a_64549_20015# 0 $ **FLOATING
C998 m1_65230_22714# a_64549_20015# 0 $ **FLOATING
C999 m1_64762_22666# a_64549_20015# 0 $ **FLOATING
C1000 m1_67060_23180# a_64549_20015# 0 $ **FLOATING
C1001 m1_66820_23080# a_64549_20015# 0 $ **FLOATING
C1002 m1_66634_23014# a_64549_20015# 0 $ **FLOATING
C1003 m1_66478_22998# a_64549_20015# 0 $ **FLOATING
C1004 m1_66322_22982# a_64549_20015# 0 $ **FLOATING
C1005 m1_65854_22934# a_64549_20015# 0 $ **FLOATING
C1006 m1_65730_22910# a_64549_20015# 0 $ **FLOATING
C1007 m1_65430_22870# a_64549_20015# 0 $ **FLOATING
C1008 m1_65730_23010# a_64549_20015# 0 $ **FLOATING
C1009 m1_65430_22970# a_64549_20015# 0 $ **FLOATING
C1010 m1_65230_22870# a_64549_20015# 0 $ **FLOATING
C1011 m1_64762_22822# a_64549_20015# 0 $ **FLOATING
C1012 m1_66634_23170# a_64549_20015# 0 $ **FLOATING
C1013 m1_66478_23154# a_64549_20015# 0 $ **FLOATING
C1014 m1_66322_23138# a_64549_20015# 0 $ **FLOATING
C1015 m1_65854_23090# a_64549_20015# 0 $ **FLOATING
C1016 m1_65730_23110# a_64549_20015# 0 $ **FLOATING
C1017 m1_65430_23070# a_64549_20015# 0 $ **FLOATING
C1018 m1_65230_23026# a_64549_20015# 0 $ **FLOATING
C1019 m1_64762_22978# a_64549_20015# 0 $ **FLOATING
C1020 m1_66322_23294# a_64549_20015# 0 $ **FLOATING
C1021 m1_65854_23246# a_64549_20015# 0 $ **FLOATING
C1022 m1_65730_23210# a_64549_20015# 0 $ **FLOATING
C1023 m1_65430_23170# a_64549_20015# 0 $ **FLOATING
C1024 m1_65430_23270# a_64549_20015# 0 $ **FLOATING
C1025 m1_65230_23182# a_64549_20015# 0 $ **FLOATING
C1026 m1_64762_23134# a_64549_20015# 0 $ **FLOATING
C1027 m1_64762_23290# a_64549_20015# 0 $ **FLOATING
C1028 m1_22018_107202# a_64549_20015# 0 $ **FLOATING
C1029 m1_21830_107200# a_64549_20015# 0 $ **FLOATING
C1030 m1_21394_107200# a_64549_20015# 0 $ **FLOATING
C1031 m1_21830_107290# a_64549_20015# 0 $ **FLOATING
C1032 m1_22018_107358# a_64549_20015# 0 $ **FLOATING
C1033 m1_21830_107390# a_64549_20015# 0 $ **FLOATING
C1034 m1_21394_107294# a_64549_20015# 0 $ **FLOATING
C1035 m1_22018_107514# a_64549_20015# 0 $ **FLOATING
C1036 m1_21830_107490# a_64549_20015# 0 $ **FLOATING
C1037 m1_21830_107590# a_64549_20015# 0 $ **FLOATING
C1038 m1_21394_107450# a_64549_20015# 0 $ **FLOATING
C1039 m1_20770_107230# a_64549_20015# 0 $ **FLOATING
C1040 m1_20614_107214# a_64549_20015# 0 $ **FLOATING
C1041 m1_21172_107500# a_64549_20015# 1.31212e-16
C1042 m1_20770_107386# a_64549_20015# 0 $ **FLOATING
C1043 m1_20614_107370# a_64549_20015# 0 $ **FLOATING
C1044 m1_22018_107670# a_64549_20015# 0 $ **FLOATING
C1045 m1_21830_107690# a_64549_20015# 0 $ **FLOATING
C1046 m1_21394_107606# a_64549_20015# 0 $ **FLOATING
C1047 m1_20770_107542# a_64549_20015# 0 $ **FLOATING
C1048 m1_20614_107526# a_64549_20015# 0 $ **FLOATING
C1049 m1_22018_107826# a_64549_20015# 0 $ **FLOATING
C1050 m1_21830_107790# a_64549_20015# 0 $ **FLOATING
C1051 m1_21394_107762# a_64549_20015# 0 $ **FLOATING
C1052 m1_21238_107746# a_64549_20015# 0 $ **FLOATING
C1053 m1_20770_107698# a_64549_20015# 0 $ **FLOATING
C1054 m1_20614_107682# a_64549_20015# 0 $ **FLOATING
C1055 m1_21830_107890# a_64549_20015# 0 $ **FLOATING
C1056 m1_22018_107982# a_64549_20015# 0 $ **FLOATING
C1057 m1_21830_107990# a_64549_20015# 0 $ **FLOATING
C1058 m1_21394_107918# a_64549_20015# 0 $ **FLOATING
C1059 m1_21238_107902# a_64549_20015# 0 $ **FLOATING
C1060 m1_20770_107854# a_64549_20015# 0 $ **FLOATING
C1061 m1_20614_107838# a_64549_20015# 0 $ **FLOATING
C1062 m1_22018_108138# a_64549_20015# 0 $ **FLOATING
C1063 m1_21830_108090# a_64549_20015# 0 $ **FLOATING
C1064 m1_21830_108190# a_64549_20015# 0 $ **FLOATING
C1065 m1_21394_108074# a_64549_20015# 0 $ **FLOATING
C1066 m1_21238_108058# a_64549_20015# 0 $ **FLOATING
C1067 m1_20770_108010# a_64549_20015# 0 $ **FLOATING
C1068 m1_20614_107994# a_64549_20015# 0 $ **FLOATING
C1069 m1_22018_108294# a_64549_20015# 0 $ **FLOATING
C1070 m1_21830_108290# a_64549_20015# 0 $ **FLOATING
C1071 m1_21394_108230# a_64549_20015# 0 $ **FLOATING
C1072 m1_21238_108214# a_64549_20015# 0 $ **FLOATING
C1073 m1_20770_108166# a_64549_20015# 0 $ **FLOATING
C1074 m1_20614_108150# a_64549_20015# 0 $ **FLOATING
C1075 m1_21830_108390# a_64549_20015# 0 $ **FLOATING
C1076 m1_22018_108450# a_64549_20015# 0 $ **FLOATING
C1077 m1_21830_108490# a_64549_20015# 0 $ **FLOATING
C1078 m1_21394_108386# a_64549_20015# 0 $ **FLOATING
C1079 m1_21238_108370# a_64549_20015# 0 $ **FLOATING
C1080 m1_20770_108322# a_64549_20015# 0 $ **FLOATING
C1081 m1_20614_108306# a_64549_20015# 0 $ **FLOATING
C1082 m1_22018_108606# a_64549_20015# 0 $ **FLOATING
C1083 m1_21830_108590# a_64549_20015# 0 $ **FLOATING
C1084 m1_21394_108542# a_64549_20015# 0 $ **FLOATING
C1085 m1_21238_108526# a_64549_20015# 0 $ **FLOATING
C1086 m1_20770_108478# a_64549_20015# 0 $ **FLOATING
C1087 m1_20614_108462# a_64549_20015# 0 $ **FLOATING
C1088 m1_21830_108690# a_64549_20015# 0 $ **FLOATING
C1089 m1_22018_108762# a_64549_20015# 0 $ **FLOATING
C1090 m1_21830_108790# a_64549_20015# 0 $ **FLOATING
C1091 m1_22018_108918# a_64549_20015# 0 $ **FLOATING
C1092 m1_21830_108890# a_64549_20015# 0 $ **FLOATING
C1093 m1_21830_108990# a_64549_20015# 0 $ **FLOATING
C1094 m1_22018_109074# a_64549_20015# 0 $ **FLOATING
C1095 m1_21830_109090# a_64549_20015# 0 $ **FLOATING
C1096 m1_21394_108698# a_64549_20015# 0 $ **FLOATING
C1097 m1_21238_108682# a_64549_20015# 0 $ **FLOATING
C1098 m1_21394_108854# a_64549_20015# 0 $ **FLOATING
C1099 m1_21238_108838# a_64549_20015# 0 $ **FLOATING
C1100 m1_21394_109010# a_64549_20015# 0 $ **FLOATING
C1101 m1_21238_108994# a_64549_20015# 0 $ **FLOATING
C1102 m1_22018_109230# a_64549_20015# 0 $ **FLOATING
C1103 m1_21830_109190# a_64549_20015# 0 $ **FLOATING
C1104 m1_21394_109166# a_64549_20015# 0 $ **FLOATING
C1105 m1_21238_109150# a_64549_20015# 0 $ **FLOATING
C1106 m1_21830_109290# a_64549_20015# 0 $ **FLOATING
C1107 m1_22018_109386# a_64549_20015# 0 $ **FLOATING
C1108 m1_21830_109390# a_64549_20015# 0 $ **FLOATING
C1109 m1_21394_109322# a_64549_20015# 0 $ **FLOATING
C1110 m1_21238_109306# a_64549_20015# 0 $ **FLOATING
C1111 m1_22018_109542# a_64549_20015# 0 $ **FLOATING
C1112 m1_21830_109490# a_64549_20015# 0 $ **FLOATING
C1113 m1_21394_109478# a_64549_20015# 0 $ **FLOATING
C1114 m1_21238_109462# a_64549_20015# 0 $ **FLOATING
C1115 m1_22018_109698# a_64549_20015# 0 $ **FLOATING
C1116 m1_21862_109682# a_64549_20015# 0 $ **FLOATING
C1117 m1_21706_109666# a_64549_20015# 0 $ **FLOATING
C1118 m1_21550_109650# a_64549_20015# 0 $ **FLOATING
C1119 m1_21394_109634# a_64549_20015# 0 $ **FLOATING
C1120 m1_21238_109618# a_64549_20015# 0 $ **FLOATING
C1121 m1_20770_108634# a_64549_20015# 0 $ **FLOATING
C1122 m1_20614_108618# a_64549_20015# 0 $ **FLOATING
C1123 m1_20770_108790# a_64549_20015# 0 $ **FLOATING
C1124 m1_20614_108774# a_64549_20015# 0 $ **FLOATING
C1125 m1_20770_108946# a_64549_20015# 0 $ **FLOATING
C1126 m1_20614_108930# a_64549_20015# 0 $ **FLOATING
C1127 m1_20770_109102# a_64549_20015# 0 $ **FLOATING
C1128 m1_20614_109086# a_64549_20015# 0 $ **FLOATING
C1129 m1_20770_109258# a_64549_20015# 0 $ **FLOATING
C1130 m1_20614_109242# a_64549_20015# 0 $ **FLOATING
C1131 m1_20770_109414# a_64549_20015# 0 $ **FLOATING
C1132 m1_20614_109398# a_64549_20015# 0 $ **FLOATING
C1133 m1_20770_109570# a_64549_20015# 0 $ **FLOATING
C1134 m1_20614_109554# a_64549_20015# 0 $ **FLOATING
C1135 m1_20430_109570# a_64549_20015# 0 $ **FLOATING
C1136 m1_20330_109590# a_64549_20015# 0 $ **FLOATING
C1137 m1_20458_109694# a_64549_20015# 0 $ **FLOATING
C1138 m1_20330_109690# a_64549_20015# 0 $ **FLOATING
C1139 m1_20222_107200# a_64549_20015# 3.5300800000000001e-16
C1140 m1_20136_108556# a_64549_20015# 3.7989600000000005e-16
C1141 m1_20030_108750# a_64549_20015# 0 $ **FLOATING
C1142 m1_20000_108866# a_64549_20015# 0 $ **FLOATING
C1143 m1_20000_109022# a_64549_20015# 0 $ **FLOATING
C1144 m1_20000_109178# a_64549_20015# 0 $ **FLOATING
C1145 m1_20000_109334# a_64549_20015# 0 $ **FLOATING
C1146 m1_20000_109490# a_64549_20015# 0 $ **FLOATING
C1147 m1_20000_109646# a_64549_20015# 0 $ **FLOATING
C1148 li_66860_20030# a_64549_20015# 0 $ **FLOATING
C1149 li_66634_20078# a_64549_20015# 0 $ **FLOATING
C1150 li_66418_20002# a_64549_20015# 0 $ **FLOATING
C1151 li_66634_20294# a_64549_20015# 0 $ **FLOATING
C1152 li_66418_20218# a_64549_20015# 0 $ **FLOATING
C1153 li_66634_20510# a_64549_20015# 0 $ **FLOATING
C1154 li_66418_20434# a_64549_20015# 0 $ **FLOATING
C1155 li_66860_20810# a_64549_20015# 0 $ **FLOATING
C1156 li_66634_20726# a_64549_20015# 0 $ **FLOATING
C1157 li_66418_20650# a_64549_20015# 0 $ **FLOATING
C1158 li_66634_20942# a_64549_20015# 0 $ **FLOATING
C1159 li_66418_20866# a_64549_20015# 0 $ **FLOATING
C1160 li_66634_21158# a_64549_20015# 0 $ **FLOATING
C1161 li_66418_21082# a_64549_20015# 0 $ **FLOATING
C1162 li_66634_21374# a_64549_20015# 0 $ **FLOATING
C1163 li_66418_21298# a_64549_20015# 0 $ **FLOATING
C1164 li_66860_21590# a_64549_20015# 0 $ **FLOATING
C1165 li_66634_21590# a_64549_20015# 0 $ **FLOATING
C1166 li_66418_21514# a_64549_20015# 0 $ **FLOATING
C1167 li_66634_21806# a_64549_20015# 0 $ **FLOATING
C1168 li_66418_21730# a_64549_20015# 0 $ **FLOATING
C1169 li_66634_22022# a_64549_20015# 0 $ **FLOATING
C1170 li_66418_21946# a_64549_20015# 0 $ **FLOATING
C1171 li_66634_22238# a_64549_20015# 0 $ **FLOATING
C1172 li_66418_22162# a_64549_20015# 0 $ **FLOATING
C1173 li_66860_22370# a_64549_20015# 0 $ **FLOATING
C1174 li_66634_22454# a_64549_20015# 0 $ **FLOATING
C1175 li_66418_22378# a_64549_20015# 0 $ **FLOATING
C1176 li_66634_22670# a_64549_20015# 0 $ **FLOATING
C1177 li_66418_22594# a_64549_20015# 0 $ **FLOATING
C1178 li_66634_22886# a_64549_20015# 0 $ **FLOATING
C1179 li_66418_22810# a_64549_20015# 0 $ **FLOATING
C1180 li_66860_23150# a_64549_20015# 0 $ **FLOATING
C1181 li_66634_23102# a_64549_20015# 0 $ **FLOATING
C1182 li_66418_23026# a_64549_20015# 0 $ **FLOATING
C1183 li_66418_23242# a_64549_20015# 0 $ **FLOATING
C1184 li_22138_107238# a_64549_20015# 0 $ **FLOATING
C1185 li_21922_107200# a_64549_20015# 0 $ **FLOATING
C1186 li_21274_107200# a_64549_20015# 0 $ **FLOATING
C1187 li_20626_107200# a_64549_20015# 0 $ **FLOATING
C1188 li_22138_107454# a_64549_20015# 0 $ **FLOATING
C1189 li_21922_107378# a_64549_20015# 0 $ **FLOATING
C1190 li_21274_107366# a_64549_20015# 0 $ **FLOATING
C1191 li_20000_107200# a_64549_20015# 0 $ **FLOATING
C1192 li_22138_107670# a_64549_20015# 0 $ **FLOATING
C1193 li_21922_107594# a_64549_20015# 0 $ **FLOATING
C1194 li_20626_107354# a_64549_20015# 0 $ **FLOATING
C1195 li_20000_107342# a_64549_20015# 0 $ **FLOATING
C1196 li_21274_107582# a_64549_20015# 0 $ **FLOATING
C1197 li_20626_107570# a_64549_20015# 0 $ **FLOATING
C1198 li_22138_107886# a_64549_20015# 0 $ **FLOATING
C1199 li_21922_107810# a_64549_20015# 0 $ **FLOATING
C1200 li_20000_107558# a_64549_20015# 0 $ **FLOATING
C1201 li_21274_107798# a_64549_20015# 0 $ **FLOATING
C1202 li_22138_108102# a_64549_20015# 0 $ **FLOATING
C1203 li_21922_108026# a_64549_20015# 0 $ **FLOATING
C1204 li_20626_107786# a_64549_20015# 0 $ **FLOATING
C1205 li_21274_108014# a_64549_20015# 0 $ **FLOATING
C1206 li_20000_107774# a_64549_20015# 0 $ **FLOATING
C1207 li_20626_108002# a_64549_20015# 0 $ **FLOATING
C1208 li_20000_107990# a_64549_20015# 0 $ **FLOATING
C1209 li_22354_108826# a_64549_20015# 0 $ **FLOATING
C1210 li_22354_109042# a_64549_20015# 0 $ **FLOATING
C1211 li_22138_108966# a_64549_20015# 0 $ **FLOATING
C1212 li_21922_108890# a_64549_20015# 0 $ **FLOATING
C1213 li_21706_108814# a_64549_20015# 0 $ **FLOATING
C1214 li_21922_109106# a_64549_20015# 0 $ **FLOATING
C1215 li_21706_109030# a_64549_20015# 0 $ **FLOATING
C1216 li_21490_108954# a_64549_20015# 0 $ **FLOATING
C1217 li_21274_108878# a_64549_20015# 0 $ **FLOATING
C1218 li_21058_108802# a_64549_20015# 0 $ **FLOATING
C1219 li_22050_109330# a_64549_20015# 0 $ **FLOATING
C1220 li_21706_109246# a_64549_20015# 0 $ **FLOATING
C1221 li_21490_109170# a_64549_20015# 0 $ **FLOATING
C1222 li_21274_109094# a_64549_20015# 0 $ **FLOATING
C1223 li_21058_109018# a_64549_20015# 0 $ **FLOATING
C1224 li_20842_108942# a_64549_20015# 0 $ **FLOATING
C1225 li_20626_108866# a_64549_20015# 0 $ **FLOATING
C1226 li_20410_108790# a_64549_20015# 0 $ **FLOATING
C1227 li_20842_109158# a_64549_20015# 0 $ **FLOATING
C1228 li_20626_109082# a_64549_20015# 0 $ **FLOATING
C1229 li_20410_109006# a_64549_20015# 0 $ **FLOATING
C1230 li_20194_108930# a_64549_20015# 0 $ **FLOATING
C1231 li_20000_108854# a_64549_20015# 0 $ **FLOATING
C1232 li_20410_109222# a_64549_20015# 0 $ **FLOATING
C1233 li_20194_109146# a_64549_20015# 0 $ **FLOATING
C1234 li_20000_109070# a_64549_20015# 0 $ **FLOATING
C1235 li_20000_109286# a_64549_20015# 0 $ **FLOATING
C1236 li_21650_109470# a_64549_20015# 0 $ **FLOATING
C1237 li_20840_109410# a_64549_20015# 0 $ **FLOATING
C1238 li_20060_109550# a_64549_20015# 0 $ **FLOATING
C1239 a_66936_20000# a_64549_20015# 0 $ **FLOATING
C1240 a_66620_20000# a_64549_20015# 0 $ **FLOATING
C1241 a_66404_20000# a_64549_20015# 0 $ **FLOATING
C1242 a_67404_20152# a_64549_20015# 0 $ **FLOATING
C1243 a_67216_20142# a_64549_20015# 0 $ **FLOATING
C1244 a_67036_20190# a_64549_20015# 0 $ **FLOATING
C1245 a_66620_20156# a_64549_20015# 0 $ **FLOATING
C1246 a_66404_20204# a_64549_20015# 0 $ **FLOATING
C1247 a_66936_20372# a_64549_20015# 0 $ **FLOATING
C1248 a_66620_20372# a_64549_20015# 0 $ **FLOATING
C1249 a_66404_20420# a_64549_20015# 0 $ **FLOATING
C1250 a_66620_20588# a_64549_20015# 0 $ **FLOATING
C1251 a_66404_20636# a_64549_20015# 0 $ **FLOATING
C1252 a_66620_20804# a_64549_20015# 0 $ **FLOATING
C1253 a_66404_20852# a_64549_20015# 0 $ **FLOATING
C1254 a_66620_21020# a_64549_20015# 0 $ **FLOATING
C1255 a_66404_21068# a_64549_20015# 0 $ **FLOATING
C1256 a_67484_21260# a_64549_20015# 0 $ **FLOATING
C1257 a_67036_21270# a_64549_20015# 0 $ **FLOATING
C1258 a_66856_21318# a_64549_20015# 0 $ **FLOATING
C1259 a_66620_21236# a_64549_20015# 0 $ **FLOATING
C1260 a_66404_21284# a_64549_20015# 0 $ **FLOATING
C1261 a_66936_21508# a_64549_20015# 0 $ **FLOATING
C1262 a_66620_21452# a_64549_20015# 0 $ **FLOATING
C1263 a_66404_21500# a_64549_20015# 0 $ **FLOATING
C1264 a_66620_21668# a_64549_20015# 0 $ **FLOATING
C1265 a_64400_20000# a_64549_20015# 2.2618000000000006e-16 $ **FLOATING
C1266 a_66404_21716# a_64549_20015# 0 $ **FLOATING
C1267 a_66620_21884# a_64549_20015# 0 $ **FLOATING
C1268 a_66404_21932# a_64549_20015# 0 $ **FLOATING
C1269 a_66620_22100# a_64549_20015# 0 $ **FLOATING
C1270 a_66404_22148# a_64549_20015# 0 $ **FLOATING
C1271 a_67576_22386# a_64549_20015# 0 $ **FLOATING
C1272 a_67268_22388# a_64549_20015# 0 $ **FLOATING
C1273 a_67052_22436# a_64549_20015# 0 $ **FLOATING
C1274 a_66856_22398# a_64549_20015# 0 $ **FLOATING
C1275 a_66620_22316# a_64549_20015# 0 $ **FLOATING
C1276 a_66404_22364# a_64549_20015# 0 $ **FLOATING
C1277 a_66936_22644# a_64549_20015# 0 $ **FLOATING
C1278 a_66620_22532# a_64549_20015# 0 $ **FLOATING
C1279 a_66404_22580# a_64549_20015# 0 $ **FLOATING
C1280 a_66620_22748# a_64549_20015# 0 $ **FLOATING
C1281 a_66404_22796# a_64549_20015# 0 $ **FLOATING
C1282 a_66620_22964# a_64549_20015# 0 $ **FLOATING
C1283 a_66404_23012# a_64549_20015# 0 $ **FLOATING
C1284 a_64400_20751# a_64549_20015# 3.0544800000000003e-16 $ **FLOATING
C1285 a_66620_23180# a_64549_20015# 0 $ **FLOATING
C1286 a_66404_23228# a_64549_20015# 0 $ **FLOATING
C1287 a_64400_22039# a_64549_20015# 9.5162400000000014e-17 $ **FLOATING
C1288 a_64400_22591# a_64549_20015# 2.3011199999999999e-16 $ **FLOATING
C1289 a_22430_108402# a_64549_20015# 3.4029800000000001e-18 $ **FLOATING
C1290 a_20068_108389# a_64549_20015# 2.6014299999999998e-16 $ **FLOATING
C1291 a_21763_108389# a_64549_20015# 1.3333199999999999e-15 $ **FLOATING
C1292 a_20000_108402# a_64549_20015# 3.6434400000000007e-15 $ **FLOATING
C1293 a_20431_108389# a_64549_20015# 1.0774900000000001e-15 $ **FLOATING
C1294 a_22124_108884# a_64549_20015# 0 $ **FLOATING
C1295 a_22340_109052# a_64549_20015# 0 $ **FLOATING
C1296 a_21908_108932# a_64549_20015# 0 $ **FLOATING
C1297 a_22124_109100# a_64549_20015# 0 $ **FLOATING
C1298 a_21692_108980# a_64549_20015# 0 $ **FLOATING
C1299 a_21260_108860# a_64549_20015# 0 $ **FLOATING
C1300 a_22340_109268# a_64549_20015# 0 $ **FLOATING
C1301 a_21908_109148# a_64549_20015# 0 $ **FLOATING
C1302 a_21476_109028# a_64549_20015# 0 $ **FLOATING
C1303 a_21044_108908# a_64549_20015# 0 $ **FLOATING
C1304 a_22124_109316# a_64549_20015# 0 $ **FLOATING
C1305 a_21692_109196# a_64549_20015# 0 $ **FLOATING
C1306 a_21260_109076# a_64549_20015# 0 $ **FLOATING
C1307 a_20828_108956# a_64549_20015# 0 $ **FLOATING
C1308 a_22396_109494# a_64549_20015# 0 $ **FLOATING
C1309 a_21908_109364# a_64549_20015# 0 $ **FLOATING
C1310 a_21476_109244# a_64549_20015# 0 $ **FLOATING
C1311 a_21044_109124# a_64549_20015# 0 $ **FLOATING
C1312 a_20612_109004# a_64549_20015# 0 $ **FLOATING
C1313 a_20180_108884# a_64549_20015# 0 $ **FLOATING
C1314 a_21692_109412# a_64549_20015# 0 $ **FLOATING
C1315 a_21260_109292# a_64549_20015# 0 $ **FLOATING
C1316 a_20828_109172# a_64549_20015# 0 $ **FLOATING
C1317 a_20396_109052# a_64549_20015# 0 $ **FLOATING
C1318 a_21044_109340# a_64549_20015# 0 $ **FLOATING
C1319 a_20612_109220# a_64549_20015# 0 $ **FLOATING
C1320 a_20180_109100# a_64549_20015# 0 $ **FLOATING
C1321 a_22396_109674# a_64549_20015# 0 $ **FLOATING
C1322 a_21496_109636# a_64549_20015# 0 $ **FLOATING
C1323 a_21260_109508# a_64549_20015# 0 $ **FLOATING
C1324 a_20828_109388# a_64549_20015# 0 $ **FLOATING
C1325 a_20396_109268# a_64549_20015# 0 $ **FLOATING
C1326 a_21044_109556# a_64549_20015# 0 $ **FLOATING
C1327 a_20612_109436# a_64549_20015# 0 $ **FLOATING
C1328 a_20180_109316# a_64549_20015# 0 $ **FLOATING
C1329 a_20828_109604# a_64549_20015# 0 $ **FLOATING
C1330 a_20396_109484# a_64549_20015# 0 $ **FLOATING
C1331 a_20612_109652# a_64549_20015# 0 $ **FLOATING
C1332 a_20180_109532# a_64549_20015# 0 $ **FLOATING
C1333 a_20000_109044# a_64549_20015# 0 $ **FLOATING
C1334 w_65333_20000# a_64549_20015# 2.1809099999999999e-14 $ **FLOATING
C1335 w_64364_19964# a_64549_20015# 1.3847000000000001e-14 $ **FLOATING
C1336 w_22048_107200# a_64549_20015# 2.0932100000000003e-15 $ **FLOATING
C1337 w_20716_107200# a_64549_20015# 3.0500900000000002e-15 $ **FLOATING
C1338 w_20000_107200# a_64549_20015# 2.3743199999999998e-16
C1339 a_64549_20015# a_64549_20015# 0 $ **FLOATING
.ends
