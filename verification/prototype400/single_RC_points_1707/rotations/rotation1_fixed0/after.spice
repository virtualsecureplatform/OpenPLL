* NGSPICE file created from RotatedCrop.ext - technology: sky130A

.subckt RotatedCrop
* OPENPLL_ORIGIN X0 sky130_fd_pr__nfet_01v8 22371 108003 22372 108004
X0 a_21487_106400.t23 w_21701_106400.t22 a_21487_106400.t21 a_21487_106400.t21 sky130_fd_pr__nfet_01v8 ad=0.143 pd=1.62 as=0 ps=0 w=0.55 l=4.73
* OPENPLL_ORIGIN X1 sky130_fd_pr__nfet_01v8 22371 109107 22372 109108
X1 a_21487_106400.t28 w_21701_106400.t20 a_21487_106400.t27 a_21487_106400.t27 sky130_fd_pr__nfet_01v8 ad=0.143 pd=1.62 as=0 ps=0 w=0.55 l=2.69
* OPENPLL_ORIGIN X2 sky130_fd_pr__pfet_01v8_hvt 21763 106531 21764 106532
X2 w_21701_106400.t15 a_21487_106400.t40 w_21701_106400.t13 w_21701_106400.t13 sky130_fd_pr__pfet_01v8_hvt ad=0.2262 pd=2.26 as=0 ps=0 w=0.87 l=4.73
* OPENPLL_ORIGIN X3 sky130_fd_pr__pfet_01v8_hvt 21763 107635 21764 107636
X3 w_21701_106400.t7 a_21487_106400.t39 w_21701_106400.t5 w_21701_106400.t5 sky130_fd_pr__pfet_01v8_hvt ad=0.2262 pd=2.26 as=0 ps=0 w=0.87 l=0.59
* OPENPLL_ORIGIN X4 sky130_fd_pr__pfet_01v8_hvt 22031 106400 22032 106401
X4 w_21701_106400.t17 a_21487_106400.t43 w_21701_106400.t16 w_21701_106400.t16 sky130_fd_pr__pfet_01v8_hvt ad=0.2262 pd=2.26 as=0 ps=0 w=0.87 l=3.11
* OPENPLL_ORIGIN X5 sky130_fd_pr__nfet_01v8_lvt 67301 21111 67302 21112
X5 a_65266_21098.t7 a_67263_21111# a_65266_21098.t6 a_21487_106400.t33 sky130_fd_pr__nfet_01v8_lvt ad=0.1197 pd=1.41 as=0 ps=0 w=0.42 l=1
* OPENPLL_ORIGIN X6 sky130_fd_pr__nfet_01v8 21487 107635 21488 107636
X6 a_21487_106400.t20 w_21701_106400.t23 a_21487_106400.t18 a_21487_106400.t18 sky130_fd_pr__nfet_01v8 ad=0.143 pd=1.62 as=0 ps=0 w=0.55 l=0.59
* OPENPLL_ORIGIN X7 sky130_fd_pr__nfet_01v8 21487 106531 21488 106532
X7 a_21487_106400.t17 w_21701_106400.t24 a_21487_106400.t15 a_21487_106400.t15 sky130_fd_pr__nfet_01v8 ad=0.143 pd=1.62 as=0 ps=0 w=0.55 l=4.73
* OPENPLL_ORIGIN X8 sky130_fd_pr__pfet_01v8 66276 21098 66277 21099
X8 a_65931_21111.t3 a_65266_21098.t9 a_65931_21111.t2 w_66216_20978.t1 sky130_fd_pr__pfet_01v8 ad=0.285 pd=2.57 as=0 ps=0 w=1 l=1
* OPENPLL_ORIGIN X9 sky130_fd_pr__pfet_01v8_hvt 21763 109107 21764 109108
X9 w_21701_106400.t9 a_21487_106400.t34 w_21701_106400.t8 w_21701_106400.t8 sky130_fd_pr__pfet_01v8_hvt ad=0.2262 pd=2.26 as=0 ps=0 w=0.87 l=2.53
* OPENPLL_ORIGIN X10 sky130_fd_pr__pfet_01v8_hvt 21763 108003 21764 108004
X10 w_21701_106400.t4 a_21487_106400.t36 w_21701_106400.t0 w_21701_106400.t0 sky130_fd_pr__pfet_01v8_hvt ad=0.2262 pd=2.26 as=0 ps=0 w=0.87 l=4.73
* OPENPLL_ORIGIN X11 sky130_fd_pr__nfet_01v8 21487 108003 21488 108004
X11 a_21487_106400.t26 w_21701_106400.t21 a_21487_106400.t24 a_21487_106400.t24 sky130_fd_pr__nfet_01v8 ad=0.143 pd=1.62 as=0 ps=0 w=0.55 l=4.73
* OPENPLL_ORIGIN X12 sky130_fd_pr__pfet_01v8_hvt 22031 107267 22032 107268
X12 w_21701_106400.t12 a_21487_106400.t41 w_21701_106400.t10 w_21701_106400.t10 sky130_fd_pr__pfet_01v8_hvt ad=0.2262 pd=2.26 as=0 ps=0 w=0.87 l=1.97
* OPENPLL_ORIGIN X13 sky130_fd_pr__nfet_01v8 21487 109107 21488 109108
X13 a_21487_106400.t30 w_21701_106400.t19 a_21487_106400.t29 a_21487_106400.t29 sky130_fd_pr__nfet_01v8 ad=0.143 pd=1.62 as=0 ps=0 w=0.55 l=2.69
* OPENPLL_ORIGIN X14 sky130_fd_pr__pfet_01v8_hvt 22031 108003 22032 108004
X14 w_21701_106400.t2 a_21487_106400.t37 w_21701_106400.t0 w_21701_106400.t0 sky130_fd_pr__pfet_01v8_hvt ad=0.2262 pd=2.26 as=0 ps=0 w=0.87 l=4.73
* OPENPLL_ORIGIN X15 sky130_fd_pr__pfet_01v8_hvt 22031 109107 22032 109108
X15 w_21701_106400.t18 a_21487_106400.t35 w_21701_106400.t8 w_21701_106400.t8 sky130_fd_pr__pfet_01v8_hvt ad=0.2262 pd=2.26 as=0 ps=0 w=0.87 l=2.53
* OPENPLL_ORIGIN X16 sky130_fd_pr__nfet_01v8_lvt 65715 21111 65716 21112
X16 a_65266_21098.t1 a_65100_21043.t4 a_65266_21098.t0 a_21487_106400.t0 sky130_fd_pr__nfet_01v8_lvt ad=0.1197 pd=1.41 as=0 ps=0 w=0.42 l=1
* OPENPLL_ORIGIN X17 sky130_fd_pr__pfet_01v8_hvt 23119 106400 23120 106401
X17 w_22789_106400.t7 a_23093_106400# w_22789_106400.t6 w_22789_106400.t6 sky130_fd_pr__pfet_01v8_hvt ad=0.1053 pd=1.33 as=0 ps=0 w=0.405 l=1.57
* OPENPLL_ORIGIN X18 sky130_fd_pr__pfet_01v8 66624 21098 66625 21099
X18 a_65931_21111.t1 a_65266_21098.t10 a_65931_21111.t0 w_66216_20978.t0 sky130_fd_pr__pfet_01v8 ad=0.285 pd=2.57 as=0 ps=0 w=1 l=1
* OPENPLL_ORIGIN X19 sky130_fd_pr__nfet_01v8_lvt 67047 21111 67048 21112
X19 a_65266_21098.t3 a_65931_21111.t5 a_65266_21098.t2 a_21487_106400.t31 sky130_fd_pr__nfet_01v8_lvt ad=0.1197 pd=1.41 as=0 ps=0 w=0.42 l=1
* OPENPLL_ORIGIN X20 sky130_fd_pr__pfet_01v8_hvt 23119 107267 23120 107268
X20 w_22789_106400.t13 a_23093_107267# w_22789_106400.t11 w_22789_106400.t11 sky130_fd_pr__pfet_01v8_hvt ad=0.1053 pd=1.33 as=0 ps=0 w=0.405 l=1.97
* OPENPLL_ORIGIN X21 sky130_fd_pr__pfet_01v8_hvt 23119 109107 23120 109108
X21 w_22789_106400.t18 a_23093_109107# w_22789_106400.t17 w_22789_106400.t17 sky130_fd_pr__pfet_01v8_hvt ad=0.1053 pd=1.33 as=0 ps=0 w=0.405 l=1.28
* OPENPLL_ORIGIN X22 sky130_fd_pr__pfet_01v8_hvt 23119 108003 23120 108004
X22 w_22789_106400.t5 a_23093_108003# w_22789_106400.t3 w_22789_106400.t3 sky130_fd_pr__pfet_01v8_hvt ad=0.1053 pd=1.33 as=0 ps=0 w=0.405 l=4.73
* OPENPLL_ORIGIN X23 sky130_fd_pr__pfet_01v8 65100 21098 65101 21099
X23 a_65100_21043.t1 a_65100_21098# a_65100_21043.t0 w_65064_21062.t0 sky130_fd_pr__pfet_01v8 ad=0.0627 pd=1.01 as=0 ps=0 w=0.22 l=1
* OPENPLL_ORIGIN X24 sky130_fd_pr__nfet_01v8_lvt 65969 21111 65970 21112
X24 a_65266_21098.t5 a_65931_21111.t4 a_65266_21098.t4 a_21487_106400.t32 sky130_fd_pr__nfet_01v8_lvt ad=0.1197 pd=1.41 as=0 ps=0 w=0.42 l=1
* OPENPLL_ORIGIN X25 sky130_fd_pr__nfet_01v8 22371 106400 22372 106401
X25 a_21487_106400.t11 w_21701_106400.t26 a_21487_106400.t10 a_21487_106400.t10 sky130_fd_pr__nfet_01v8 ad=0.143 pd=1.62 as=0 ps=0 w=0.55 l=3.27
* OPENPLL_ORIGIN X26 sky130_fd_pr__pfet_01v8_hvt 22851 107635 22852 107636
X26 w_22789_106400.t16 a_21487_106400.t42 w_22789_106400.t14 w_22789_106400.t14 sky130_fd_pr__pfet_01v8_hvt ad=0.2262 pd=2.26 as=0 ps=0 w=0.87 l=4.73
* OPENPLL_ORIGIN X27 sky130_fd_pr__pfet_01v8_hvt 22851 106531 22852 106532
X27 w_22789_106400.t10 a_21487_106400.t44 w_22789_106400.t8 w_22789_106400.t8 sky130_fd_pr__pfet_01v8_hvt ad=0.2262 pd=2.26 as=0 ps=0 w=0.87 l=4.73
* OPENPLL_ORIGIN X28 sky130_fd_pr__pfet_01v8 65292 21098 65293 21099
X28 a_65100_21043.t3 a_65266_21098.t8 a_65100_21043.t2 w_65064_21062.t1 sky130_fd_pr__pfet_01v8 ad=0.285 pd=2.57 as=0 ps=0 w=1 l=1
* OPENPLL_ORIGIN X29 sky130_fd_pr__pfet_01v8_hvt 22851 108739 22852 108740
X29 w_22789_106400.t2 a_21487_106400.t38 w_22789_106400.t0 w_22789_106400.t0 sky130_fd_pr__pfet_01v8_hvt ad=0.06525 pd=1.89 as=0 ps=0 w=0.87 l=4.73
* OPENPLL_ORIGIN X30 sky130_fd_pr__nfet_01v8 22575 106531 22576 106532
X30 a_21487_106400.t3 w_22789_106400.t21 a_21487_106400.t1 a_21487_106400.t1 sky130_fd_pr__nfet_01v8 ad=0.143 pd=1.62 as=0 ps=0 w=0.55 l=4.73
* OPENPLL_ORIGIN X31 sky130_fd_pr__nfet_01v8 22575 108739 22576 108740
X31 a_21487_106400.t9 w_22789_106400.t19 a_21487_106400.t7 a_21487_106400.t7 sky130_fd_pr__nfet_01v8 ad=0.04125 pd=1.25 as=0 ps=0 w=0.55 l=4.73
* OPENPLL_ORIGIN X32 sky130_fd_pr__nfet_01v8 22371 107267 22372 107268
X32 a_21487_106400.t14 w_21701_106400.t25 a_21487_106400.t12 a_21487_106400.t12 sky130_fd_pr__nfet_01v8 ad=0.143 pd=1.62 as=0 ps=0 w=0.55 l=1.97
* OPENPLL_ORIGIN X33 sky130_fd_pr__nfet_01v8 22575 107635 22576 107636
X33 a_21487_106400.t6 w_22789_106400.t20 a_21487_106400.t4 a_21487_106400.t4 sky130_fd_pr__nfet_01v8 ad=0.143 pd=1.62 as=0 ps=0 w=0.55 l=4.73
C0 a_65100_21043# m3_66000_22226# 1.61041e-18
C1 m4_65100_22426# m2_65100_22346# 2.5023100000000001e-17
C2 a_65266_21098# m3_66000_22226# 2.8119599999999999e-17
C3 a_65100_21043# m1_66376_22136# 6.1075300000000006e-20
C4 a_65266_21098# m1_66376_22136# 1.08716e-16
C5 w_65064_21062# a_65100_21043# 5.3274900000000011e-16
C6 a_65266_21098# w_66216_20978# 4.0230400000000002e-16
C7 a_65266_21098# w_67548_20978# 6.0162100000000004e-17
C8 a_65266_21098# w_65064_21062# 2.0189100000000001e-16
C9 m4_65100_22042# m1_67412_21080# 1.6285e-18
C10 w_22789_106400# a_23093_106400# 3.3554199999999996e-16
C11 a_23093_106400# w_21701_106400# 3.5767900000000004e-18
C12 w_22789_106400# a_23093_107267# 2.1416300000000004e-16
C13 a_23093_107267# w_21701_106400# 4.3139900000000006e-18
C14 m5_66336_20000# m2_65100_22346# 1.2434900000000002e-17
C15 m5_66336_20000# m2_65100_21674# 8.0638400000000022e-18
C16 w_22789_106400# a_23093_108003# 4.4880300000000007e-16
C17 a_23093_108003# w_21701_106400# 4.3139900000000006e-18
C18 w_22789_106400# a_23093_109107# 2.63403e-16
C19 a_23093_109107# w_21701_106400# 4.0955600000000003e-19
C20 a_65100_21043# a_65931_21111# 4.1809300000000004e-17
C21 a_65266_21098# a_65931_21111# 1.2376300000000002e-15
C22 m1_67350_20000# a_67263_21111# 1.7539699999999999e-17
C23 w_65064_21062# a_65100_21098# 5.2726700000000005e-17
C24 m1_67412_21080# m2_65100_22346# 2.4623200000000003e-17
C25 m2_65100_21674# m1_67412_21080# 2.49988e-17
C26 m3_66000_22226# m1_66376_22136# 1.9391000000000001e-17
C27 m4_65100_22426# a_67263_21111# 1.0530900000000002e-19
C28 m3_66000_22226# w_66216_20978# 1.6701200000000002e-17
C29 m3_66000_22226# w_67548_20978# 8.4649000000000005e-19
C30 w_65064_21062# m3_66000_22226# 4.9466100000000001e-18
C31 m4_65100_21658# a_65100_21043# 1.6507000000000003e-17
C32 m4_65100_21658# a_65266_21098# 2.27618e-16
C33 m1_66376_22136# w_67548_20978# 3.2119600000000002e-18
C34 m4_65100_22426# m1_67350_20000# 1.4477500000000001e-18
C35 m1_66376_22136# w_66216_20978# 8.1488200000000022e-17
C36 w_65064_21062# m1_66376_22136# 3.8351200000000004e-19
C37 a_65100_21043# m2_65100_21482# 1.01416e-16
C38 a_65266_21098# m2_65100_21482# 2.3021e-16
C39 w_22789_106400# w_21701_106400# 8.8069700000000004e-16
C40 m5_66336_20000# a_67263_21111# 3.5281500000000001e-19
C41 m5_66336_20000# m1_67350_20000# 2.3707300000000004e-18
C42 m3_66000_22226# a_65931_21111# 1.24753e-17
C43 m1_66376_22136# a_65931_21111# 2.0253100000000003e-16
C44 m4_65100_22426# m5_66336_20000# 1.6045500000000004e-16
C45 a_65931_21111# w_66216_20978# 7.2327600000000002e-16
C46 m4_65100_21658# a_65100_21098# 2.8074700000000005e-19
C47 m1_67412_21080# a_67263_21111# 4.1616900000000002e-17
C48 m2_65100_21482# a_65100_21098# 2.0855700000000003e-18
C49 m4_65100_21658# m3_66000_22226# 2.0485600000000002e-19
C50 m4_65100_22042# a_65100_21043# 9.049500000000001e-18
C51 m4_65100_22042# a_65266_21098# 1.6941400000000004e-17
C52 m1_67350_20000# m1_67412_21080# 6.5872900000000004e-16
C53 m4_65100_21658# m1_66376_22136# 4.7e-19
C54 m2_65100_21482# m3_66000_22226# 8.4636000000000015e-20
C55 m4_65100_21658# w_67548_20978# 2.5581000000000003e-18
C56 m4_65100_21658# w_66216_20978# 1.1378399999999999e-17
C57 m4_65100_21658# w_65064_21062# 8.1896100000000012e-18
C58 m2_65100_21482# m1_66376_22136# 4.0203900000000004e-20
C59 m4_65100_22426# m1_67412_21080# 1.7991299999999999e-18
C60 m2_65100_21482# w_66216_20978# 3.0487600000000004e-17
C61 m2_65100_21482# w_67548_20978# 3.3428399999999998e-18
C62 w_65064_21062# m2_65100_21482# 1.8931300000000003e-17
C63 m5_66336_20000# m1_67412_21080# 1.4143500000000001e-18
C64 a_65100_21043# m2_65100_22346# 7.3327300000000006e-17
C65 m4_65100_22042# a_65100_21098# 1.0612000000000001e-20
C66 a_65266_21098# m2_65100_22346# 1.5127600000000004e-16
C67 m4_65100_21658# a_65931_21111# 1.6397200000000001e-17
C68 a_65100_21043# m2_65100_21674# 7.6047300000000016e-17
C69 a_65266_21098# m2_65100_21674# 1.5544400000000001e-16
C70 m2_65100_21482# a_65931_21111# 1.1764e-16
C71 m4_65100_22042# m3_66000_22226# 6.140160000000001e-16
C72 m4_65100_22042# m1_66376_22136# 1.4423900000000002e-17
C73 m4_65100_22042# w_66216_20978# 9.0080500000000004e-18
C74 m4_65100_22042# w_67548_20978# 1.08472e-18
C75 m4_65100_22042# w_65064_21062# 6.5861000000000007e-18
C76 m4_65100_21658# m2_65100_21482# 1.4945500000000001e-17
C77 a_65100_21098# m2_65100_22346# 7.8486300000000013e-21
C78 m2_65100_21674# a_65100_21098# 3.1880400000000006e-20
C79 m3_66000_22226# m2_65100_22346# 5.1122700000000006e-17
C80 m2_65100_21674# m3_66000_22226# 1.5491500000000002e-18
C81 m4_65100_22042# a_65931_21111# 8.8562999999999996e-18
C82 m1_66376_22136# m2_65100_22346# 1.6445500000000003e-16
C83 m2_65100_21674# m1_66376_22136# 1.2037300000000002e-16
C84 a_65266_21098# a_67263_21111# 2.1590700000000004e-16
C85 m2_65100_22346# w_67548_20978# 3.5987800000000002e-18
C86 m2_65100_22346# w_66216_20978# 5.2978499999999999e-17
C87 w_65064_21062# m2_65100_22346# 3.1349100000000002e-17
C88 m2_65100_21674# w_66216_20978# 4.7071100000000005e-17
C89 m2_65100_21674# w_67548_20978# 2.9277600000000006e-18
C90 w_65064_21062# m2_65100_21674# 3.3636200000000009e-17
C91 a_65266_21098# m1_67350_20000# 8.5240000000000001e-16
C92 m4_65100_21658# m4_65100_22042# 5.3652999999999996e-16
C93 m4_65100_22426# a_65100_21043# 4.5276800000000007e-18
C94 m4_65100_22426# a_65266_21098# 1.7684100000000003e-17
C95 a_65931_21111# m2_65100_22346# 7.4594999999999995e-17
C96 m2_65100_21674# a_65931_21111# 7.9094400000000003e-17
C97 m5_66336_20000# a_65100_21043# 5.1755800000000002e-18
C98 m5_66336_20000# a_65266_21098# 7.4302000000000009e-16
C99 a_67263_21111# m3_66000_22226# 9.1782600000000015e-20
C100 m4_65100_21658# m2_65100_22346# 1.1895700000000002e-18
C101 m4_65100_21658# m2_65100_21674# 2.66712e-17
C102 a_67263_21111# m1_66376_22136# 1.6522900000000002e-19
C103 m1_67350_20000# m3_66000_22226# 1.5272800000000001e-18
C104 m4_65100_22426# a_65100_21098# 9.3524300000000013e-22
C105 a_67263_21111# w_67548_20978# 2.2428400000000003e-17
C106 m2_65100_21674# m2_65100_21482# 5.5803600000000002e-16
C107 m1_67350_20000# m1_66376_22136# 2.3896500000000002e-17
C108 m1_67350_20000# w_67548_20978# 1.4063000000000002e-18
C109 m4_65100_22426# m3_66000_22226# 3.5329800000000001e-16
C110 a_65266_21098# m1_67412_21080# 7.302050000000001e-17
C111 m4_65100_22426# m1_66376_22136# 8.8940900000000013e-18
C112 m5_66336_20000# a_65100_21098# -6.8540499999999999e-35
C113 m4_65100_22426# w_67548_20978# 9.3597800000000002e-19
C114 m4_65100_22426# w_66216_20978# 8.2920700000000015e-18
C115 m4_65100_22426# w_65064_21062# 4.0374999999999995e-18
C116 m5_66336_20000# m3_66000_22226# 1.7783400000000002e-16
C117 a_67263_21111# a_65931_21111# 3.4042600000000001e-17
C118 m5_66336_20000# m1_66376_22136# 1.1621500000000001e-17
C119 m1_67350_20000# a_65931_21111# 1.1850400000000001e-17
C120 m5_66336_20000# w_66216_20978# 2.0536599999999999e-17
C121 m5_66336_20000# w_67548_20978# 1.5137900000000001e-18
C122 m5_66336_20000# w_65064_21062# 4.8700000000000003e-18
C123 m4_65100_22042# m2_65100_22346# 1.5639100000000002e-17
C124 m4_65100_22042# m2_65100_21674# 1.0179600000000001e-17
C125 m4_65100_22426# a_65931_21111# 7.7190600000000003e-18
C126 m4_65100_21658# a_67263_21111# 1.9722600000000002e-18
C127 m1_67412_21080# m3_66000_22226# 1.6020600000000002e-18
C128 m4_65100_21658# m1_67350_20000# 3.8046000000000005e-18
C129 m2_65100_21482# a_67263_21111# 1.1578200000000001e-17
C130 m1_67412_21080# m1_66376_22136# 2.4991099999999999e-17
C131 m1_67350_20000# m2_65100_21482# 2.4562000000000002e-17
C132 m1_67412_21080# w_66216_20978# 8.5384699999999998e-20
C133 m5_66336_20000# a_65931_21111# 2.8862400000000001e-17
C134 m1_67412_21080# w_67548_20978# 1.4178000000000003e-17
C135 m2_65100_21674# m2_65100_22346# 1.3387800000000001e-16
C136 m5_66336_20000# m4_65100_21658# 2.4036099999999999e-16
C137 m1_67412_21080# a_65931_21111# 4.434400000000001e-19
C138 m5_66336_20000# m2_65100_21482# 1.3326700000000002e-17
C139 m4_65100_22042# a_67263_21111# 1.2061800000000001e-19
C140 m4_65100_22042# m1_67350_20000# 2.5642200000000004e-18
C141 a_65266_21098# a_65100_21043# 6.3810599999999996e-16
C142 a_23093_106400# a_23093_107267# 2.6329100000000002e-18
C143 m4_65100_21658# m1_67412_21080# 2.9948400000000002e-18
C144 m4_65100_22426# m4_65100_22042# 3.6473300000000006e-16
C145 a_23093_107267# a_23093_108003# 1.2163700000000001e-18
C146 m2_65100_21482# m1_67412_21080# 4.8298300000000001e-17
C147 a_67263_21111# m2_65100_22346# 1.10534e-19
C148 m2_65100_21674# a_67263_21111# 5.5591599999999995e-19
C149 m5_66336_20000# m4_65100_22042# 1.98648e-16
C150 m1_67350_20000# m2_65100_22346# 2.3529000000000002e-17
C151 m2_65100_21674# m1_67350_20000# 2.3884200000000004e-17
C152 a_23093_108003# a_23093_109107# 2.6329100000000002e-18
C153 a_65100_21043# a_65100_21098# 5.9348399999999998e-17
C154 a_65266_21098# a_65100_21098# 3.35961e-17
R0 a_65931_21111.n2 a_65931_21111.n0 19.430800781249999
R1 a_65931_21111.t0 a_65931_21111.n0 219.089
R2 a_65931_21111.n1 a_65931_21111.n2 19.430499999999999
R3 a_65931_21111.n2 a_65931_21111.n3 10.6302998046875
R4 a_65931_21111.n3 a_65931_21111.t3 252.012
R5 a_65931_21111.n3 a_65931_21111.t1 252.01300000000001
R6 a_65931_21111.n0 a_65931_21111.t5 278.63299999999998
R7 a_65931_21111.n1 a_65931_21111.t2 219.089
R8 a_65931_21111.t4 a_65931_21111.n1 278.63299999999998
R9 a_65931_21111# a_65931_21111.t4 126.842
R10 a_65100_21043.t0 a_65100_21043.n1 721.81600000000003
R11 a_65100_21043.n1 a_65100_21043.n0 19.430499999999999
R12 a_65100_21043.n2 a_65100_21043.n1 10.6302998046875
R13 a_65100_21043.n3 a_65100_21043.n2 604.78200000000004
R14 a_65100_21043.n2 a_65100_21043.t3 252.01300000000001
R15 a_65100_21043# a_65100_21043.n3 111.932
R16 a_65100_21043.n3 a_65100_21043.t1 134.31800000000001
R17 a_65100_21043.n0 a_65100_21043.t4 278.63299999999998
R18 a_65100_21043.n0 a_65100_21043.t2 219.089
R19 a_65266_21098.t4 a_65266_21098.n1 249.82400000000001
R20 a_65266_21098.n6 a_65266_21098.n7 4.5
R21 a_65266_21098.n8 a_65266_21098.n9 4.5
R22 a_65266_21098.n10 a_65266_21098.n11 4.5
R23 a_65266_21098.n12 a_65266_21098.n13 4.5
R24 a_65266_21098.n6 a_65266_21098.n5 2.3277700195312501
R25 a_65266_21098.n8 a_65266_21098.n6 0.083333297729492189
R26 a_65266_21098.n10 a_65266_21098.n8 0.083333297729492189
R27 a_65266_21098.n12 a_65266_21098.n10 0.083333297729492189
R28 a_65266_21098.n0 a_65266_21098.n12 0.91028802490234373
R29 a_65266_21098.n14 a_65266_21098.n15 3.4100000000000001
R30 a_65266_21098.n16 a_65266_21098.n17 3.4100000000000001
R31 a_65266_21098.n18 a_65266_21098.n19 3.4100000000000001
R32 a_65266_21098.n5 a_65266_21098.n21 3.493159912109375
R33 a_65266_21098.n5 a_65266_21098.n18 0.080455200195312507
R34 a_65266_21098.n18 a_65266_21098.n7 0.081081100463867184
R35 a_65266_21098.n7 a_65266_21098.n16 0.054054100036621096
R36 a_65266_21098.n16 a_65266_21098.n9 0.054054100036621096
R37 a_65266_21098.n9 a_65266_21098.n14 0.081081100463867184
R38 a_65266_21098.n14 a_65266_21098.n11 0.027027000427246095
R39 a_65266_21098.n11 a_65266_21098.n13 0.10810800170898438
R40 a_65266_21098.n21 a_65266_21098.n22 1.6913800048828125
R41 a_65266_21098.n20 a_65266_21098.n22 1.6913800048828125
R42 a_65266_21098.n15 a_65266_21098.n20 0.028748899459838866
R43 a_65266_21098.n17 a_65266_21098.n22 3.4100000000000001
R44 a_65266_21098.n19 a_65266_21098.n21 0.028748899459838866
R45 a_65266_21098.n19 a_65266_21098.n17 0.056969699859619138
R46 a_65266_21098.n17 a_65266_21098.n15 0.056969699859619138
R47 a_65266_21098.n20 a_65266_21098.n13 3.4387500000000002
R48 a_65266_21098.n23 a_65266_21098.n24 3.4100000000000001
R49 a_65266_21098.n24 a_65266_21098.n25 1.6913800048828125
R50 a_65266_21098.n28 a_65266_21098.n27 0.028748899459838866
R51 a_65266_21098.n24 a_65266_21098.n28 1.6913800048828125
R52 a_65266_21098.n22 a_65266_21098.n24 0.15650999450683595
R53 a_65266_21098.n25 a_65266_21098.n30 3.4387500000000002
R54 a_65266_21098.n26 a_65266_21098.n31 3.4100000000000001
R55 a_65266_21098.n27 a_65266_21098.n32 3.4100000000000001
R56 a_65266_21098.n29 a_65266_21098.n45 3.4100000000000001
R57 a_65266_21098.n29 a_65266_21098.n23 0.056969699859619138
R58 a_65266_21098.n28 a_65266_21098.n29 0.028748899459838866
R59 a_65266_21098.n27 a_65266_21098.n26 0.056969699859619138
R60 a_65266_21098.n25 a_65266_21098.n26 0.028748899459838866
R61 a_65266_21098.n34 a_65266_21098.n35 4.5
R62 a_65266_21098.n36 a_65266_21098.n37 4.5
R63 a_65266_21098.n38 a_65266_21098.n39 4.5
R64 a_65266_21098.n44 a_65266_21098.n30 4.5
R65 a_65266_21098.n23 a_65266_21098.n33 3.464409912109375
R66 a_65266_21098.n45 a_65266_21098.n33 0.080455200195312507
R67 a_65266_21098.n45 a_65266_21098.n35 0.081081100463867184
R68 a_65266_21098.n32 a_65266_21098.n35 0.054054100036621096
R69 a_65266_21098.n32 a_65266_21098.n37 0.054054100036621096
R70 a_65266_21098.n37 a_65266_21098.n31 0.081081100463867184
R71 a_65266_21098.n31 a_65266_21098.n39 0.027027000427246095
R72 a_65266_21098.n39 a_65266_21098.n30 0.10810800170898438
R73 a_65266_21098.n33 a_65266_21098.n34 2.3277700195312501
R74 a_65266_21098.n34 a_65266_21098.n36 0.083333297729492189
R75 a_65266_21098.n36 a_65266_21098.n38 0.083333297729492189
R76 a_65266_21098.n38 a_65266_21098.n44 0.083333297729492189
R77 a_65266_21098.n40 a_65266_21098.n41 3.9453701171875002
R78 a_65266_21098.n44 a_65266_21098.n40 0.91030902099609379
R79 a_65266_21098.n43 a_65266_21098.t6 249.82400000000001
R80 a_65266_21098.n43 a_65266_21098.t2 249.82400000000001
R81 a_65266_21098.n40 a_65266_21098.n43 5.8117402343749998
R82 a_65266_21098.n41 a_65266_21098.n42 14.371900390624999
R83 a_65266_21098.n41 a_65266_21098.t7 239.37200000000001
R84 a_65266_21098.n42 a_65266_21098.t3 225
R85 a_65266_21098.n42 a_65266_21098.t10 271.81400000000002
R86 a_65266_21098.n3 a_65266_21098.n2 14.371900390624999
R87 a_65266_21098.n2 a_65266_21098.n4 14.371900390624999
R88 a_65266_21098.n4 a_65266_21098.t5 225
R89 a_65266_21098.n4 a_65266_21098.t9 271.81400000000002
R90 a_65266_21098.n3 a_65266_21098.t1 225
R91 a_65266_21098.t8 a_65266_21098.n3 271.81400000000002
R92 a_65266_21098# a_65266_21098.t8 209.48500000000001
R93 a_65266_21098.n2 a_65266_21098.n0 3.9453898925781248
R94 a_65266_21098.n0 a_65266_21098.n1 5.8111601562499997
R95 a_65266_21098.n1 a_65266_21098.t0 249.82400000000001
R96 w_66216_20978# w_66216_20978.t1 99.868601562500004
R97 w_66216_20978.t1 w_66216_20978.t0 217.214
R98 w_65064_21062.t0 w_65064_21062.t1 168.52799999999999
R99 w_65064_21062# w_65064_21062.t0 3602.6199999999999
R100 w_22789_106400.t4 w_22789_106400.n98 650.66700000000003
R101 w_22789_106400.n2 w_22789_106400.n1 9.3000000000000007
R102 w_22789_106400.n4 w_22789_106400.n3 9.3000000000000007
R103 w_22789_106400.n6 w_22789_106400.n5 9.3000000000000007
R104 w_22789_106400.n8 w_22789_106400.n7 9.3000000000000007
R105 w_22789_106400.n1 w_22789_106400.n0 0.21157000732421874
R106 w_22789_106400.n0 w_22789_106400.n3 3.032510009765625
R107 w_22789_106400.n3 w_22789_106400.n5 3.2440800781250001
R108 w_22789_106400.n5 w_22789_106400.n98 3.032510009765625
R109 w_22789_106400.n7 w_22789_106400.n98 0.21157000732421874
R110 w_22789_106400.n11 w_22789_106400.n10 152
R111 w_22789_106400.n13 w_22789_106400.n12 152
R112 w_22789_106400.n15 w_22789_106400.n14 152
R113 w_22789_106400.n18 w_22789_106400.n19 9.3000000000000007
R114 w_22789_106400.n20 w_22789_106400.n21 9.3000000000000007
R115 w_22789_106400.n22 w_22789_106400.n23 9.3000000000000007
R116 w_22789_106400.n24 w_22789_106400.n25 9.3000000000000007
R117 w_22789_106400.n26 w_22789_106400.n27 9.3000000000000007
R118 w_22789_106400.n29 w_22789_106400.n28 9.3000000000000007
R119 w_22789_106400.n97 w_22789_106400.n18 0.84967901611328123
R120 w_22789_106400.n18 w_22789_106400.n11 0.16445399475097655
R121 w_22789_106400.n11 w_22789_106400.n20 2.3571699218750002
R122 w_22789_106400.n20 w_22789_106400.n13 1.1511800537109376
R123 w_22789_106400.n13 w_22789_106400.n22 1.3704499511718751
R124 w_22789_106400.n22 w_22789_106400.n15 2.1378999023437499
R125 w_22789_106400.n15 w_22789_106400.n24 0.38372601318359373
R126 w_22789_106400.n24 w_22789_106400.n26 2.5216298828124999
R127 w_22789_106400.n26 w_22789_106400.n17 0.60299798583984376
R128 w_22789_106400.n17 w_22789_106400.n9 1.7541800537109375
R129 w_22789_106400.n28 w_22789_106400.n9 0.16445399475097655
R130 w_22789_106400.n28 w_22789_106400.n1 4.8797001953125001
R131 w_22789_106400.n30 w_22789_106400.n31 4.6207402343749999
R132 w_22789_106400.n97 w_22789_106400.n30 3.7978000488281252
R133 w_22789_106400.n33 w_22789_106400.n34 9.3000000000000007
R134 w_22789_106400.n35 w_22789_106400.n36 9.3000000000000007
R135 w_22789_106400.n37 w_22789_106400.n38 9.3000000000000007
R136 w_22789_106400.n39 w_22789_106400.n40 9.3000000000000007
R137 w_22789_106400.n32 w_22789_106400.n35 0.30476199340820315
R138 w_22789_106400.n41 w_22789_106400.n32 2.0317500000000002
R139 w_22789_106400.n37 w_22789_106400.n41 2.3365100097656248
R140 w_22789_106400.n33 w_22789_106400.n37 4.6730200195312497
R141 w_22789_106400.n39 w_22789_106400.n33 4.6730200195312497
R142 w_22789_106400.n39 w_22789_106400.n97 7.0681298828125003
R143 w_22789_106400.n35 w_22789_106400.n42 8.2494902343749992
R144 w_22789_106400.n45 w_22789_106400.n44 152
R145 w_22789_106400.n47 w_22789_106400.n46 152
R146 w_22789_106400.n49 w_22789_106400.n48 152
R147 w_22789_106400.n53 w_22789_106400.n52 9.3000000000000007
R148 w_22789_106400.n55 w_22789_106400.n54 9.3000000000000007
R149 w_22789_106400.n57 w_22789_106400.n56 9.3000000000000007
R150 w_22789_106400.n59 w_22789_106400.n58 9.3000000000000007
R151 w_22789_106400.n61 w_22789_106400.n60 9.3000000000000007
R152 w_22789_106400.n63 w_22789_106400.n62 9.3000000000000007
R153 w_22789_106400.n52 w_22789_106400.n45 0.21572999572753906
R154 w_22789_106400.n45 w_22789_106400.n65 1.3662900390624999
R155 w_22789_106400.n65 w_22789_106400.n54 1.7258399658203125
R156 w_22789_106400.n54 w_22789_106400.n47 1.5101099853515625
R157 w_22789_106400.n47 w_22789_106400.n56 1.79775
R158 w_22789_106400.n56 w_22789_106400.n49 2.8044899902343752
R159 w_22789_106400.n58 w_22789_106400.n49 0.5033710021972656
R160 w_22789_106400.n58 w_22789_106400.n64 1.61797998046875
R161 w_22789_106400.n60 w_22789_106400.n64 1.6898900146484375
R162 w_22789_106400.n60 w_22789_106400.n51 0.79101098632812505
R163 w_22789_106400.n51 w_22789_106400.n43 2.3011201171875002
R164 w_22789_106400.n62 w_22789_106400.n43 0.21572999572753906
R165 w_22789_106400.n62 w_22789_106400.n42 7.4067402343750004
R166 w_22789_106400.n68 w_22789_106400.n67 9.3000000000000007
R167 w_22789_106400.n70 w_22789_106400.n69 9.3000000000000007
R168 w_22789_106400.n72 w_22789_106400.n71 9.3000000000000007
R169 w_22789_106400.n74 w_22789_106400.n73 9.3000000000000007
R170 w_22789_106400.n76 w_22789_106400.n75 9.3000000000000007
R171 w_22789_106400.n78 w_22789_106400.n66 3.5474099121093752
R172 w_22789_106400.n66 w_22789_106400.n67 4.3682499999999997
R173 w_22789_106400.n67 w_22789_106400.n69 4.6730200195312497
R174 w_22789_106400.n69 w_22789_106400.n77 3.1492099609375002
R175 w_22789_106400.n71 w_22789_106400.n77 1.52381005859375
R176 w_22789_106400.n71 w_22789_106400.n73 4.6730200195312497
R177 w_22789_106400.n73 w_22789_106400.n75 4.6730200195312497
R178 w_22789_106400.n75 w_22789_106400.n52 4.2130200195312497
R179 w_22789_106400.n78 w_22789_106400.n77 42.048499999999997
R180 w_22789_106400.n77 w_22789_106400.n65 40.360398437500002
R181 w_22789_106400.n65 w_22789_106400.t7 655.50999999999999
R182 w_22789_106400.n80 w_22789_106400.n79 4.6207402343749999
R183 w_22789_106400.n81 w_22789_106400.n82 9.3000000000000007
R184 w_22789_106400.n84 w_22789_106400.n83 9.3000000000000007
R185 w_22789_106400.n85 w_22789_106400.n86 9.3000000000000007
R186 w_22789_106400.n68 w_22789_106400.n78 4.1199199218749998
R187 w_22789_106400.n70 w_22789_106400.n68 0.11979199981689453
R188 w_22789_106400.n72 w_22789_106400.n70 0.11979199981689453
R189 w_22789_106400.n74 w_22789_106400.n72 0.11979199981689453
R190 w_22789_106400.n76 w_22789_106400.n74 0.11979199981689453
R191 w_22789_106400.n53 w_22789_106400.n76 0.11979199981689453
R192 w_22789_106400.n55 w_22789_106400.n53 0.11979199981689453
R193 w_22789_106400.n57 w_22789_106400.n55 0.11979199981689453
R194 w_22789_106400.n59 w_22789_106400.n57 0.11979199981689453
R195 w_22789_106400.n61 w_22789_106400.n59 0.11979199981689453
R196 w_22789_106400.n63 w_22789_106400.n61 0.11979199981689453
R197 w_22789_106400.n36 w_22789_106400.n63 0.11979199981689453
R198 w_22789_106400.n38 w_22789_106400.n36 0.11979199981689453
R199 w_22789_106400.n34 w_22789_106400.n38 0.11979199981689453
R200 w_22789_106400.n40 w_22789_106400.n34 0.11979199981689453
R201 w_22789_106400.n40 w_22789_106400.n31 0.17980400085449219
R202 w_22789_106400.n31 w_22789_106400.n19 0.17980400085449219
R203 w_22789_106400.n19 w_22789_106400.n21 0.11979199981689453
R204 w_22789_106400.n21 w_22789_106400.n23 0.11979199981689453
R205 w_22789_106400.n23 w_22789_106400.n25 0.11979199981689453
R206 w_22789_106400.n25 w_22789_106400.n27 0.11979199981689453
R207 w_22789_106400.n27 w_22789_106400.n29 0.11979199981689453
R208 w_22789_106400.n29 w_22789_106400.n2 0.11979199981689453
R209 w_22789_106400.n2 w_22789_106400.n4 0.11979199981689453
R210 w_22789_106400.n4 w_22789_106400.n6 0.11979199981689453
R211 w_22789_106400.n6 w_22789_106400.n8 0.11979199981689453
R212 w_22789_106400.n8 w_22789_106400.n80 0.17980400085449219
R213 w_22789_106400.n80 w_22789_106400.n82 0.17980400085449219
R214 w_22789_106400.n82 w_22789_106400.n84 0.11979199981689453
R215 w_22789_106400.n84 w_22789_106400.n86 0.11979199981689453
R216 w_22789_106400.n86 w_22789_106400.n96 4.2445000000000004
R217 w_22789_106400.n88 w_22789_106400.n87 152
R218 w_22789_106400.n90 w_22789_106400.n89 152
R219 w_22789_106400.n92 w_22789_106400.n91 152
R220 w_22789_106400.n95 w_22789_106400.n81 0.84967901611328123
R221 w_22789_106400.n81 w_22789_106400.n88 0.16445399475097655
R222 w_22789_106400.n88 w_22789_106400.n83 2.3571699218750002
R223 w_22789_106400.n83 w_22789_106400.n90 1.1511800537109376
R224 w_22789_106400.n85 w_22789_106400.n90 1.3704499511718751
R225 w_22789_106400.n92 w_22789_106400.n85 2.1378999023437499
R226 w_22789_106400.n96 w_22789_106400.n92 1.4882500000000001
R227 w_22789_106400.n96 w_22789_106400.n94 1.7217499999999999
R228 w_22789_106400.n94 w_22789_106400.t1 625.37599999999998
R229 w_22789_106400.n79 w_22789_106400.n95 3.7978000488281252
R230 w_22789_106400.n7 w_22789_106400.n95 6.6332402343750001
R231 w_22789_106400.n79 w_22789_106400.t18 656.01199999999994
R232 w_22789_106400.n87 w_22789_106400.n89 62.955101562499998
R233 w_22789_106400.n89 w_22789_106400.n93 32.461199218749996
R234 w_22789_106400.n91 w_22789_106400.n93 30.493900390625001
R235 w_22789_106400.n91 w_22789_106400.n94 214.95500000000001
R236 w_22789_106400.n87 w_22789_106400.t19 571.74400000000003
R237 w_22789_106400.n93 w_22789_106400.t19 107.79300000000001
R238 w_22789_106400.n66 w_22789_106400.t10 388.65499999999997
R239 w_22789_106400.n64 w_22789_106400.n42 21.218
R240 w_22789_106400.n42 w_22789_106400.n41 10.724299804687501
R241 w_22789_106400.n64 w_22789_106400.t13 665.77300000000002
R242 w_22789_106400.n41 w_22789_106400.t12 655.279
R243 w_22789_106400.n44 w_22789_106400.n46 62.955101562499998
R244 w_22789_106400.n46 w_22789_106400.n50 32.461199218749996
R245 w_22789_106400.n48 w_22789_106400.n50 30.493900390625001
R246 w_22789_106400.n48 w_22789_106400.n51 214.95500000000001
R247 w_22789_106400.n44 w_22789_106400.t21 571.74400000000003
R248 w_22789_106400.n50 w_22789_106400.t21 107.79300000000001
R249 w_22789_106400.n43 w_22789_106400.t9 388.65499999999997
R250 w_22789_106400.t14 w_22789_106400.n39 1079.21
R251 w_22789_106400.t8 w_22789_106400.t11 233.78100000000001
R252 w_22789_106400.t11 w_22789_106400.t14 429.30599999999998
R253 w_22789_106400.t14 w_22789_106400.t3 429.30599999999998
R254 w_22789_106400.t3 w_22789_106400.t0 820.35799999999995
R255 w_22789_106400.t0 w_22789_106400.t17 53.131999999999998
R256 w_22789_106400# w_22789_106400.t6 752.34900000000005
R257 w_22789_106400.t6 w_22789_106400.t8 178.523
R258 w_22789_106400.n32 w_22789_106400.t16 388.65499999999997
R259 w_22789_106400.n30 w_22789_106400.t5 656.01199999999994
R260 w_22789_106400.n10 w_22789_106400.n12 62.955101562499998
R261 w_22789_106400.n12 w_22789_106400.n16 32.461199218749996
R262 w_22789_106400.n16 w_22789_106400.n14 30.493900390625001
R263 w_22789_106400.n14 w_22789_106400.n17 214.95500000000001
R264 w_22789_106400.n10 w_22789_106400.t20 571.74400000000003
R265 w_22789_106400.n16 w_22789_106400.t20 107.79300000000001
R266 w_22789_106400.n9 w_22789_106400.t15 388.65499999999997
R267 w_22789_106400.n0 w_22789_106400.t2 388.65499999999997
R268 w_21701_106400.n53 w_21701_106400.t1 804.73099999999999
R269 w_21701_106400.t1 w_21701_106400.n0 751.69200000000001
R270 w_21701_106400.n1 w_21701_106400.t21 147.851
R271 w_21701_106400.n3 w_21701_106400.n2 1.4404599609375
R272 w_21701_106400.n3 w_21701_106400.n49 0.40968701171874999
R273 w_21701_106400.n2 w_21701_106400.n1 3.17343994140625
R274 w_21701_106400.n2 w_21701_106400.n53 1.8743699951171875
R275 w_21701_106400.n53 w_21701_106400.n0 2.5156101074218751
R276 w_21701_106400.n5 w_21701_106400.n4 9.3000000000000007
R277 w_21701_106400.n8 w_21701_106400.n7 2.2526201171875
R278 w_21701_106400.n21 w_21701_106400.n8 0.35758700561523438
R279 w_21701_106400.n21 w_21701_106400.n22 4.6207402343749999
R280 w_21701_106400.n44 w_21701_106400.n9 9.3000000000000007
R281 w_21701_106400.n10 w_21701_106400.n11 9.3000000000000007
R282 w_21701_106400.n12 w_21701_106400.n13 9.3000000000000007
R283 w_21701_106400.n14 w_21701_106400.n15 9.3000000000000007
R284 w_21701_106400.n16 w_21701_106400.n17 9.3000000000000007
R285 w_21701_106400.n18 w_21701_106400.n19 9.3000000000000007
R286 w_21701_106400.n46 w_21701_106400.n47 9.3000000000000007
R287 w_21701_106400.n48 w_21701_106400.n49 9.3000000000000007
R288 w_21701_106400.n5 w_21701_106400.n21 0.17980400085449219
R289 w_21701_106400.n9 w_21701_106400.n5 0.11979199981689453
R290 w_21701_106400.n9 w_21701_106400.n11 0.11979199981689453
R291 w_21701_106400.n11 w_21701_106400.n13 0.11979199981689453
R292 w_21701_106400.n13 w_21701_106400.n15 0.11979199981689453
R293 w_21701_106400.n15 w_21701_106400.n17 0.11979199981689453
R294 w_21701_106400.n17 w_21701_106400.n19 0.11979199981689453
R295 w_21701_106400.n19 w_21701_106400.n47 0.11979199981689453
R296 w_21701_106400.n47 w_21701_106400.n3 0.40790399169921876
R297 w_21701_106400.n49 w_21701_106400.n50 0.71329498291015625
R298 w_21701_106400.n51 w_21701_106400.n48 0.1634040069580078
R299 w_21701_106400.n50 w_21701_106400.n51 5.5688198242187497
R300 w_21701_106400.n50 w_21701_106400.n52 4.0787299804687498
R301 w_21701_106400.n2 w_21701_106400.n48 13.9662998046875
R302 w_21701_106400.n52 w_21701_106400.t19 279.46600000000001
R303 w_21701_106400.n52 w_21701_106400.t20 279.46600000000001
R304 w_21701_106400.n51 w_21701_106400.t18 388.65499999999997
R305 w_21701_106400.n51 w_21701_106400.t9 388.65499999999997
R306 w_21701_106400.n10 w_21701_106400.n20 0.1634040069580078
R307 w_21701_106400.n20 w_21701_106400.n12 2.3421298828124999
R308 w_21701_106400.n12 w_21701_106400.n14 2.505530029296875
R309 w_21701_106400.n14 w_21701_106400.n16 2.505530029296875
R310 w_21701_106400.n18 w_21701_106400.n16 2.505530029296875
R311 w_21701_106400.n46 w_21701_106400.n18 2.505530029296875
R312 w_21701_106400.n2 w_21701_106400.n46 1.661280029296875
R313 w_21701_106400.n44 w_21701_106400.n10 13.5897998046875
R314 w_21701_106400.n45 w_21701_106400.n44 106.56
R315 w_21701_106400# w_21701_106400.t16 594.16999999999996
R316 w_21701_106400.t16 w_21701_106400.t13 419.61099999999999
R317 w_21701_106400.t13 w_21701_106400.t10 772.08500000000004
R318 w_21701_106400.t10 w_21701_106400.t5 386.04199999999997
R319 w_21701_106400.t5 w_21701_106400.n45 308.834
R320 w_21701_106400.n45 w_21701_106400.t0 1003.71
R321 w_21701_106400.t0 w_21701_106400.t8 1555.9200000000001
R322 w_21701_106400.n25 w_21701_106400.n4 6.4000000000000004
R323 w_21701_106400.n4 w_21701_106400.n44 23.717599609375
R324 w_21701_106400.n22 w_21701_106400.n25 1.1014100341796875
R325 w_21701_106400.n22 w_21701_106400.n24 5.2583798828125001
R326 w_21701_106400.n43 w_21701_106400.n24 2.283239990234375
R327 w_21701_106400.n43 w_21701_106400.n23 4.7740498046875004
R328 w_21701_106400.n34 w_21701_106400.n30 2.65225
R329 w_21701_106400.n34 w_21701_106400.n29 1.2684699707031251
R330 w_21701_106400.n7 w_21701_106400.n29 2.9213200683593752
R331 w_21701_106400.n7 w_21701_106400.n32 2.9213200683593752
R332 w_21701_106400.n32 w_21701_106400.n43 1.2684699707031251
R333 w_21701_106400.n43 w_21701_106400.n31 2.65225
R334 w_21701_106400.n42 w_21701_106400.n34 46.079999999999998
R335 w_21701_106400.n36 w_21701_106400.n37 152
R336 w_21701_106400.n41 w_21701_106400.n35 156.67699999999999
R337 w_21701_106400.n41 w_21701_106400.n37 11.076900390624999
R338 w_21701_106400.n37 w_21701_106400.n42 0.3692309875488281
R339 w_21701_106400.n42 w_21701_106400.n38 18.26919921875
R340 w_21701_106400.n34 w_21701_106400.n41 3.1075100097656252
R341 w_21701_106400.n6 w_21701_106400.n34 2.68825
R342 w_21701_106400.n6 w_21701_106400.n40 3.17343994140625
R343 w_21701_106400.n40 w_21701_106400.t26 105.999
R344 w_21701_106400.n40 w_21701_106400.t17 388.02699999999999
R345 w_21701_106400.n35 w_21701_106400.n36 62.955101562499998
R346 w_21701_106400.n39 w_21701_106400.n36 32.461199218749996
R347 w_21701_106400.n38 w_21701_106400.n39 119.241
R348 w_21701_106400.n30 w_21701_106400.n38 6.4311899414062497
R349 w_21701_106400.n35 w_21701_106400.t24 571.74400000000003
R350 w_21701_106400.n39 w_21701_106400.t24 107.79300000000001
R351 w_21701_106400.n31 w_21701_106400.n33 9.6371699218749995
R352 w_21701_106400.n33 w_21701_106400.n23 10.8947998046875
R353 w_21701_106400.n33 w_21701_106400.t25 122.636
R354 w_21701_106400.n32 w_21701_106400.t12 804.73099999999999
R355 w_21701_106400.n31 w_21701_106400.t12 751.69200000000001
R356 w_21701_106400.n30 w_21701_106400.t14 751.69200000000001
R357 w_21701_106400.t14 w_21701_106400.n29 804.73099999999999
R358 w_21701_106400.n26 w_21701_106400.n28 2.634889892578125
R359 w_21701_106400.n25 w_21701_106400.n26 3.120659912109375
R360 w_21701_106400.n27 w_21701_106400.t23 245.667
R361 w_21701_106400.n28 w_21701_106400.n27 2.3744499511718749
R362 w_21701_106400.n28 w_21701_106400.t7 380.19299999999998
R363 w_21701_106400.n27 w_21701_106400.t6 725.173
R364 w_21701_106400.t6 w_21701_106400.n26 804.73099999999999
R365 w_21701_106400.n24 w_21701_106400.t11 804.73099999999999
R366 w_21701_106400.n23 w_21701_106400.t11 751.69200000000001
R367 w_21701_106400.n20 w_21701_106400.t2 388.65499999999997
R368 w_21701_106400.n20 w_21701_106400.t4 388.65499999999997
R369 w_21701_106400.n6 w_21701_106400.t15 395.90899999999999
R370 w_21701_106400.n8 w_21701_106400.n6 1.68447998046875
R371 w_21701_106400.n0 w_21701_106400.t22 146.63800000000001
R372 w_21701_106400.n1 w_21701_106400.t3 388.02699999999999
R373 a_21487_106400.n189 a_21487_106400.t30 214.45500000000001
R374 a_21487_106400.n2 a_21487_106400.n1 152
R375 a_21487_106400.n4 a_21487_106400.n3 152
R376 a_21487_106400.n8 a_21487_106400.n7 9.3000000000000007
R377 a_21487_106400.n10 a_21487_106400.n9 9.3000000000000007
R378 a_21487_106400.n12 a_21487_106400.n11 9.3000000000000007
R379 a_21487_106400.n13 a_21487_106400.n14 9.3000000000000007
R380 a_21487_106400.n7 a_21487_106400.n189 0.26301400756835935
R381 a_21487_106400.n189 a_21487_106400.n6 2.630139892578125
R382 a_21487_106400.n9 a_21487_106400.n6 1.13972998046875
R383 a_21487_106400.n9 a_21487_106400.n11 4.0328798828124999
R384 a_21487_106400.n11 a_21487_106400.n4 0.43835598754882815
R385 a_21487_106400.n4 a_21487_106400.n13 3.5945200195312501
R386 a_21487_106400.n2 a_21487_106400.n13 2.0164399414062499
R387 a_21487_106400.n15 a_21487_106400.n2 3.7269799804687498
R388 a_21487_106400.n15 a_21487_106400.n0 153.22399999999999
R389 a_21487_106400.n14 a_21487_106400.n15 3.2858898925781248
R390 a_21487_106400.n18 a_21487_106400.n17 9.3000000000000007
R391 a_21487_106400.n20 a_21487_106400.n19 9.3000000000000007
R392 a_21487_106400.n22 a_21487_106400.n21 9.3000000000000007
R393 a_21487_106400.n24 a_21487_106400.n23 9.3000000000000007
R394 a_21487_106400.n26 a_21487_106400.n25 9.3000000000000007
R395 a_21487_106400.n28 a_21487_106400.n27 9.3000000000000007
R396 a_21487_106400.n17 a_21487_106400.n19 6.2638300781250003
R397 a_21487_106400.n19 a_21487_106400.n21 6.2638300781250003
R398 a_21487_106400.n21 a_21487_106400.n23 6.2638300781250003
R399 a_21487_106400.n23 a_21487_106400.n25 6.2638300781250003
R400 a_21487_106400.n25 a_21487_106400.n16 5.8553198242187499
R401 a_21487_106400.n27 a_21487_106400.n16 0.40851098632812499
R402 a_21487_106400.n27 a_21487_106400.n7 16.354099609375002
R403 a_21487_106400.n30 a_21487_106400.n29 152
R404 a_21487_106400.n32 a_21487_106400.n31 152
R405 a_21487_106400.n34 a_21487_106400.n33 152
R406 a_21487_106400.n39 a_21487_106400.n38 9.3000000000000007
R407 a_21487_106400.n41 a_21487_106400.n40 9.3000000000000007
R408 a_21487_106400.n43 a_21487_106400.n42 9.3000000000000007
R409 a_21487_106400.n45 a_21487_106400.n44 9.3000000000000007
R410 a_21487_106400.n47 a_21487_106400.n46 9.3000000000000007
R411 a_21487_106400.n49 a_21487_106400.n48 9.3000000000000007
R412 a_21487_106400.n38 a_21487_106400.n37 0.26301400756835935
R413 a_21487_106400.n37 a_21487_106400.n36 2.630139892578125
R414 a_21487_106400.n40 a_21487_106400.n36 1.13972998046875
R415 a_21487_106400.n40 a_21487_106400.n42 4.0328798828124999
R416 a_21487_106400.n42 a_21487_106400.n34 0.43835598754882815
R417 a_21487_106400.n34 a_21487_106400.n44 3.5945200195312501
R418 a_21487_106400.n44 a_21487_106400.n32 2.0164399414062499
R419 a_21487_106400.n32 a_21487_106400.n46 2.0164399414062499
R420 a_21487_106400.n46 a_21487_106400.n30 3.5945200195312501
R421 a_21487_106400.n48 a_21487_106400.n30 0.43835598754882815
R422 a_21487_106400.n48 a_21487_106400.n17 5.6090898437499996
R423 a_21487_106400.n50 a_21487_106400.n38 14.0712001953125
R424 a_21487_106400.n188 a_21487_106400.n50 9.3000000000000007
R425 a_21487_106400.n50 a_21487_106400.n145 1198.25
R426 a_21487_106400.n147 a_21487_106400.n148 9.3000000000000007
R427 a_21487_106400.n149 a_21487_106400.n150 9.3000000000000007
R428 a_21487_106400.n152 a_21487_106400.n151 9.3000000000000007
R429 a_21487_106400.n154 a_21487_106400.n153 9.3000000000000007
R430 a_21487_106400.n156 a_21487_106400.n155 9.3000000000000007
R431 a_21487_106400.n158 a_21487_106400.n157 9.3000000000000007
R432 a_21487_106400.n160 a_21487_106400.n159 9.3000000000000007
R433 a_21487_106400.n162 a_21487_106400.n161 9.3000000000000007
R434 a_21487_106400.n164 a_21487_106400.n163 9.3000000000000007
R435 a_21487_106400.n166 a_21487_106400.n165 9.3000000000000007
R436 a_21487_106400.n168 a_21487_106400.n167 9.3000000000000007
R437 a_21487_106400.n170 a_21487_106400.n169 9.3000000000000007
R438 a_21487_106400.n172 a_21487_106400.n171 9.3000000000000007
R439 a_21487_106400.n187 a_21487_106400.n186 9.3000000000000007
R440 a_21487_106400.n146 a_21487_106400.n148 2.7602500000000001
R441 a_21487_106400.n148 a_21487_106400.n150 0.11979199981689453
R442 a_21487_106400.n150 a_21487_106400.n152 0.11979199981689453
R443 a_21487_106400.n152 a_21487_106400.n154 0.11979199981689453
R444 a_21487_106400.n154 a_21487_106400.n156 0.11979199981689453
R445 a_21487_106400.n156 a_21487_106400.n158 0.11979199981689453
R446 a_21487_106400.n158 a_21487_106400.n160 0.11979199981689453
R447 a_21487_106400.n160 a_21487_106400.n162 0.11979199981689453
R448 a_21487_106400.n162 a_21487_106400.n164 0.11979199981689453
R449 a_21487_106400.n164 a_21487_106400.n166 0.11979199981689453
R450 a_21487_106400.n166 a_21487_106400.n168 0.11979199981689453
R451 a_21487_106400.n168 a_21487_106400.n170 0.11979199981689453
R452 a_21487_106400.n170 a_21487_106400.n172 0.11979199981689453
R453 a_21487_106400.n172 a_21487_106400.n187 0.11979199981689453
R454 a_21487_106400.n187 a_21487_106400.n188 0.11979199981689453
R455 a_21487_106400.n188 a_21487_106400.n39 0.11979199981689453
R456 a_21487_106400.n39 a_21487_106400.n41 0.11979199981689453
R457 a_21487_106400.n41 a_21487_106400.n43 0.11979199981689453
R458 a_21487_106400.n43 a_21487_106400.n45 0.11979199981689453
R459 a_21487_106400.n45 a_21487_106400.n47 0.11979199981689453
R460 a_21487_106400.n47 a_21487_106400.n49 0.11979199981689453
R461 a_21487_106400.n49 a_21487_106400.n18 0.11979199981689453
R462 a_21487_106400.n18 a_21487_106400.n20 0.11979199981689453
R463 a_21487_106400.n20 a_21487_106400.n22 0.11979199981689453
R464 a_21487_106400.n22 a_21487_106400.n24 0.11979199981689453
R465 a_21487_106400.n24 a_21487_106400.n26 0.11979199981689453
R466 a_21487_106400.n26 a_21487_106400.n28 0.11979199981689453
R467 a_21487_106400.n28 a_21487_106400.n8 0.11979199981689453
R468 a_21487_106400.n8 a_21487_106400.n10 0.11979199981689453
R469 a_21487_106400.n10 a_21487_106400.n12 0.11979199981689453
R470 a_21487_106400.n12 a_21487_106400.n14 0.11979199981689453
R471 a_21487_106400.n169 a_21487_106400.n174 0.41739099121093748
R472 a_21487_106400.n174 a_21487_106400.n175 1.1826099853515626
R473 a_21487_106400.n175 a_21487_106400.n171 4.7999999999999998
R474 a_21487_106400.n171 a_21487_106400.n173 5.9826098632812501
R475 a_21487_106400.n186 a_21487_106400.n173 0.41739099121093748
R476 a_21487_106400.n157 a_21487_106400.n159 6.2638300781250003
R477 a_21487_106400.n159 a_21487_106400.n161 6.2638300781250003
R478 a_21487_106400.n161 a_21487_106400.n163 6.2638300781250003
R479 a_21487_106400.n163 a_21487_106400.n165 6.2638300781250003
R480 a_21487_106400.n165 a_21487_106400.n176 5.8553198242187499
R481 a_21487_106400.n167 a_21487_106400.n176 0.40851098632812499
R482 a_21487_106400.n167 a_21487_106400.n169 17.100199218749999
R483 a_21487_106400.n178 a_21487_106400.n177 152
R484 a_21487_106400.n180 a_21487_106400.n179 152
R485 a_21487_106400.n182 a_21487_106400.n181 152
R486 a_21487_106400.n146 a_21487_106400.n185 4.3153701171875003
R487 a_21487_106400.n185 a_21487_106400.n184 2.630139892578125
R488 a_21487_106400.n184 a_21487_106400.n147 1.13972998046875
R489 a_21487_106400.n147 a_21487_106400.n149 4.0328798828124999
R490 a_21487_106400.n149 a_21487_106400.n182 0.43835598754882815
R491 a_21487_106400.n182 a_21487_106400.n151 3.5945200195312501
R492 a_21487_106400.n151 a_21487_106400.n180 2.0164399414062499
R493 a_21487_106400.n180 a_21487_106400.n153 2.0164399414062499
R494 a_21487_106400.n153 a_21487_106400.n178 3.5945200195312501
R495 a_21487_106400.n155 a_21487_106400.n178 0.43835598754882815
R496 a_21487_106400.n155 a_21487_106400.n157 5.6090898437499996
R497 a_21487_106400# a_21487_106400.n146 455.26600000000002
R498 a_21487_106400.n185 a_21487_106400.t17 214.45500000000001
R499 a_21487_106400.n184 a_21487_106400.n181 214.95500000000001
R500 a_21487_106400.n181 a_21487_106400.n183 31.477599609375002
R501 a_21487_106400.n183 a_21487_106400.n179 31.477599609375002
R502 a_21487_106400.n179 a_21487_106400.n177 62.955101562499998
R503 a_21487_106400.n183 a_21487_106400.t40 68.698898437500006
R504 a_21487_106400.t40 a_21487_106400.n177 538.31200000000001
R505 a_21487_106400.n176 a_21487_106400.t16 214.45500000000001
R506 a_21487_106400.n186 a_21487_106400.n50 14.817400390625
R507 a_21487_106400.n175 a_21487_106400.t39 259.08100000000002
R508 a_21487_106400.n174 a_21487_106400.t20 214.45500000000001
R509 a_21487_106400.n173 a_21487_106400.t19 214.45500000000001
R510 a_21487_106400.t18 a_21487_106400.t15 1784.8299999999999
R511 a_21487_106400.n145 a_21487_106400.t18 475.95499999999998
R512 a_21487_106400.n145 a_21487_106400.t24 1546.8499999999999
R513 a_21487_106400.t24 a_21487_106400.t29 2397.8800000000001
R514 a_21487_106400.t15 a_21487_106400.n143 19529
R515 a_21487_106400.n143 a_21487_106400.n144 7752.1300000000001
R516 a_21487_106400.n144 a_21487_106400.t0 367.14800000000002
R517 a_21487_106400.n144 a_21487_106400.t32 367.14800000000002
R518 a_21487_106400.n144 a_21487_106400.t31 367.14800000000002
R519 a_21487_106400.n144 a_21487_106400.t33 367.14800000000002
R520 a_21487_106400.n143 a_21487_106400.t10 19361.700000000001
R521 a_21487_106400.t10 a_21487_106400.t1 2107.2800000000002
R522 a_21487_106400.t1 a_21487_106400.t12 3877.3899999999999
R523 a_21487_106400.t12 a_21487_106400.n51 3489.6599999999999
R524 a_21487_106400.n51 a_21487_106400.t4 1938.7
R525 a_21487_106400.t4 a_21487_106400.t21 3101.9200000000001
R526 a_21487_106400.t21 a_21487_106400.t7 6203.8299999999999
R527 a_21487_106400.t7 a_21487_106400.t27 1609.96
R528 a_21487_106400.n52 a_21487_106400.n53 4.6207402343749999
R529 a_21487_106400.n51 a_21487_106400.n52 1195.49
R530 a_21487_106400.n52 a_21487_106400.n142 7.57431005859375
R531 a_21487_106400.n56 a_21487_106400.n55 4.6207402343749999
R532 a_21487_106400.n55 a_21487_106400.n57 6.570669921875
R533 a_21487_106400.n55 a_21487_106400.n54 8.1066699218749996
R534 a_21487_106400.n142 a_21487_106400.n54 2.901330078125
R535 a_21487_106400.n60 a_21487_106400.n59 4.6207402343749999
R536 a_21487_106400.n141 a_21487_106400.n58 3.718919921875
R537 a_21487_106400.n59 a_21487_106400.n141 4.4972998046874997
R538 a_21487_106400.n59 a_21487_106400.n142 11.1567998046875
R539 a_21487_106400.n62 a_21487_106400.n61 152
R540 a_21487_106400.n64 a_21487_106400.n63 152
R541 a_21487_106400.n67 a_21487_106400.n66 152
R542 a_21487_106400.n69 a_21487_106400.n68 9.3000000000000007
R543 a_21487_106400.n71 a_21487_106400.n70 9.3000000000000007
R544 a_21487_106400.n73 a_21487_106400.n72 9.3000000000000007
R545 a_21487_106400.n75 a_21487_106400.n74 9.3000000000000007
R546 a_21487_106400.n141 a_21487_106400.n68 1.865469970703125
R547 a_21487_106400.n68 a_21487_106400.n62 0.28699600219726562
R548 a_21487_106400.n62 a_21487_106400.n70 2.3533601074218748
R549 a_21487_106400.n70 a_21487_106400.n64 1.3201800537109376
R550 a_21487_106400.n64 a_21487_106400.n72 1.3201800537109376
R551 a_21487_106400.n72 a_21487_106400.n67 2.3533601074218748
R552 a_21487_106400.n74 a_21487_106400.n67 0.28699600219726562
R553 a_21487_106400.n78 a_21487_106400.n77 9.3000000000000007
R554 a_21487_106400.n79 a_21487_106400.n80 9.3000000000000007
R555 a_21487_106400.n74 a_21487_106400.n77 3.2076398925781251
R556 a_21487_106400.n77 a_21487_106400.n76 3.2187099609374998
R557 a_21487_106400.n79 a_21487_106400.n76 0.22456100463867187
R558 a_21487_106400.n140 a_21487_106400.n79 3.430929931640625
R559 a_21487_106400.n83 a_21487_106400.n82 2.2526201171875
R560 a_21487_106400.n83 a_21487_106400.n87 0.35758700561523438
R561 a_21487_106400.n82 a_21487_106400.n140 2.9597600097656249
R562 a_21487_106400.n82 a_21487_106400.n81 3.6516499023437499
R563 a_21487_106400.n81 a_21487_106400.n84 1.3069100341796875
R564 a_21487_106400.n84 a_21487_106400.t38 120.17100000000001
R565 a_21487_106400.n87 a_21487_106400.n86 4.6207402343749999
R566 a_21487_106400.n139 a_21487_106400.n85 3.718919921875
R567 a_21487_106400.n86 a_21487_106400.n139 4.4972998046874997
R568 a_21487_106400.n86 a_21487_106400.n84 11.1567998046875
R569 a_21487_106400.n89 a_21487_106400.n88 152
R570 a_21487_106400.n91 a_21487_106400.n90 152
R571 a_21487_106400.n94 a_21487_106400.n93 152
R572 a_21487_106400.n96 a_21487_106400.n95 9.3000000000000007
R573 a_21487_106400.n98 a_21487_106400.n97 9.3000000000000007
R574 a_21487_106400.n99 a_21487_106400.n100 9.3000000000000007
R575 a_21487_106400.n139 a_21487_106400.n95 1.865469970703125
R576 a_21487_106400.n95 a_21487_106400.n89 0.28699600219726562
R577 a_21487_106400.n89 a_21487_106400.n97 2.3533601074218748
R578 a_21487_106400.n97 a_21487_106400.n91 1.3201800537109376
R579 a_21487_106400.n99 a_21487_106400.n91 1.3201800537109376
R580 a_21487_106400.n94 a_21487_106400.n99 2.3533601074218748
R581 a_21487_106400.n101 a_21487_106400.n94 1.6479399414062501
R582 a_21487_106400.n104 a_21487_106400.n103 9.3000000000000007
R583 a_21487_106400.n106 a_21487_106400.n105 9.3000000000000007
R584 a_21487_106400.n108 a_21487_106400.n107 9.3000000000000007
R585 a_21487_106400.n110 a_21487_106400.n109 9.3000000000000007
R586 a_21487_106400.n112 a_21487_106400.n111 9.3000000000000007
R587 a_21487_106400.n114 a_21487_106400.n113 9.3000000000000007
R588 a_21487_106400.n116 a_21487_106400.n115 9.3000000000000007
R589 a_21487_106400.n118 a_21487_106400.n117 9.3000000000000007
R590 a_21487_106400.n120 a_21487_106400.n119 9.3000000000000007
R591 a_21487_106400.n122 a_21487_106400.n121 9.3000000000000007
R592 a_21487_106400.n138 a_21487_106400.n137 9.3000000000000007
R593 a_21487_106400.n104 a_21487_106400.n102 6.6348598632812497
R594 a_21487_106400.n106 a_21487_106400.n104 0.11979199981689453
R595 a_21487_106400.n108 a_21487_106400.n106 0.11979199981689453
R596 a_21487_106400.n110 a_21487_106400.n108 0.11979199981689453
R597 a_21487_106400.n112 a_21487_106400.n110 0.11979199981689453
R598 a_21487_106400.n114 a_21487_106400.n112 0.11979199981689453
R599 a_21487_106400.n116 a_21487_106400.n114 0.11979199981689453
R600 a_21487_106400.n118 a_21487_106400.n116 0.11979199981689453
R601 a_21487_106400.n120 a_21487_106400.n118 0.11979199981689453
R602 a_21487_106400.n122 a_21487_106400.n120 0.11979199981689453
R603 a_21487_106400.n138 a_21487_106400.n122 0.11979199981689453
R604 a_21487_106400.n56 a_21487_106400.n138 0.17980400085449219
R605 a_21487_106400.n53 a_21487_106400.n56 0.23981700134277345
R606 a_21487_106400.n53 a_21487_106400.n60 0.23981700134277345
R607 a_21487_106400.n60 a_21487_106400.n69 0.17980400085449219
R608 a_21487_106400.n69 a_21487_106400.n71 0.11979199981689453
R609 a_21487_106400.n71 a_21487_106400.n73 0.11979199981689453
R610 a_21487_106400.n73 a_21487_106400.n75 0.11979199981689453
R611 a_21487_106400.n75 a_21487_106400.n78 0.11979199981689453
R612 a_21487_106400.n78 a_21487_106400.n80 0.11979199981689453
R613 a_21487_106400.n80 a_21487_106400.n83 0.29679098510742186
R614 a_21487_106400.n87 a_21487_106400.n96 0.17980400085449219
R615 a_21487_106400.n96 a_21487_106400.n98 0.11979199981689453
R616 a_21487_106400.n98 a_21487_106400.n100 0.11979199981689453
R617 a_21487_106400.n100 a_21487_106400.n101 4.1154702148437501
R618 a_21487_106400.n117 a_21487_106400.n123 0.22456100463867187
R619 a_21487_106400.n123 a_21487_106400.n119 3.2187099609374998
R620 a_21487_106400.n119 a_21487_106400.n121 3.44327001953125
R621 a_21487_106400.n121 a_21487_106400.n124 3.2187099609374998
R622 a_21487_106400.n137 a_21487_106400.n124 0.22456100463867187
R623 a_21487_106400.n113 a_21487_106400.n125 3.2187099609374998
R624 a_21487_106400.n115 a_21487_106400.n125 0.22456100463867187
R625 a_21487_106400.n115 a_21487_106400.n117 4.5163100585937501
R626 a_21487_106400.n127 a_21487_106400.n126 152
R627 a_21487_106400.n129 a_21487_106400.n128 152
R628 a_21487_106400.n131 a_21487_106400.n130 152
R629 a_21487_106400.n102 a_21487_106400.n134 0.40149899291992186
R630 a_21487_106400.n134 a_21487_106400.n135 1.119280029296875
R631 a_21487_106400.n135 a_21487_106400.n133 0.60269097900390622
R632 a_21487_106400.n133 a_21487_106400.n103 0.74618798828124999
R633 a_21487_106400.n103 a_21487_106400.n105 2.6403601074218752
R634 a_21487_106400.n105 a_21487_106400.n131 0.28699600219726562
R635 a_21487_106400.n131 a_21487_106400.n107 2.3533601074218748
R636 a_21487_106400.n107 a_21487_106400.n129 1.3201800537109376
R637 a_21487_106400.n109 a_21487_106400.n129 1.3201800537109376
R638 a_21487_106400.n109 a_21487_106400.n127 2.3533601074218748
R639 a_21487_106400.n111 a_21487_106400.n127 0.28699600219726562
R640 a_21487_106400.n111 a_21487_106400.n113 3.2076398925781251
R641 a_21487_106400.n136 a_21487_106400.n102 25.612900390625001
R642 a_21487_106400.n135 a_21487_106400.n136 5.4950400390625003
R643 a_21487_106400.n136 a_21487_106400.t43 146.48500000000001
R644 a_21487_106400.n134 a_21487_106400.t3 214.45500000000001
R645 a_21487_106400.n133 a_21487_106400.n130 214.95500000000001
R646 a_21487_106400.n130 a_21487_106400.n132 31.477599609375002
R647 a_21487_106400.n132 a_21487_106400.n128 31.477599609375002
R648 a_21487_106400.n128 a_21487_106400.n126 62.955101562499998
R649 a_21487_106400.n132 a_21487_106400.t44 68.698898437500006
R650 a_21487_106400.t44 a_21487_106400.n126 538.31200000000001
R651 a_21487_106400.n125 a_21487_106400.t11 214.45500000000001
R652 a_21487_106400.n137 a_21487_106400.n57 3.430929931640625
R653 a_21487_106400.n124 a_21487_106400.t2 214.45500000000001
R654 a_21487_106400.n123 a_21487_106400.t14 214.45500000000001
R655 a_21487_106400.n119 a_21487_106400.t41 116.733
R656 a_21487_106400.n101 a_21487_106400.t8 202.12700000000001
R657 a_21487_106400.n85 a_21487_106400.n88 229.05199999999999
R658 a_21487_106400.n88 a_21487_106400.n92 31.477599609375002
R659 a_21487_106400.n92 a_21487_106400.n90 31.477599609375002
R660 a_21487_106400.n90 a_21487_106400.n93 62.955101562499998
R661 a_21487_106400.n92 a_21487_106400.t35 19.667800781250001
R662 a_21487_106400.t35 a_21487_106400.n93 210.18100000000001
R663 a_21487_106400.n85 a_21487_106400.t28 214.45500000000001
R664 a_21487_106400.n81 a_21487_106400.t9 214.45500000000001
R665 a_21487_106400.n140 a_21487_106400.t22 215.14599999999999
R666 a_21487_106400.n76 a_21487_106400.t5 214.45500000000001
R667 a_21487_106400.n58 a_21487_106400.n61 229.05199999999999
R668 a_21487_106400.n61 a_21487_106400.n65 31.477599609375002
R669 a_21487_106400.n65 a_21487_106400.n63 31.477599609375002
R670 a_21487_106400.n63 a_21487_106400.n66 62.955101562499998
R671 a_21487_106400.n65 a_21487_106400.t37 68.698898437500006
R672 a_21487_106400.t37 a_21487_106400.n66 538.31200000000001
R673 a_21487_106400.n142 a_21487_106400.t42 118.375
R674 a_21487_106400.n58 a_21487_106400.t23 214.45500000000001
R675 a_21487_106400.n54 a_21487_106400.t6 214.45500000000001
R676 a_21487_106400.n57 a_21487_106400.t13 215.99100000000001
R677 a_21487_106400.n37 a_21487_106400.t26 214.45500000000001
R678 a_21487_106400.n36 a_21487_106400.n33 214.95500000000001
R679 a_21487_106400.n33 a_21487_106400.n35 31.477599609375002
R680 a_21487_106400.n35 a_21487_106400.n31 31.477599609375002
R681 a_21487_106400.n31 a_21487_106400.n29 62.955101562499998
R682 a_21487_106400.n35 a_21487_106400.t36 68.698898437500006
R683 a_21487_106400.t36 a_21487_106400.n29 538.31200000000001
R684 a_21487_106400.n16 a_21487_106400.t25 214.45500000000001
R685 a_21487_106400.n6 a_21487_106400.n3 214.95500000000001
R686 a_21487_106400.n3 a_21487_106400.n5 31.477599609375002
R687 a_21487_106400.n1 a_21487_106400.n5 31.477599609375002
R688 a_21487_106400.n1 a_21487_106400.n0 62.955101562499998
R689 a_21487_106400.n5 a_21487_106400.t34 19.667800781250001
R690 a_21487_106400.t34 a_21487_106400.n0 210.18100000000001
C155 m5_67100_20000# a_21487_106400# 0 $ **FLOATING
C156 m5_67100_21500# a_21487_106400# 0 $ **FLOATING
C157 m5_66336_20000# a_21487_106400# 8.8871e-16
C158 m5_65100_20000# a_21487_106400# 0 $ **FLOATING
C159 m5_65100_21500# a_21487_106400# 0 $ **FLOATING
C160 m5_23100_106400# a_21487_106400# 0 $ **FLOATING
C161 m5_21100_106400# a_21487_106400# 0 $ **FLOATING
C162 m5_20000_106400# a_21487_106400# 0 $ **FLOATING
C163 m5_23100_107500# a_21487_106400# 0 $ **FLOATING
C164 m5_21100_107500# a_21487_106400# 0 $ **FLOATING
C165 m5_20000_107500# a_21487_106400# 0 $ **FLOATING
C166 m5_23100_109500# a_21487_106400# 0 $ **FLOATING
C167 m5_21100_109500# a_21487_106400# 0 $ **FLOATING
C168 m5_20000_109500# a_21487_106400# 0 $ **FLOATING
C169 m4_66850_20000# a_21487_106400# 0 $ **FLOATING
C170 m4_66660_20000# a_21487_106400# 0 $ **FLOATING
C171 m4_66484_20000# a_21487_106400# 0 $ **FLOATING
C172 m4_66308_20000# a_21487_106400# 0 $ **FLOATING
C173 m4_66050_20000# a_21487_106400# 0 $ **FLOATING
C174 m4_65780_20000# a_21487_106400# 0 $ **FLOATING
C175 m4_65604_20000# a_21487_106400# 0 $ **FLOATING
C176 m4_65428_20000# a_21487_106400# 0 $ **FLOATING
C177 m4_65250_20000# a_21487_106400# 0 $ **FLOATING
C178 m4_65100_20000# a_21487_106400# 0 $ **FLOATING
C179 m4_67540_20876# a_21487_106400# 0 $ **FLOATING
C180 m4_67364_20840# a_21487_106400# 0 $ **FLOATING
C181 m4_67188_20804# a_21487_106400# 0 $ **FLOATING
C182 m4_67012_20768# a_21487_106400# 0 $ **FLOATING
C183 m4_66836_20732# a_21487_106400# 0 $ **FLOATING
C184 m4_67540_21052# a_21487_106400# 0 $ **FLOATING
C185 m4_67364_21016# a_21487_106400# 0 $ **FLOATING
C186 m4_67188_20980# a_21487_106400# 0 $ **FLOATING
C187 m4_67012_20944# a_21487_106400# 0 $ **FLOATING
C188 m4_66836_20908# a_21487_106400# 0 $ **FLOATING
C189 m4_66660_20872# a_21487_106400# 0 $ **FLOATING
C190 m4_66484_20836# a_21487_106400# 0 $ **FLOATING
C191 m4_66308_20800# a_21487_106400# 0 $ **FLOATING
C192 m4_66132_20764# a_21487_106400# 0 $ **FLOATING
C193 m4_65956_20728# a_21487_106400# 0 $ **FLOATING
C194 m4_67540_21228# a_21487_106400# 0 $ **FLOATING
C195 m4_67364_21192# a_21487_106400# 0 $ **FLOATING
C196 m4_67188_21156# a_21487_106400# 0 $ **FLOATING
C197 m4_67012_21120# a_21487_106400# 0 $ **FLOATING
C198 m4_66836_21084# a_21487_106400# 0 $ **FLOATING
C199 m4_66660_21048# a_21487_106400# 0 $ **FLOATING
C200 m4_66484_21012# a_21487_106400# 0 $ **FLOATING
C201 m4_66308_20976# a_21487_106400# 0 $ **FLOATING
C202 m4_66132_20940# a_21487_106400# 0 $ **FLOATING
C203 m4_65956_20904# a_21487_106400# 0 $ **FLOATING
C204 m4_65780_20868# a_21487_106400# 0 $ **FLOATING
C205 m4_65604_20832# a_21487_106400# 0 $ **FLOATING
C206 m4_65428_20796# a_21487_106400# 0 $ **FLOATING
C207 m4_65252_20760# a_21487_106400# 0 $ **FLOATING
C208 m4_65100_20724# a_21487_106400# 0 $ **FLOATING
C209 m4_67540_21404# a_21487_106400# 0 $ **FLOATING
C210 m4_67364_21368# a_21487_106400# 0 $ **FLOATING
C211 m4_67188_21332# a_21487_106400# 0 $ **FLOATING
C212 m4_67012_21296# a_21487_106400# 0 $ **FLOATING
C213 m4_66836_21260# a_21487_106400# 0 $ **FLOATING
C214 m4_66660_21224# a_21487_106400# 0 $ **FLOATING
C215 m4_66484_21188# a_21487_106400# 0 $ **FLOATING
C216 m4_66308_21152# a_21487_106400# 0 $ **FLOATING
C217 m4_66132_21116# a_21487_106400# 0 $ **FLOATING
C218 m4_65956_21080# a_21487_106400# 0 $ **FLOATING
C219 m4_65780_21044# a_21487_106400# 0 $ **FLOATING
C220 m4_65604_21008# a_21487_106400# 0 $ **FLOATING
C221 m4_65428_20972# a_21487_106400# 0 $ **FLOATING
C222 m4_65252_20936# a_21487_106400# 0 $ **FLOATING
C223 m4_65100_20900# a_21487_106400# 0 $ **FLOATING
C224 m4_66836_21436# a_21487_106400# 0 $ **FLOATING
C225 m4_66660_21400# a_21487_106400# 0 $ **FLOATING
C226 m4_66484_21364# a_21487_106400# 0 $ **FLOATING
C227 m4_66308_21328# a_21487_106400# 0 $ **FLOATING
C228 m4_66132_21292# a_21487_106400# 0 $ **FLOATING
C229 m4_65956_21256# a_21487_106400# 0 $ **FLOATING
C230 m4_65780_21220# a_21487_106400# 0 $ **FLOATING
C231 m4_65604_21184# a_21487_106400# 0 $ **FLOATING
C232 m4_65428_21148# a_21487_106400# 0 $ **FLOATING
C233 m4_65252_21112# a_21487_106400# 0 $ **FLOATING
C234 m4_65100_21076# a_21487_106400# 0 $ **FLOATING
C235 m4_65956_21432# a_21487_106400# 0 $ **FLOATING
C236 m4_65780_21396# a_21487_106400# 0 $ **FLOATING
C237 m4_65604_21360# a_21487_106400# 0 $ **FLOATING
C238 m4_65428_21324# a_21487_106400# 0 $ **FLOATING
C239 m4_65252_21288# a_21487_106400# 0 $ **FLOATING
C240 m4_65100_21252# a_21487_106400# 0 $ **FLOATING
C241 m4_65100_21428# a_21487_106400# 0 $ **FLOATING
C242 m4_65100_21658# a_21487_106400# 2.46726e-16
C243 m4_67012_21824# a_21487_106400# 0 $ **FLOATING
C244 m4_66850_21850# a_21487_106400# 0 $ **FLOATING
C245 m4_66132_21820# a_21487_106400# 0 $ **FLOATING
C246 m4_65410_21800# a_21487_106400# 0 $ **FLOATING
C247 m4_65250_21830# a_21487_106400# 0 $ **FLOATING
C248 m4_65100_21860# a_21487_106400# 0 $ **FLOATING
C249 m4_65100_22042# a_21487_106400# 1.1617500000000001e-16
C250 m4_65730_22220# a_21487_106400# 0 $ **FLOATING
C251 m4_65428_22204# a_21487_106400# 0 $ **FLOATING
C252 m4_65100_22426# a_21487_106400# 5.3096900000000011e-16
C253 m4_22690_106400# a_21487_106400# 0 $ **FLOATING
C254 m4_22130_106400# a_21487_106400# 0 $ **FLOATING
C255 m4_22690_106630# a_21487_106400# 0 $ **FLOATING
C256 m4_21570_106400# a_21487_106400# 0 $ **FLOATING
C257 m4_20450_106400# a_21487_106400# 0 $ **FLOATING
C258 m4_22130_106770# a_21487_106400# 0 $ **FLOATING
C259 m4_21010_106490# a_21487_106400# 0 $ **FLOATING
C260 m4_20000_106400# a_21487_106400# 0 $ **FLOATING
C261 m4_22690_107190# a_21487_106400# 0 $ **FLOATING
C262 m4_21570_106910# a_21487_106400# 0 $ **FLOATING
C263 m4_20450_106630# a_21487_106400# 0 $ **FLOATING
C264 m4_22130_107330# a_21487_106400# 0 $ **FLOATING
C265 m4_21010_107050# a_21487_106400# 0 $ **FLOATING
C266 m4_20000_106770# a_21487_106400# 0 $ **FLOATING
C267 m4_22690_107750# a_21487_106400# 0 $ **FLOATING
C268 m4_21570_107470# a_21487_106400# 0 $ **FLOATING
C269 m4_20450_107190# a_21487_106400# 0 $ **FLOATING
C270 m4_22130_107890# a_21487_106400# 0 $ **FLOATING
C271 m4_21010_107610# a_21487_106400# 0 $ **FLOATING
C272 m4_20000_107330# a_21487_106400# 0 $ **FLOATING
C273 m4_22690_108310# a_21487_106400# 0 $ **FLOATING
C274 m4_21570_108030# a_21487_106400# 0 $ **FLOATING
C275 m4_20450_107750# a_21487_106400# 0 $ **FLOATING
C276 m4_22130_108450# a_21487_106400# 0 $ **FLOATING
C277 m4_21010_108170# a_21487_106400# 0 $ **FLOATING
C278 m4_20000_107890# a_21487_106400# 0 $ **FLOATING
C279 m4_22690_108870# a_21487_106400# 0 $ **FLOATING
C280 m4_21570_108590# a_21487_106400# 0 $ **FLOATING
C281 m4_20450_108310# a_21487_106400# 0 $ **FLOATING
C282 m4_22130_109010# a_21487_106400# 0 $ **FLOATING
C283 m4_21010_108730# a_21487_106400# 0 $ **FLOATING
C284 m4_20000_108450# a_21487_106400# 0 $ **FLOATING
C285 m4_22690_109430# a_21487_106400# 0 $ **FLOATING
C286 m4_21570_109150# a_21487_106400# 0 $ **FLOATING
C287 m4_20450_108870# a_21487_106400# 0 $ **FLOATING
C288 m4_22130_109570# a_21487_106400# 0 $ **FLOATING
C289 m4_21010_109290# a_21487_106400# 0 $ **FLOATING
C290 m4_20000_109010# a_21487_106400# 0 $ **FLOATING
C291 m4_20450_109430# a_21487_106400# 0 $ **FLOATING
C292 m4_20000_109570# a_21487_106400# 0 $ **FLOATING
C293 m3_67434_20000# a_21487_106400# 0 $ **FLOATING
C294 m3_67434_20066# a_21487_106400# 0 $ **FLOATING
C295 m3_66906_20000# a_21487_106400# 0 $ **FLOATING
C296 m3_66730_20000# a_21487_106400# 0 $ **FLOATING
C297 m3_67434_20242# a_21487_106400# 0 $ **FLOATING
C298 m3_66906_20134# a_21487_106400# 0 $ **FLOATING
C299 m3_66730_20098# a_21487_106400# 0 $ **FLOATING
C300 m3_66554_20062# a_21487_106400# 0 $ **FLOATING
C301 m3_66378_20026# a_21487_106400# 0 $ **FLOATING
C302 m3_66202_20000# a_21487_106400# 0 $ **FLOATING
C303 m3_66026_20000# a_21487_106400# 0 $ **FLOATING
C304 m3_65850_20000# a_21487_106400# 0 $ **FLOATING
C305 m3_67434_20418# a_21487_106400# 0 $ **FLOATING
C306 m3_66906_20310# a_21487_106400# 0 $ **FLOATING
C307 m3_66730_20274# a_21487_106400# 0 $ **FLOATING
C308 m3_66554_20238# a_21487_106400# 0 $ **FLOATING
C309 m3_66378_20202# a_21487_106400# 0 $ **FLOATING
C310 m3_66202_20166# a_21487_106400# 0 $ **FLOATING
C311 m3_66026_20130# a_21487_106400# 0 $ **FLOATING
C312 m3_65498_20022# a_21487_106400# 0 $ **FLOATING
C313 m3_65322_20000# a_21487_106400# 0 $ **FLOATING
C314 m3_65146_20000# a_21487_106400# 0 $ **FLOATING
C315 m3_67434_20594# a_21487_106400# 0 $ **FLOATING
C316 m3_66906_20486# a_21487_106400# 0 $ **FLOATING
C317 m3_66730_20450# a_21487_106400# 0 $ **FLOATING
C318 m3_66554_20414# a_21487_106400# 0 $ **FLOATING
C319 m3_66378_20378# a_21487_106400# 0 $ **FLOATING
C320 m3_66202_20342# a_21487_106400# 0 $ **FLOATING
C321 m3_66026_20306# a_21487_106400# 0 $ **FLOATING
C322 m3_65498_20198# a_21487_106400# 0 $ **FLOATING
C323 m3_65322_20162# a_21487_106400# 0 $ **FLOATING
C324 m3_65146_20126# a_21487_106400# 0 $ **FLOATING
C325 m3_67434_20770# a_21487_106400# 0 $ **FLOATING
C326 m3_67258_20734# a_21487_106400# 0 $ **FLOATING
C327 m3_66906_20662# a_21487_106400# 0 $ **FLOATING
C328 m3_66730_20626# a_21487_106400# 0 $ **FLOATING
C329 m3_66554_20590# a_21487_106400# 0 $ **FLOATING
C330 m3_66378_20554# a_21487_106400# 0 $ **FLOATING
C331 m3_66202_20518# a_21487_106400# 0 $ **FLOATING
C332 m3_66026_20482# a_21487_106400# 0 $ **FLOATING
C333 m3_65498_20374# a_21487_106400# 0 $ **FLOATING
C334 m3_65322_20338# a_21487_106400# 0 $ **FLOATING
C335 m3_65146_20302# a_21487_106400# 0 $ **FLOATING
C336 m3_67434_20946# a_21487_106400# 0 $ **FLOATING
C337 m3_67258_20910# a_21487_106400# 0 $ **FLOATING
C338 m3_67082_20874# a_21487_106400# 0 $ **FLOATING
C339 m3_66906_20838# a_21487_106400# 0 $ **FLOATING
C340 m3_66730_20802# a_21487_106400# 0 $ **FLOATING
C341 m3_66554_20766# a_21487_106400# 0 $ **FLOATING
C342 m3_66378_20730# a_21487_106400# 0 $ **FLOATING
C343 m3_66202_20694# a_21487_106400# 0 $ **FLOATING
C344 m3_66026_20658# a_21487_106400# 0 $ **FLOATING
C345 m3_65498_20550# a_21487_106400# 0 $ **FLOATING
C346 m3_65322_20514# a_21487_106400# 0 $ **FLOATING
C347 m3_65146_20478# a_21487_106400# 0 $ **FLOATING
C348 m3_67434_21122# a_21487_106400# 0 $ **FLOATING
C349 m3_67258_21086# a_21487_106400# 0 $ **FLOATING
C350 m3_67082_21050# a_21487_106400# 0 $ **FLOATING
C351 m3_66906_21014# a_21487_106400# 0 $ **FLOATING
C352 m3_66730_20978# a_21487_106400# 0 $ **FLOATING
C353 m3_66554_20942# a_21487_106400# 0 $ **FLOATING
C354 m3_66378_20906# a_21487_106400# 0 $ **FLOATING
C355 m3_66202_20870# a_21487_106400# 0 $ **FLOATING
C356 m3_66026_20834# a_21487_106400# 0 $ **FLOATING
C357 m3_65850_20798# a_21487_106400# 0 $ **FLOATING
C358 m3_65674_20762# a_21487_106400# 0 $ **FLOATING
C359 m3_65498_20726# a_21487_106400# 0 $ **FLOATING
C360 m3_65322_20690# a_21487_106400# 0 $ **FLOATING
C361 m3_65146_20654# a_21487_106400# 0 $ **FLOATING
C362 m3_66026_21010# a_21487_106400# 0 $ **FLOATING
C363 m3_65850_20974# a_21487_106400# 0 $ **FLOATING
C364 m3_65674_20938# a_21487_106400# 0 $ **FLOATING
C365 m3_65498_20902# a_21487_106400# 0 $ **FLOATING
C366 m3_65322_20866# a_21487_106400# 0 $ **FLOATING
C367 m3_65146_20830# a_21487_106400# 0 $ **FLOATING
C368 m3_67434_21298# a_21487_106400# 0 $ **FLOATING
C369 m3_66906_21190# a_21487_106400# 0 $ **FLOATING
C370 m3_66730_21154# a_21487_106400# 0 $ **FLOATING
C371 m3_65498_21078# a_21487_106400# 0 $ **FLOATING
C372 m3_65322_21042# a_21487_106400# 0 $ **FLOATING
C373 m3_65146_21006# a_21487_106400# 0 $ **FLOATING
C374 m3_67434_21474# a_21487_106400# 0 $ **FLOATING
C375 m3_67130_21320# a_21487_106400# 0 $ **FLOATING
C376 m3_66906_21366# a_21487_106400# 0 $ **FLOATING
C377 m3_66610_21340# a_21487_106400# 0 $ **FLOATING
C378 m3_66350_21220# a_21487_106400# 0 $ **FLOATING
C379 m3_66090_21360# a_21487_106400# 0 $ **FLOATING
C380 m3_65830_21240# a_21487_106400# 0 $ **FLOATING
C381 m3_67434_21650# a_21487_106400# 0 $ **FLOATING
C382 m3_67434_21826# a_21487_106400# 0 $ **FLOATING
C383 m3_67434_22002# a_21487_106400# 0 $ **FLOATING
C384 m3_66930_21650# a_21487_106400# 0 $ **FLOATING
C385 m3_66730_21682# a_21487_106400# 0 $ **FLOATING
C386 m3_66554_21646# a_21487_106400# 0 $ **FLOATING
C387 m3_66378_21610# a_21487_106400# 0 $ **FLOATING
C388 m3_65850_21502# a_21487_106400# 0 $ **FLOATING
C389 m3_65570_21380# a_21487_106400# 0 $ **FLOATING
C390 m3_65310_21260# a_21487_106400# 0 $ **FLOATING
C391 m3_65110_21200# a_21487_106400# 0 $ **FLOATING
C392 m3_65110_21360# a_21487_106400# 0 $ **FLOATING
C393 m3_66730_21858# a_21487_106400# 0 $ **FLOATING
C394 m3_66554_21822# a_21487_106400# 0 $ **FLOATING
C395 m3_66378_21786# a_21487_106400# 0 $ **FLOATING
C396 m3_66202_21750# a_21487_106400# 0 $ **FLOATING
C397 m3_66026_21714# a_21487_106400# 0 $ **FLOATING
C398 m3_65850_21678# a_21487_106400# 0 $ **FLOATING
C399 m3_65674_21642# a_21487_106400# 0 $ **FLOATING
C400 m3_65322_21570# a_21487_106400# 0 $ **FLOATING
C401 m3_67434_22178# a_21487_106400# 0 $ **FLOATING
C402 m3_67258_22142# a_21487_106400# 0 $ **FLOATING
C403 m3_66730_22034# a_21487_106400# 0 $ **FLOATING
C404 m3_66554_21998# a_21487_106400# 0 $ **FLOATING
C405 m3_66378_21962# a_21487_106400# 0 $ **FLOATING
C406 m3_66202_21926# a_21487_106400# 0 $ **FLOATING
C407 m3_66026_21890# a_21487_106400# 0 $ **FLOATING
C408 m3_65850_21854# a_21487_106400# 0 $ **FLOATING
C409 m3_65674_21818# a_21487_106400# 0 $ **FLOATING
C410 m3_65498_21782# a_21487_106400# 0 $ **FLOATING
C411 m3_65322_21746# a_21487_106400# 0 $ **FLOATING
C412 m3_67434_22354# a_21487_106400# 0 $ **FLOATING
C413 m3_67258_22318# a_21487_106400# 0 $ **FLOATING
C414 m3_67082_22282# a_21487_106400# 0 $ **FLOATING
C415 m3_66906_22246# a_21487_106400# 0 $ **FLOATING
C416 m3_66730_22210# a_21487_106400# 0 $ **FLOATING
C417 m3_66554_22174# a_21487_106400# 0 $ **FLOATING
C418 m3_66378_22138# a_21487_106400# 0 $ **FLOATING
C419 m3_66202_22102# a_21487_106400# 0 $ **FLOATING
C420 m3_65674_21994# a_21487_106400# 0 $ **FLOATING
C421 m3_65498_21958# a_21487_106400# 0 $ **FLOATING
C422 m3_65322_21922# a_21487_106400# 0 $ **FLOATING
C423 m3_67258_22494# a_21487_106400# 0 $ **FLOATING
C424 m3_67082_22458# a_21487_106400# 0 $ **FLOATING
C425 m3_66906_22422# a_21487_106400# 0 $ **FLOATING
C426 m3_66730_22386# a_21487_106400# 0 $ **FLOATING
C427 m3_66554_22350# a_21487_106400# 0 $ **FLOATING
C428 m3_66378_22314# a_21487_106400# 0 $ **FLOATING
C429 m3_66202_22278# a_21487_106400# 0 $ **FLOATING
C430 m3_65674_22170# a_21487_106400# 0 $ **FLOATING
C431 m3_65498_22134# a_21487_106400# 0 $ **FLOATING
C432 m3_65322_22098# a_21487_106400# 0 $ **FLOATING
C433 m3_66378_22490# a_21487_106400# 0 $ **FLOATING
C434 m3_66202_22454# a_21487_106400# 0 $ **FLOATING
C435 m3_66000_22226# a_21487_106400# 1.5996000000000004e-16
C436 m3_65674_22346# a_21487_106400# 0 $ **FLOATING
C437 m3_65498_22310# a_21487_106400# 0 $ **FLOATING
C438 m3_65322_22274# a_21487_106400# 0 $ **FLOATING
C439 m3_65146_22238# a_21487_106400# 0 $ **FLOATING
C440 m3_65498_22486# a_21487_106400# 0 $ **FLOATING
C441 m3_65322_22450# a_21487_106400# 0 $ **FLOATING
C442 m3_65146_22414# a_21487_106400# 0 $ **FLOATING
C443 m3_22690_106400# a_21487_106400# 0 $ **FLOATING
C444 m3_22130_106400# a_21487_106400# 0 $ **FLOATING
C445 m3_22690_106630# a_21487_106400# 0 $ **FLOATING
C446 m3_21570_106400# a_21487_106400# 0 $ **FLOATING
C447 m3_20450_106400# a_21487_106400# 0 $ **FLOATING
C448 m3_22130_106770# a_21487_106400# 0 $ **FLOATING
C449 m3_21010_106490# a_21487_106400# 0 $ **FLOATING
C450 m3_20000_106400# a_21487_106400# 0 $ **FLOATING
C451 m3_22690_107190# a_21487_106400# 0 $ **FLOATING
C452 m3_21570_106910# a_21487_106400# 0 $ **FLOATING
C453 m3_20450_106630# a_21487_106400# 0 $ **FLOATING
C454 m3_22130_107330# a_21487_106400# 0 $ **FLOATING
C455 m3_21010_107050# a_21487_106400# 0 $ **FLOATING
C456 m3_20000_106770# a_21487_106400# 0 $ **FLOATING
C457 m3_22690_107750# a_21487_106400# 0 $ **FLOATING
C458 m3_21570_107470# a_21487_106400# 0 $ **FLOATING
C459 m3_20450_107190# a_21487_106400# 0 $ **FLOATING
C460 m3_22130_107890# a_21487_106400# 0 $ **FLOATING
C461 m3_21010_107610# a_21487_106400# 0 $ **FLOATING
C462 m3_20000_107330# a_21487_106400# 0 $ **FLOATING
C463 m3_22690_108310# a_21487_106400# 0 $ **FLOATING
C464 m3_21570_108030# a_21487_106400# 0 $ **FLOATING
C465 m3_20450_107750# a_21487_106400# 0 $ **FLOATING
C466 m3_22130_108450# a_21487_106400# 0 $ **FLOATING
C467 m3_21010_108170# a_21487_106400# 0 $ **FLOATING
C468 m3_20000_107890# a_21487_106400# 0 $ **FLOATING
C469 m3_22690_108870# a_21487_106400# 0 $ **FLOATING
C470 m3_21570_108590# a_21487_106400# 0 $ **FLOATING
C471 m3_20450_108310# a_21487_106400# 0 $ **FLOATING
C472 m3_22130_109010# a_21487_106400# 0 $ **FLOATING
C473 m3_21010_108730# a_21487_106400# 0 $ **FLOATING
C474 m3_20000_108450# a_21487_106400# 0 $ **FLOATING
C475 m3_22690_109430# a_21487_106400# 0 $ **FLOATING
C476 m3_21570_109150# a_21487_106400# 0 $ **FLOATING
C477 m3_20450_108870# a_21487_106400# 0 $ **FLOATING
C478 m3_22130_109570# a_21487_106400# 0 $ **FLOATING
C479 m3_21010_109290# a_21487_106400# 0 $ **FLOATING
C480 m3_20000_109010# a_21487_106400# 0 $ **FLOATING
C481 m3_20450_109430# a_21487_106400# 0 $ **FLOATING
C482 m3_20000_109570# a_21487_106400# 0 $ **FLOATING
C483 m2_67580_20024# a_21487_106400# 0 $ **FLOATING
C484 m2_67424_20008# a_21487_106400# 0 $ **FLOATING
C485 m2_67268_20000# a_21487_106400# 0 $ **FLOATING
C486 m2_67112_20000# a_21487_106400# 0 $ **FLOATING
C487 m2_66956_20000# a_21487_106400# 0 $ **FLOATING
C488 m2_66800_20000# a_21487_106400# 0 $ **FLOATING
C489 m2_66644_20000# a_21487_106400# 0 $ **FLOATING
C490 m2_66488_20000# a_21487_106400# 0 $ **FLOATING
C491 m2_67580_20180# a_21487_106400# 0 $ **FLOATING
C492 m2_67424_20164# a_21487_106400# 0 $ **FLOATING
C493 m2_66956_20116# a_21487_106400# 0 $ **FLOATING
C494 m2_66800_20100# a_21487_106400# 0 $ **FLOATING
C495 m2_66644_20084# a_21487_106400# 0 $ **FLOATING
C496 m2_66488_20068# a_21487_106400# 0 $ **FLOATING
C497 m2_66332_20052# a_21487_106400# 0 $ **FLOATING
C498 m2_66176_20036# a_21487_106400# 0 $ **FLOATING
C499 m2_66021_20020# a_21487_106400# 0 $ **FLOATING
C500 m2_65864_20004# a_21487_106400# 0 $ **FLOATING
C501 m2_65708_20000# a_21487_106400# 0 $ **FLOATING
C502 m2_65552_20000# a_21487_106400# 0 $ **FLOATING
C503 m2_65396_20000# a_21487_106400# 0 $ **FLOATING
C504 m2_65240_20000# a_21487_106400# 0 $ **FLOATING
C505 m2_65100_20000# a_21487_106400# 0 $ **FLOATING
C506 m2_67580_20336# a_21487_106400# 0 $ **FLOATING
C507 m2_67424_20320# a_21487_106400# 0 $ **FLOATING
C508 m2_66956_20272# a_21487_106400# 0 $ **FLOATING
C509 m2_66800_20256# a_21487_106400# 0 $ **FLOATING
C510 m2_66644_20240# a_21487_106400# 0 $ **FLOATING
C511 m2_66488_20224# a_21487_106400# 0 $ **FLOATING
C512 m2_66332_20208# a_21487_106400# 0 $ **FLOATING
C513 m2_66176_20192# a_21487_106400# 0 $ **FLOATING
C514 m2_66021_20176# a_21487_106400# 0 $ **FLOATING
C515 m2_65552_20128# a_21487_106400# 0 $ **FLOATING
C516 m2_65396_20112# a_21487_106400# 0 $ **FLOATING
C517 m2_65240_20096# a_21487_106400# 0 $ **FLOATING
C518 m2_65100_20080# a_21487_106400# 0 $ **FLOATING
C519 m2_67580_20492# a_21487_106400# 0 $ **FLOATING
C520 m2_67424_20476# a_21487_106400# 0 $ **FLOATING
C521 m2_66956_20428# a_21487_106400# 0 $ **FLOATING
C522 m2_66800_20412# a_21487_106400# 0 $ **FLOATING
C523 m2_66644_20396# a_21487_106400# 0 $ **FLOATING
C524 m2_66488_20380# a_21487_106400# 0 $ **FLOATING
C525 m2_66332_20364# a_21487_106400# 0 $ **FLOATING
C526 m2_66176_20348# a_21487_106400# 0 $ **FLOATING
C527 m2_66021_20332# a_21487_106400# 0 $ **FLOATING
C528 m2_65552_20284# a_21487_106400# 0 $ **FLOATING
C529 m2_65396_20268# a_21487_106400# 0 $ **FLOATING
C530 m2_65240_20252# a_21487_106400# 0 $ **FLOATING
C531 m2_65100_20236# a_21487_106400# 0 $ **FLOATING
C532 m2_67580_20648# a_21487_106400# 0 $ **FLOATING
C533 m2_67424_20632# a_21487_106400# 0 $ **FLOATING
C534 m2_66956_20584# a_21487_106400# 0 $ **FLOATING
C535 m2_66800_20568# a_21487_106400# 0 $ **FLOATING
C536 m2_66644_20552# a_21487_106400# 0 $ **FLOATING
C537 m2_66488_20536# a_21487_106400# 0 $ **FLOATING
C538 m2_66332_20520# a_21487_106400# 0 $ **FLOATING
C539 m2_66176_20504# a_21487_106400# 0 $ **FLOATING
C540 m2_66021_20488# a_21487_106400# 0 $ **FLOATING
C541 m2_65552_20440# a_21487_106400# 0 $ **FLOATING
C542 m2_65396_20424# a_21487_106400# 0 $ **FLOATING
C543 m2_65240_20408# a_21487_106400# 0 $ **FLOATING
C544 m2_65100_20392# a_21487_106400# 0 $ **FLOATING
C545 m2_67580_20804# a_21487_106400# 0 $ **FLOATING
C546 m2_67424_20788# a_21487_106400# 0 $ **FLOATING
C547 m2_67268_20772# a_21487_106400# 0 $ **FLOATING
C548 m2_67112_20756# a_21487_106400# 0 $ **FLOATING
C549 m2_66956_20740# a_21487_106400# 0 $ **FLOATING
C550 m2_66800_20724# a_21487_106400# 0 $ **FLOATING
C551 m2_66644_20708# a_21487_106400# 0 $ **FLOATING
C552 m2_66488_20692# a_21487_106400# 0 $ **FLOATING
C553 m2_66332_20676# a_21487_106400# 0 $ **FLOATING
C554 m2_66176_20660# a_21487_106400# 0 $ **FLOATING
C555 m2_66021_20644# a_21487_106400# 0 $ **FLOATING
C556 m2_65552_20596# a_21487_106400# 0 $ **FLOATING
C557 m2_65396_20580# a_21487_106400# 0 $ **FLOATING
C558 m2_65240_20564# a_21487_106400# 0 $ **FLOATING
C559 m2_65100_20548# a_21487_106400# 0 $ **FLOATING
C560 m2_67300_20940# a_21487_106400# 0 $ **FLOATING
C561 m2_67112_20912# a_21487_106400# 0 $ **FLOATING
C562 m2_66956_20896# a_21487_106400# 0 $ **FLOATING
C563 m2_66800_20880# a_21487_106400# 0 $ **FLOATING
C564 m2_66644_20864# a_21487_106400# 0 $ **FLOATING
C565 m2_66488_20848# a_21487_106400# 0 $ **FLOATING
C566 m2_66332_20832# a_21487_106400# 0 $ **FLOATING
C567 m2_66176_20816# a_21487_106400# 0 $ **FLOATING
C568 m2_66020_20800# a_21487_106400# 0 $ **FLOATING
C569 m2_65864_20784# a_21487_106400# 0 $ **FLOATING
C570 m2_65708_20768# a_21487_106400# 0 $ **FLOATING
C571 m2_65552_20752# a_21487_106400# 0 $ **FLOATING
C572 m2_65396_20736# a_21487_106400# 0 $ **FLOATING
C573 m2_65240_20720# a_21487_106400# 0 $ **FLOATING
C574 m2_65100_20704# a_21487_106400# 0 $ **FLOATING
C575 m2_67112_21068# a_21487_106400# 0 $ **FLOATING
C576 m2_66956_21052# a_21487_106400# 0 $ **FLOATING
C577 m2_66800_21036# a_21487_106400# 0 $ **FLOATING
C578 m2_66644_21020# a_21487_106400# 0 $ **FLOATING
C579 m2_66488_21004# a_21487_106400# 0 $ **FLOATING
C580 m2_66332_20988# a_21487_106400# 0 $ **FLOATING
C581 m2_66176_20972# a_21487_106400# 0 $ **FLOATING
C582 m2_66020_20956# a_21487_106400# 0 $ **FLOATING
C583 m2_65864_20940# a_21487_106400# 0 $ **FLOATING
C584 m2_65708_20924# a_21487_106400# 0 $ **FLOATING
C585 m2_65552_20908# a_21487_106400# 0 $ **FLOATING
C586 m2_65396_20892# a_21487_106400# 0 $ **FLOATING
C587 m2_65240_20876# a_21487_106400# 0 $ **FLOATING
C588 m2_65100_20860# a_21487_106400# 0 $ **FLOATING
C589 m2_67424_21256# a_21487_106400# 0 $ **FLOATING
C590 m2_67268_21240# a_21487_106400# 0 $ **FLOATING
C591 m2_67112_21224# a_21487_106400# 0 $ **FLOATING
C592 m2_66956_21208# a_21487_106400# 0 $ **FLOATING
C593 m2_66800_21192# a_21487_106400# 0 $ **FLOATING
C594 m2_66644_21176# a_21487_106400# 0 $ **FLOATING
C595 m2_66488_21160# a_21487_106400# 0 $ **FLOATING
C596 m2_66332_21144# a_21487_106400# 0 $ **FLOATING
C597 m2_66176_21128# a_21487_106400# 0 $ **FLOATING
C598 m2_66020_21112# a_21487_106400# 0 $ **FLOATING
C599 m2_65864_21096# a_21487_106400# 0 $ **FLOATING
C600 m2_65708_21080# a_21487_106400# 0 $ **FLOATING
C601 m2_65552_21064# a_21487_106400# 0 $ **FLOATING
C602 m2_65396_21048# a_21487_106400# 0 $ **FLOATING
C603 m2_65240_21032# a_21487_106400# 0 $ **FLOATING
C604 m2_65100_21016# a_21487_106400# 0 $ **FLOATING
C605 m2_66700_21360# a_21487_106400# 0 $ **FLOATING
C606 m2_66400_21320# a_21487_106400# 0 $ **FLOATING
C607 m2_66300_21340# a_21487_106400# 0 $ **FLOATING
C608 m2_66200_21360# a_21487_106400# 0 $ **FLOATING
C609 m2_65864_21252# a_21487_106400# 0 $ **FLOATING
C610 m2_65708_21236# a_21487_106400# 0 $ **FLOATING
C611 m2_65552_21220# a_21487_106400# 0 $ **FLOATING
C612 m2_65396_21204# a_21487_106400# 0 $ **FLOATING
C613 m2_65240_21188# a_21487_106400# 0 $ **FLOATING
C614 m2_65100_21172# a_21487_106400# 0 $ **FLOATING
C615 m2_65200_21360# a_21487_106400# 0 $ **FLOATING
C616 m2_65100_21482# a_21487_106400# 3.5008700000000003e-16
C617 m2_65100_21674# a_21487_106400# 1.9860200000000002e-16
C618 m2_67580_21896# a_21487_106400# 0 $ **FLOATING
C619 m2_67424_21880# a_21487_106400# 0 $ **FLOATING
C620 m2_67268_21864# a_21487_106400# 0 $ **FLOATING
C621 m2_67112_21848# a_21487_106400# 0 $ **FLOATING
C622 m2_66956_21832# a_21487_106400# 0 $ **FLOATING
C623 m2_66800_21816# a_21487_106400# 0 $ **FLOATING
C624 m2_66600_21780# a_21487_106400# 0 $ **FLOATING
C625 m2_66500_21800# a_21487_106400# 0 $ **FLOATING
C626 m2_66700_21860# a_21487_106400# 0 $ **FLOATING
C627 m2_66400_21820# a_21487_106400# 0 $ **FLOATING
C628 m2_66100_21780# a_21487_106400# 0 $ **FLOATING
C629 m2_66600_21880# a_21487_106400# 0 $ **FLOATING
C630 m2_66500_21900# a_21487_106400# 0 $ **FLOATING
C631 m2_67000_22000# a_21487_106400# 0 $ **FLOATING
C632 m2_66700_21960# a_21487_106400# 0 $ **FLOATING
C633 m2_66900_22020# a_21487_106400# 0 $ **FLOATING
C634 m2_66600_21980# a_21487_106400# 0 $ **FLOATING
C635 m2_66500_22000# a_21487_106400# 0 $ **FLOATING
C636 m2_66332_21924# a_21487_106400# 0 $ **FLOATING
C637 m2_66176_21908# a_21487_106400# 0 $ **FLOATING
C638 m2_66020_21892# a_21487_106400# 0 $ **FLOATING
C639 m2_65864_21876# a_21487_106400# 0 $ **FLOATING
C640 m2_65708_21860# a_21487_106400# 0 $ **FLOATING
C641 m2_65552_21844# a_21487_106400# 0 $ **FLOATING
C642 m2_65396_21828# a_21487_106400# 0 $ **FLOATING
C643 m2_65240_21812# a_21487_106400# 0 $ **FLOATING
C644 m2_65100_21780# a_21487_106400# 0 $ **FLOATING
C645 m2_66200_22160# a_21487_106400# 0 $ **FLOATING
C646 m2_66020_22048# a_21487_106400# 0 $ **FLOATING
C647 m2_65864_22032# a_21487_106400# 0 $ **FLOATING
C648 m2_65708_22016# a_21487_106400# 0 $ **FLOATING
C649 m2_65552_22000# a_21487_106400# 0 $ **FLOATING
C650 m2_65396_21984# a_21487_106400# 0 $ **FLOATING
C651 m2_65240_21968# a_21487_106400# 0 $ **FLOATING
C652 m2_65100_21952# a_21487_106400# 0 $ **FLOATING
C653 m2_65900_22220# a_21487_106400# 0 $ **FLOATING
C654 m2_65600_22180# a_21487_106400# 0 $ **FLOATING
C655 m2_65500_22200# a_21487_106400# 0 $ **FLOATING
C656 m2_65400_22220# a_21487_106400# 0 $ **FLOATING
C657 m2_65240_22124# a_21487_106400# 0 $ **FLOATING
C658 m2_65100_22108# a_21487_106400# 0 $ **FLOATING
C659 m2_65100_22346# a_21487_106400# 6.0877200000000016e-16
C660 m2_67300_22440# a_21487_106400# 0 $ **FLOATING
C661 m2_67200_22460# a_21487_106400# 0 $ **FLOATING
C662 m2_67100_22480# a_21487_106400# 0 $ **FLOATING
C663 m2_66800_22440# a_21487_106400# 0 $ **FLOATING
C664 m2_66700_22460# a_21487_106400# 0 $ **FLOATING
C665 m2_66600_22480# a_21487_106400# 0 $ **FLOATING
C666 m2_66300_22440# a_21487_106400# 0 $ **FLOATING
C667 m2_66200_22460# a_21487_106400# 0 $ **FLOATING
C668 m2_66100_22480# a_21487_106400# 0 $ **FLOATING
C669 m2_65800_22440# a_21487_106400# 0 $ **FLOATING
C670 m2_65700_22460# a_21487_106400# 0 $ **FLOATING
C671 m2_65600_22480# a_21487_106400# 0 $ **FLOATING
C672 m2_65300_22440# a_21487_106400# 0 $ **FLOATING
C673 m2_65200_22460# a_21487_106400# 0 $ **FLOATING
C674 m2_65100_22480# a_21487_106400# 0 $ **FLOATING
C675 m2_22690_106400# a_21487_106400# 0 $ **FLOATING
C676 m2_22900_106520# a_21487_106400# 0 $ **FLOATING
C677 m2_22130_106400# a_21487_106400# 0 $ **FLOATING
C678 m2_22690_106630# a_21487_106400# 0 $ **FLOATING
C679 m2_22200_106660# a_21487_106400# 0 $ **FLOATING
C680 m2_21570_106400# a_21487_106400# 0 $ **FLOATING
C681 m2_21100_106400# a_21487_106400# 0 $ **FLOATING
C682 m2_20900_106420# a_21487_106400# 0 $ **FLOATING
C683 m2_20450_106400# a_21487_106400# 0 $ **FLOATING
C684 m2_23100_107080# a_21487_106400# 0 $ **FLOATING
C685 m2_22600_107080# a_21487_106400# 0 $ **FLOATING
C686 m2_22130_106770# a_21487_106400# 0 $ **FLOATING
C687 m2_22000_106800# a_21487_106400# 0 $ **FLOATING
C688 m2_21500_106800# a_21487_106400# 0 $ **FLOATING
C689 m2_21010_106490# a_21487_106400# 0 $ **FLOATING
C690 m2_20900_106520# a_21487_106400# 0 $ **FLOATING
C691 m2_20400_106520# a_21487_106400# 0 $ **FLOATING
C692 m2_20000_106400# a_21487_106400# 0 $ **FLOATING
C693 m2_20900_106620# a_21487_106400# 0 $ **FLOATING
C694 m2_20900_106720# a_21487_106400# 0 $ **FLOATING
C695 m2_20900_106820# a_21487_106400# 0 $ **FLOATING
C696 m2_22690_107190# a_21487_106400# 0 $ **FLOATING
C697 m2_22400_107220# a_21487_106400# 0 $ **FLOATING
C698 m2_21570_106910# a_21487_106400# 0 $ **FLOATING
C699 m2_21300_106940# a_21487_106400# 0 $ **FLOATING
C700 m2_20900_106920# a_21487_106400# 0 $ **FLOATING
C701 m2_22800_107640# a_21487_106400# 0 $ **FLOATING
C702 m2_22130_107330# a_21487_106400# 0 $ **FLOATING
C703 m2_21700_107360# a_21487_106400# 0 $ **FLOATING
C704 m2_21010_107050# a_21487_106400# 0 $ **FLOATING
C705 m2_20900_107020# a_21487_106400# 0 $ **FLOATING
C706 m2_20450_106630# a_21487_106400# 0 $ **FLOATING
C707 m2_20200_106660# a_21487_106400# 0 $ **FLOATING
C708 m2_20900_107120# a_21487_106400# 0 $ **FLOATING
C709 m2_20600_107080# a_21487_106400# 0 $ **FLOATING
C710 m2_20000_106770# a_21487_106400# 0 $ **FLOATING
C711 m2_20900_107220# a_21487_106400# 0 $ **FLOATING
C712 m2_20900_107320# a_21487_106400# 0 $ **FLOATING
C713 m2_22690_107750# a_21487_106400# 0 $ **FLOATING
C714 m2_22100_107780# a_21487_106400# 0 $ **FLOATING
C715 m2_21570_107470# a_21487_106400# 0 $ **FLOATING
C716 m2_20900_107420# a_21487_106400# 0 $ **FLOATING
C717 m2_21000_107500# a_21487_106400# 0 $ **FLOATING
C718 m2_20900_107520# a_21487_106400# 0 $ **FLOATING
C719 m2_20450_107190# a_21487_106400# 0 $ **FLOATING
C720 m2_23000_108200# a_21487_106400# 0 $ **FLOATING
C721 m2_22130_107890# a_21487_106400# 0 $ **FLOATING
C722 m2_21900_107920# a_21487_106400# 0 $ **FLOATING
C723 m2_21010_107610# a_21487_106400# 0 $ **FLOATING
C724 m2_20900_107620# a_21487_106400# 0 $ **FLOATING
C725 m2_20800_107640# a_21487_106400# 0 $ **FLOATING
C726 m2_20900_107720# a_21487_106400# 0 $ **FLOATING
C727 m2_20000_107330# a_21487_106400# 0 $ **FLOATING
C728 m2_20900_107820# a_21487_106400# 0 $ **FLOATING
C729 m2_20900_107920# a_21487_106400# 0 $ **FLOATING
C730 m2_22690_108310# a_21487_106400# 0 $ **FLOATING
C731 m2_22300_108340# a_21487_106400# 0 $ **FLOATING
C732 m2_21570_108030# a_21487_106400# 0 $ **FLOATING
C733 m2_21200_108060# a_21487_106400# 0 $ **FLOATING
C734 m2_20900_108020# a_21487_106400# 0 $ **FLOATING
C735 m2_22700_108760# a_21487_106400# 0 $ **FLOATING
C736 m2_22130_108450# a_21487_106400# 0 $ **FLOATING
C737 m2_21600_108480# a_21487_106400# 0 $ **FLOATING
C738 m2_21010_108170# a_21487_106400# 0 $ **FLOATING
C739 m2_20900_108120# a_21487_106400# 0 $ **FLOATING
C740 m2_20450_107750# a_21487_106400# 0 $ **FLOATING
C741 m2_20100_107780# a_21487_106400# 0 $ **FLOATING
C742 m2_20900_108220# a_21487_106400# 0 $ **FLOATING
C743 m2_20500_108200# a_21487_106400# 0 $ **FLOATING
C744 m2_20000_107890# a_21487_106400# 0 $ **FLOATING
C745 m2_20900_108320# a_21487_106400# 0 $ **FLOATING
C746 m2_20900_108420# a_21487_106400# 0 $ **FLOATING
C747 m2_20900_108520# a_21487_106400# 0 $ **FLOATING
C748 m2_22690_108870# a_21487_106400# 0 $ **FLOATING
C749 m2_22500_108900# a_21487_106400# 0 $ **FLOATING
C750 m2_21570_108590# a_21487_106400# 0 $ **FLOATING
C751 m2_21400_108620# a_21487_106400# 0 $ **FLOATING
C752 m2_20900_108620# a_21487_106400# 0 $ **FLOATING
C753 m2_20450_108310# a_21487_106400# 0 $ **FLOATING
C754 m2_20300_108340# a_21487_106400# 0 $ **FLOATING
C755 m2_22900_109320# a_21487_106400# 0 $ **FLOATING
C756 m2_22130_109010# a_21487_106400# 0 $ **FLOATING
C757 m2_21800_109040# a_21487_106400# 0 $ **FLOATING
C758 m2_21010_108730# a_21487_106400# 0 $ **FLOATING
C759 m2_20900_108720# a_21487_106400# 0 $ **FLOATING
C760 m2_20700_108760# a_21487_106400# 0 $ **FLOATING
C761 m2_20900_108820# a_21487_106400# 0 $ **FLOATING
C762 m2_20000_108450# a_21487_106400# 0 $ **FLOATING
C763 m2_20900_108920# a_21487_106400# 0 $ **FLOATING
C764 m2_20900_109020# a_21487_106400# 0 $ **FLOATING
C765 m2_22690_109430# a_21487_106400# 0 $ **FLOATING
C766 m2_22200_109460# a_21487_106400# 0 $ **FLOATING
C767 m2_21570_109150# a_21487_106400# 0 $ **FLOATING
C768 m2_20900_109120# a_21487_106400# 0 $ **FLOATING
C769 m2_21100_109180# a_21487_106400# 0 $ **FLOATING
C770 m2_20900_109220# a_21487_106400# 0 $ **FLOATING
C771 m2_20450_108870# a_21487_106400# 0 $ **FLOATING
C772 m2_20000_108900# a_21487_106400# 0 $ **FLOATING
C773 m2_22130_109570# a_21487_106400# 0 $ **FLOATING
C774 m2_22000_109600# a_21487_106400# 0 $ **FLOATING
C775 m2_21500_109600# a_21487_106400# 0 $ **FLOATING
C776 m2_21010_109290# a_21487_106400# 0 $ **FLOATING
C777 m2_20900_109320# a_21487_106400# 0 $ **FLOATING
C778 m2_20400_109320# a_21487_106400# 0 $ **FLOATING
C779 m2_20000_109010# a_21487_106400# 0 $ **FLOATING
C780 m2_20900_109420# a_21487_106400# 0 $ **FLOATING
C781 m2_20900_109520# a_21487_106400# 0 $ **FLOATING
C782 m2_20900_109620# a_21487_106400# 0 $ **FLOATING
C783 m2_20450_109430# a_21487_106400# 0 $ **FLOATING
C784 m2_20200_109460# a_21487_106400# 0 $ **FLOATING
C785 m2_20000_109570# a_21487_106400# 0 $ **FLOATING
C786 m1_67494_20000# a_21487_106400# 0 $ **FLOATING
C787 m1_67494_20094# a_21487_106400# 0 $ **FLOATING
C788 m1_67494_20250# a_21487_106400# 0 $ **FLOATING
C789 m1_67494_20406# a_21487_106400# 0 $ **FLOATING
C790 m1_67494_20562# a_21487_106400# 0 $ **FLOATING
C791 m1_67494_20718# a_21487_106400# 0 $ **FLOATING
C792 m1_67510_20890# a_21487_106400# 0 $ **FLOATING
C793 m1_67412_21080# a_21487_106400# 3.7989600000000005e-16
C794 m1_67350_20000# a_21487_106400# 3.5300800000000001e-16
C795 m1_67210_20000# a_21487_106400# 0 $ **FLOATING
C796 m1_67026_20000# a_21487_106400# 0 $ **FLOATING
C797 m1_67210_20050# a_21487_106400# 0 $ **FLOATING
C798 m1_67110_20070# a_21487_106400# 0 $ **FLOATING
C799 m1_66870_20030# a_21487_106400# 0 $ **FLOATING
C800 m1_66714_20014# a_21487_106400# 0 $ **FLOATING
C801 m1_66870_20186# a_21487_106400# 0 $ **FLOATING
C802 m1_66714_20170# a_21487_106400# 0 $ **FLOATING
C803 m1_66870_20342# a_21487_106400# 0 $ **FLOATING
C804 m1_66714_20326# a_21487_106400# 0 $ **FLOATING
C805 m1_66870_20498# a_21487_106400# 0 $ **FLOATING
C806 m1_66714_20482# a_21487_106400# 0 $ **FLOATING
C807 m1_66870_20654# a_21487_106400# 0 $ **FLOATING
C808 m1_66714_20638# a_21487_106400# 0 $ **FLOATING
C809 m1_66870_20810# a_21487_106400# 0 $ **FLOATING
C810 m1_66714_20794# a_21487_106400# 0 $ **FLOATING
C811 m1_66870_20966# a_21487_106400# 0 $ **FLOATING
C812 m1_66714_20950# a_21487_106400# 0 $ **FLOATING
C813 m1_66246_20000# a_21487_106400# 0 $ **FLOATING
C814 m1_66090_20000# a_21487_106400# 0 $ **FLOATING
C815 m1_65934_20000# a_21487_106400# 0 $ **FLOATING
C816 m1_65778_20000# a_21487_106400# 0 $ **FLOATING
C817 m1_65622_20000# a_21487_106400# 0 $ **FLOATING
C818 m1_65466_20000# a_21487_106400# 0 $ **FLOATING
C819 m1_66246_20122# a_21487_106400# 0 $ **FLOATING
C820 m1_66090_20106# a_21487_106400# 0 $ **FLOATING
C821 m1_65710_20150# a_21487_106400# 0 $ **FLOATING
C822 m1_65466_20042# a_21487_106400# 0 $ **FLOATING
C823 m1_66246_20278# a_21487_106400# 0 $ **FLOATING
C824 m1_66090_20262# a_21487_106400# 0 $ **FLOATING
C825 m1_65710_20250# a_21487_106400# 0 $ **FLOATING
C826 m1_65466_20198# a_21487_106400# 0 $ **FLOATING
C827 m1_65710_20350# a_21487_106400# 0 $ **FLOATING
C828 m1_66246_20434# a_21487_106400# 0 $ **FLOATING
C829 m1_66090_20418# a_21487_106400# 0 $ **FLOATING
C830 m1_65710_20450# a_21487_106400# 0 $ **FLOATING
C831 m1_65466_20354# a_21487_106400# 0 $ **FLOATING
C832 m1_66246_20590# a_21487_106400# 0 $ **FLOATING
C833 m1_66090_20574# a_21487_106400# 0 $ **FLOATING
C834 m1_66246_20746# a_21487_106400# 0 $ **FLOATING
C835 m1_66090_20730# a_21487_106400# 0 $ **FLOATING
C836 m1_66246_20902# a_21487_106400# 0 $ **FLOATING
C837 m1_66090_20886# a_21487_106400# 0 $ **FLOATING
C838 m1_65710_20550# a_21487_106400# 0 $ **FLOATING
C839 m1_65466_20510# a_21487_106400# 0 $ **FLOATING
C840 m1_65710_20650# a_21487_106400# 0 $ **FLOATING
C841 m1_65710_20750# a_21487_106400# 0 $ **FLOATING
C842 m1_65466_20666# a_21487_106400# 0 $ **FLOATING
C843 m1_65710_20850# a_21487_106400# 0 $ **FLOATING
C844 m1_65466_20822# a_21487_106400# 0 $ **FLOATING
C845 m1_65710_20950# a_21487_106400# 0 $ **FLOATING
C846 m1_66870_21122# a_21487_106400# 0 $ **FLOATING
C847 m1_66714_21106# a_21487_106400# 0 $ **FLOATING
C848 m1_66246_21058# a_21487_106400# 0 $ **FLOATING
C849 m1_66090_21042# a_21487_106400# 0 $ **FLOATING
C850 m1_65710_21050# a_21487_106400# 0 $ **FLOATING
C851 m1_65466_20978# a_21487_106400# 0 $ **FLOATING
C852 m1_66870_21278# a_21487_106400# 0 $ **FLOATING
C853 m1_66714_21262# a_21487_106400# 0 $ **FLOATING
C854 m1_66246_21214# a_21487_106400# 0 $ **FLOATING
C855 m1_66090_21198# a_21487_106400# 0 $ **FLOATING
C856 m1_65710_21150# a_21487_106400# 0 $ **FLOATING
C857 m1_65466_21134# a_21487_106400# 0 $ **FLOATING
C858 m1_65710_21250# a_21487_106400# 0 $ **FLOATING
C859 m1_66870_21434# a_21487_106400# 0 $ **FLOATING
C860 m1_66714_21418# a_21487_106400# 0 $ **FLOATING
C861 m1_66246_21370# a_21487_106400# 0 $ **FLOATING
C862 m1_66090_21354# a_21487_106400# 0 $ **FLOATING
C863 m1_65710_21350# a_21487_106400# 0 $ **FLOATING
C864 m1_65466_21290# a_21487_106400# 0 $ **FLOATING
C865 m1_66870_21590# a_21487_106400# 0 $ **FLOATING
C866 m1_66714_21574# a_21487_106400# 0 $ **FLOATING
C867 m1_66246_21526# a_21487_106400# 0 $ **FLOATING
C868 m1_66090_21510# a_21487_106400# 0 $ **FLOATING
C869 m1_65710_21450# a_21487_106400# 0 $ **FLOATING
C870 m1_65710_21550# a_21487_106400# 0 $ **FLOATING
C871 m1_65466_21446# a_21487_106400# 0 $ **FLOATING
C872 m1_66870_21746# a_21487_106400# 0 $ **FLOATING
C873 m1_66714_21730# a_21487_106400# 0 $ **FLOATING
C874 m1_66246_21682# a_21487_106400# 0 $ **FLOATING
C875 m1_66090_21666# a_21487_106400# 0 $ **FLOATING
C876 m1_65710_21650# a_21487_106400# 0 $ **FLOATING
C877 m1_65466_21602# a_21487_106400# 0 $ **FLOATING
C878 m1_65710_21750# a_21487_106400# 0 $ **FLOATING
C879 m1_66870_21902# a_21487_106400# 0 $ **FLOATING
C880 m1_66714_21886# a_21487_106400# 0 $ **FLOATING
C881 m1_66246_21838# a_21487_106400# 0 $ **FLOATING
C882 m1_66090_21822# a_21487_106400# 0 $ **FLOATING
C883 m1_65710_21850# a_21487_106400# 0 $ **FLOATING
C884 m1_65466_21758# a_21487_106400# 0 $ **FLOATING
C885 m1_66870_22058# a_21487_106400# 0 $ **FLOATING
C886 m1_66714_22042# a_21487_106400# 0 $ **FLOATING
C887 m1_66090_21978# a_21487_106400# 0 $ **FLOATING
C888 m1_65710_21950# a_21487_106400# 0 $ **FLOATING
C889 m1_65466_21914# a_21487_106400# 0 $ **FLOATING
C890 m1_66870_22214# a_21487_106400# 0 $ **FLOATING
C891 m1_66714_22198# a_21487_106400# 0 $ **FLOATING
C892 m1_66870_22370# a_21487_106400# 0 $ **FLOATING
C893 m1_66714_22354# a_21487_106400# 0 $ **FLOATING
C894 m1_66376_22136# a_21487_106400# 1.31212e-16
C895 m1_66090_22134# a_21487_106400# 0 $ **FLOATING
C896 m1_65710_22050# a_21487_106400# 0 $ **FLOATING
C897 m1_65710_22150# a_21487_106400# 0 $ **FLOATING
C898 m1_65466_22070# a_21487_106400# 0 $ **FLOATING
C899 m1_66090_22290# a_21487_106400# 0 $ **FLOATING
C900 m1_65710_22250# a_21487_106400# 0 $ **FLOATING
C901 m1_65466_22226# a_21487_106400# 0 $ **FLOATING
C902 m1_65710_22350# a_21487_106400# 0 $ **FLOATING
C903 m1_66090_22446# a_21487_106400# 0 $ **FLOATING
C904 m1_65710_22450# a_21487_106400# 0 $ **FLOATING
C905 m1_65466_22382# a_21487_106400# 0 $ **FLOATING
C906 m1_22722_106400# a_21487_106400# 0 $ **FLOATING
C907 m1_22722_106450# a_21487_106400# 0 $ **FLOATING
C908 m1_22254_106402# a_21487_106400# 0 $ **FLOATING
C909 m1_22110_106400# a_21487_106400# 0 $ **FLOATING
C910 m1_22110_106470# a_21487_106400# 0 $ **FLOATING
C911 m1_21810_106430# a_21487_106400# 0 $ **FLOATING
C912 m1_21630_106400# a_21487_106400# 0 $ **FLOATING
C913 m1_21162_106400# a_21487_106400# 0 $ **FLOATING
C914 m1_22722_106606# a_21487_106400# 0 $ **FLOATING
C915 m1_22254_106558# a_21487_106400# 0 $ **FLOATING
C916 m1_22110_106570# a_21487_106400# 0 $ **FLOATING
C917 m1_21810_106530# a_21487_106400# 0 $ **FLOATING
C918 m1_21630_106494# a_21487_106400# 0 $ **FLOATING
C919 m1_21162_106446# a_21487_106400# 0 $ **FLOATING
C920 m1_21006_106430# a_21487_106400# 0 $ **FLOATING
C921 m1_20850_106414# a_21487_106400# 0 $ **FLOATING
C922 m1_22722_106762# a_21487_106400# 0 $ **FLOATING
C923 m1_22254_106714# a_21487_106400# 0 $ **FLOATING
C924 m1_22110_106670# a_21487_106400# 0 $ **FLOATING
C925 m1_21810_106630# a_21487_106400# 0 $ **FLOATING
C926 m1_22110_106770# a_21487_106400# 0 $ **FLOATING
C927 m1_21810_106730# a_21487_106400# 0 $ **FLOATING
C928 m1_21630_106650# a_21487_106400# 0 $ **FLOATING
C929 m1_21162_106602# a_21487_106400# 0 $ **FLOATING
C930 m1_21006_106586# a_21487_106400# 0 $ **FLOATING
C931 m1_20850_106570# a_21487_106400# 0 $ **FLOATING
C932 m1_20580_106420# a_21487_106400# 0 $ **FLOATING
C933 m1_20340_106400# a_21487_106400# 0 $ **FLOATING
C934 m1_22722_106918# a_21487_106400# 0 $ **FLOATING
C935 m1_22254_106870# a_21487_106400# 0 $ **FLOATING
C936 m1_22110_106870# a_21487_106400# 0 $ **FLOATING
C937 m1_21810_106830# a_21487_106400# 0 $ **FLOATING
C938 m1_21630_106806# a_21487_106400# 0 $ **FLOATING
C939 m1_21162_106758# a_21487_106400# 0 $ **FLOATING
C940 m1_21006_106742# a_21487_106400# 0 $ **FLOATING
C941 m1_20850_106726# a_21487_106400# 0 $ **FLOATING
C942 m1_20580_106660# a_21487_106400# 0 $ **FLOATING
C943 m1_20340_106560# a_21487_106400# 0 $ **FLOATING
C944 m1_20000_106400# a_21487_106400# 0 $ **FLOATING
C945 m1_20210_106650# a_21487_106400# 0 $ **FLOATING
C946 m1_20110_106670# a_21487_106400# 0 $ **FLOATING
C947 m1_22722_107074# a_21487_106400# 0 $ **FLOATING
C948 m1_22254_107026# a_21487_106400# 0 $ **FLOATING
C949 m1_22110_106970# a_21487_106400# 0 $ **FLOATING
C950 m1_21810_106930# a_21487_106400# 0 $ **FLOATING
C951 m1_22110_107070# a_21487_106400# 0 $ **FLOATING
C952 m1_21810_107030# a_21487_106400# 0 $ **FLOATING
C953 m1_21630_106962# a_21487_106400# 0 $ **FLOATING
C954 m1_21162_106914# a_21487_106400# 0 $ **FLOATING
C955 m1_21006_106898# a_21487_106400# 0 $ **FLOATING
C956 m1_20850_106882# a_21487_106400# 0 $ **FLOATING
C957 m1_22722_107230# a_21487_106400# 0 $ **FLOATING
C958 m1_22254_107182# a_21487_106400# 0 $ **FLOATING
C959 m1_22110_107170# a_21487_106400# 0 $ **FLOATING
C960 m1_21810_107130# a_21487_106400# 0 $ **FLOATING
C961 m1_22110_107270# a_21487_106400# 0 $ **FLOATING
C962 m1_21810_107230# a_21487_106400# 0 $ **FLOATING
C963 m1_21630_107118# a_21487_106400# 0 $ **FLOATING
C964 m1_21162_107070# a_21487_106400# 0 $ **FLOATING
C965 m1_21006_107054# a_21487_106400# 0 $ **FLOATING
C966 m1_20850_107038# a_21487_106400# 0 $ **FLOATING
C967 m1_20580_106900# a_21487_106400# 0 $ **FLOATING
C968 m1_20340_106800# a_21487_106400# 0 $ **FLOATING
C969 m1_22722_107386# a_21487_106400# 0 $ **FLOATING
C970 m1_22254_107338# a_21487_106400# 0 $ **FLOATING
C971 m1_22110_107370# a_21487_106400# 0 $ **FLOATING
C972 m1_21810_107330# a_21487_106400# 0 $ **FLOATING
C973 m1_21630_107274# a_21487_106400# 0 $ **FLOATING
C974 m1_21162_107226# a_21487_106400# 0 $ **FLOATING
C975 m1_21006_107210# a_21487_106400# 0 $ **FLOATING
C976 m1_20850_107194# a_21487_106400# 0 $ **FLOATING
C977 m1_20580_107140# a_21487_106400# 0 $ **FLOATING
C978 m1_20340_107040# a_21487_106400# 0 $ **FLOATING
C979 m1_20000_106770# a_21487_106400# 0 $ **FLOATING
C980 m1_22722_107542# a_21487_106400# 0 $ **FLOATING
C981 m1_22254_107494# a_21487_106400# 0 $ **FLOATING
C982 m1_22110_107470# a_21487_106400# 0 $ **FLOATING
C983 m1_21810_107430# a_21487_106400# 0 $ **FLOATING
C984 m1_22110_107570# a_21487_106400# 0 $ **FLOATING
C985 m1_21810_107530# a_21487_106400# 0 $ **FLOATING
C986 m1_21630_107430# a_21487_106400# 0 $ **FLOATING
C987 m1_21162_107382# a_21487_106400# 0 $ **FLOATING
C988 m1_21006_107366# a_21487_106400# 0 $ **FLOATING
C989 m1_20850_107350# a_21487_106400# 0 $ **FLOATING
C990 m1_22722_107698# a_21487_106400# 0 $ **FLOATING
C991 m1_22254_107650# a_21487_106400# 0 $ **FLOATING
C992 m1_22110_107670# a_21487_106400# 0 $ **FLOATING
C993 m1_21810_107630# a_21487_106400# 0 $ **FLOATING
C994 m1_21630_107586# a_21487_106400# 0 $ **FLOATING
C995 m1_21162_107538# a_21487_106400# 0 $ **FLOATING
C996 m1_21006_107522# a_21487_106400# 0 $ **FLOATING
C997 m1_20850_107506# a_21487_106400# 0 $ **FLOATING
C998 m1_20580_107380# a_21487_106400# 0 $ **FLOATING
C999 m1_20340_107280# a_21487_106400# 0 $ **FLOATING
C1000 m1_22722_107854# a_21487_106400# 0 $ **FLOATING
C1001 m1_22254_107806# a_21487_106400# 0 $ **FLOATING
C1002 m1_22110_107770# a_21487_106400# 0 $ **FLOATING
C1003 m1_21810_107730# a_21487_106400# 0 $ **FLOATING
C1004 m1_22110_107870# a_21487_106400# 0 $ **FLOATING
C1005 m1_21810_107830# a_21487_106400# 0 $ **FLOATING
C1006 m1_21630_107742# a_21487_106400# 0 $ **FLOATING
C1007 m1_21162_107694# a_21487_106400# 0 $ **FLOATING
C1008 m1_21006_107678# a_21487_106400# 0 $ **FLOATING
C1009 m1_20850_107662# a_21487_106400# 0 $ **FLOATING
C1010 m1_22722_108010# a_21487_106400# 0 $ **FLOATING
C1011 m1_22254_107962# a_21487_106400# 0 $ **FLOATING
C1012 m1_22110_107970# a_21487_106400# 0 $ **FLOATING
C1013 m1_21810_107930# a_21487_106400# 0 $ **FLOATING
C1014 m1_21630_107898# a_21487_106400# 0 $ **FLOATING
C1015 m1_21162_107850# a_21487_106400# 0 $ **FLOATING
C1016 m1_21006_107834# a_21487_106400# 0 $ **FLOATING
C1017 m1_20850_107818# a_21487_106400# 0 $ **FLOATING
C1018 m1_20580_107620# a_21487_106400# 0 $ **FLOATING
C1019 m1_20340_107520# a_21487_106400# 0 $ **FLOATING
C1020 m1_20000_107330# a_21487_106400# 0 $ **FLOATING
C1021 m1_22722_108166# a_21487_106400# 0 $ **FLOATING
C1022 m1_22254_108118# a_21487_106400# 0 $ **FLOATING
C1023 m1_22110_108070# a_21487_106400# 0 $ **FLOATING
C1024 m1_21810_108030# a_21487_106400# 0 $ **FLOATING
C1025 m1_22110_108170# a_21487_106400# 0 $ **FLOATING
C1026 m1_21810_108130# a_21487_106400# 0 $ **FLOATING
C1027 m1_21630_108054# a_21487_106400# 0 $ **FLOATING
C1028 m1_21162_108006# a_21487_106400# 0 $ **FLOATING
C1029 m1_21006_107990# a_21487_106400# 0 $ **FLOATING
C1030 m1_20850_107974# a_21487_106400# 0 $ **FLOATING
C1031 m1_20580_107860# a_21487_106400# 0 $ **FLOATING
C1032 m1_20340_107760# a_21487_106400# 0 $ **FLOATING
C1033 m1_20110_107770# a_21487_106400# 0 $ **FLOATING
C1034 m1_20010_107790# a_21487_106400# 0 $ **FLOATING
C1035 m1_22722_108322# a_21487_106400# 0 $ **FLOATING
C1036 m1_22254_108274# a_21487_106400# 0 $ **FLOATING
C1037 m1_22110_108270# a_21487_106400# 0 $ **FLOATING
C1038 m1_21810_108230# a_21487_106400# 0 $ **FLOATING
C1039 m1_21630_108210# a_21487_106400# 0 $ **FLOATING
C1040 m1_21162_108162# a_21487_106400# 0 $ **FLOATING
C1041 m1_21006_108146# a_21487_106400# 0 $ **FLOATING
C1042 m1_20850_108130# a_21487_106400# 0 $ **FLOATING
C1043 m1_22110_108370# a_21487_106400# 0 $ **FLOATING
C1044 m1_21810_108330# a_21487_106400# 0 $ **FLOATING
C1045 m1_22722_108478# a_21487_106400# 0 $ **FLOATING
C1046 m1_22254_108430# a_21487_106400# 0 $ **FLOATING
C1047 m1_22110_108470# a_21487_106400# 0 $ **FLOATING
C1048 m1_21810_108430# a_21487_106400# 0 $ **FLOATING
C1049 m1_21630_108366# a_21487_106400# 0 $ **FLOATING
C1050 m1_21162_108318# a_21487_106400# 0 $ **FLOATING
C1051 m1_21006_108302# a_21487_106400# 0 $ **FLOATING
C1052 m1_20850_108286# a_21487_106400# 0 $ **FLOATING
C1053 m1_20580_108100# a_21487_106400# 0 $ **FLOATING
C1054 m1_20340_108000# a_21487_106400# 0 $ **FLOATING
C1055 m1_22722_108634# a_21487_106400# 0 $ **FLOATING
C1056 m1_22254_108586# a_21487_106400# 0 $ **FLOATING
C1057 m1_22110_108570# a_21487_106400# 0 $ **FLOATING
C1058 m1_21810_108530# a_21487_106400# 0 $ **FLOATING
C1059 m1_22110_108670# a_21487_106400# 0 $ **FLOATING
C1060 m1_21810_108630# a_21487_106400# 0 $ **FLOATING
C1061 m1_21630_108522# a_21487_106400# 0 $ **FLOATING
C1062 m1_21162_108474# a_21487_106400# 0 $ **FLOATING
C1063 m1_21006_108458# a_21487_106400# 0 $ **FLOATING
C1064 m1_20850_108442# a_21487_106400# 0 $ **FLOATING
C1065 m1_20580_108340# a_21487_106400# 0 $ **FLOATING
C1066 m1_20340_108240# a_21487_106400# 0 $ **FLOATING
C1067 m1_20000_107890# a_21487_106400# 0 $ **FLOATING
C1068 m1_20210_108350# a_21487_106400# 0 $ **FLOATING
C1069 m1_22722_108790# a_21487_106400# 0 $ **FLOATING
C1070 m1_22254_108742# a_21487_106400# 0 $ **FLOATING
C1071 m1_22110_108770# a_21487_106400# 0 $ **FLOATING
C1072 m1_21810_108730# a_21487_106400# 0 $ **FLOATING
C1073 m1_21630_108678# a_21487_106400# 0 $ **FLOATING
C1074 m1_21162_108630# a_21487_106400# 0 $ **FLOATING
C1075 m1_21006_108614# a_21487_106400# 0 $ **FLOATING
C1076 m1_20850_108598# a_21487_106400# 0 $ **FLOATING
C1077 m1_22722_108946# a_21487_106400# 0 $ **FLOATING
C1078 m1_22254_108898# a_21487_106400# 0 $ **FLOATING
C1079 m1_22110_108870# a_21487_106400# 0 $ **FLOATING
C1080 m1_21810_108830# a_21487_106400# 0 $ **FLOATING
C1081 m1_22110_108970# a_21487_106400# 0 $ **FLOATING
C1082 m1_21810_108930# a_21487_106400# 0 $ **FLOATING
C1083 m1_21630_108834# a_21487_106400# 0 $ **FLOATING
C1084 m1_21162_108786# a_21487_106400# 0 $ **FLOATING
C1085 m1_21006_108770# a_21487_106400# 0 $ **FLOATING
C1086 m1_20850_108754# a_21487_106400# 0 $ **FLOATING
C1087 m1_20580_108580# a_21487_106400# 0 $ **FLOATING
C1088 m1_20340_108480# a_21487_106400# 0 $ **FLOATING
C1089 m1_22722_109102# a_21487_106400# 0 $ **FLOATING
C1090 m1_22254_109054# a_21487_106400# 0 $ **FLOATING
C1091 m1_22110_109070# a_21487_106400# 0 $ **FLOATING
C1092 m1_21810_109030# a_21487_106400# 0 $ **FLOATING
C1093 m1_21630_108990# a_21487_106400# 0 $ **FLOATING
C1094 m1_21162_108942# a_21487_106400# 0 $ **FLOATING
C1095 m1_21006_108926# a_21487_106400# 0 $ **FLOATING
C1096 m1_20850_108910# a_21487_106400# 0 $ **FLOATING
C1097 m1_20580_108820# a_21487_106400# 0 $ **FLOATING
C1098 m1_20340_108720# a_21487_106400# 0 $ **FLOATING
C1099 m1_20000_108450# a_21487_106400# 0 $ **FLOATING
C1100 m1_20010_108890# a_21487_106400# 0 $ **FLOATING
C1101 m1_22722_109258# a_21487_106400# 0 $ **FLOATING
C1102 m1_22254_109210# a_21487_106400# 0 $ **FLOATING
C1103 m1_22110_109170# a_21487_106400# 0 $ **FLOATING
C1104 m1_21810_109130# a_21487_106400# 0 $ **FLOATING
C1105 m1_22110_109270# a_21487_106400# 0 $ **FLOATING
C1106 m1_21810_109230# a_21487_106400# 0 $ **FLOATING
C1107 m1_21630_109146# a_21487_106400# 0 $ **FLOATING
C1108 m1_21162_109098# a_21487_106400# 0 $ **FLOATING
C1109 m1_21006_109082# a_21487_106400# 0 $ **FLOATING
C1110 m1_20850_109066# a_21487_106400# 0 $ **FLOATING
C1111 m1_22722_109414# a_21487_106400# 0 $ **FLOATING
C1112 m1_22254_109366# a_21487_106400# 0 $ **FLOATING
C1113 m1_22110_109370# a_21487_106400# 0 $ **FLOATING
C1114 m1_21810_109330# a_21487_106400# 0 $ **FLOATING
C1115 m1_21630_109302# a_21487_106400# 0 $ **FLOATING
C1116 m1_21162_109254# a_21487_106400# 0 $ **FLOATING
C1117 m1_21006_109238# a_21487_106400# 0 $ **FLOATING
C1118 m1_20850_109222# a_21487_106400# 0 $ **FLOATING
C1119 m1_20580_109060# a_21487_106400# 0 $ **FLOATING
C1120 m1_20340_108960# a_21487_106400# 0 $ **FLOATING
C1121 m1_22722_109570# a_21487_106400# 0 $ **FLOATING
C1122 m1_22254_109522# a_21487_106400# 0 $ **FLOATING
C1123 m1_22110_109470# a_21487_106400# 0 $ **FLOATING
C1124 m1_21810_109430# a_21487_106400# 0 $ **FLOATING
C1125 m1_22110_109570# a_21487_106400# 0 $ **FLOATING
C1126 m1_21810_109530# a_21487_106400# 0 $ **FLOATING
C1127 m1_21630_109458# a_21487_106400# 0 $ **FLOATING
C1128 m1_21162_109410# a_21487_106400# 0 $ **FLOATING
C1129 m1_21006_109394# a_21487_106400# 0 $ **FLOATING
C1130 m1_20850_109378# a_21487_106400# 0 $ **FLOATING
C1131 m1_20580_109300# a_21487_106400# 0 $ **FLOATING
C1132 m1_20340_109200# a_21487_106400# 0 $ **FLOATING
C1133 m1_20000_109010# a_21487_106400# 0 $ **FLOATING
C1134 m1_22254_109678# a_21487_106400# 0 $ **FLOATING
C1135 m1_22110_109670# a_21487_106400# 0 $ **FLOATING
C1136 m1_21810_109630# a_21487_106400# 0 $ **FLOATING
C1137 m1_21630_109614# a_21487_106400# 0 $ **FLOATING
C1138 m1_21162_109566# a_21487_106400# 0 $ **FLOATING
C1139 m1_21006_109550# a_21487_106400# 0 $ **FLOATING
C1140 m1_20850_109534# a_21487_106400# 0 $ **FLOATING
C1141 m1_20850_109690# a_21487_106400# 0 $ **FLOATING
C1142 m1_20580_109540# a_21487_106400# 0 $ **FLOATING
C1143 m1_20340_109440# a_21487_106400# 0 $ **FLOATING
C1144 m1_20210_109450# a_21487_106400# 0 $ **FLOATING
C1145 m1_20110_109470# a_21487_106400# 0 $ **FLOATING
C1146 m1_20340_109680# a_21487_106400# 0 $ **FLOATING
C1147 m1_20000_109570# a_21487_106400# 0 $ **FLOATING
C1148 li_66940_20000# a_21487_106400# 0 $ **FLOATING
C1149 li_66160_20000# a_21487_106400# 0 $ **FLOATING
C1150 li_65650_20000# a_21487_106400# 0 $ **FLOATING
C1151 li_67506_20298# a_21487_106400# 0 $ **FLOATING
C1152 li_67506_20514# a_21487_106400# 0 $ **FLOATING
C1153 li_67290_20438# a_21487_106400# 0 $ **FLOATING
C1154 li_67074_20362# a_21487_106400# 0 $ **FLOATING
C1155 li_67506_20730# a_21487_106400# 0 $ **FLOATING
C1156 li_67290_20654# a_21487_106400# 0 $ **FLOATING
C1157 li_67074_20578# a_21487_106400# 0 $ **FLOATING
C1158 li_66858_20502# a_21487_106400# 0 $ **FLOATING
C1159 li_66642_20426# a_21487_106400# 0 $ **FLOATING
C1160 li_67074_20794# a_21487_106400# 0 $ **FLOATING
C1161 li_66858_20718# a_21487_106400# 0 $ **FLOATING
C1162 li_66642_20642# a_21487_106400# 0 $ **FLOATING
C1163 li_66426_20566# a_21487_106400# 0 $ **FLOATING
C1164 li_66210_20490# a_21487_106400# 0 $ **FLOATING
C1165 li_65994_20414# a_21487_106400# 0 $ **FLOATING
C1166 li_65778_20338# a_21487_106400# 0 $ **FLOATING
C1167 li_65250_20070# a_21487_106400# 0 $ **FLOATING
C1168 li_66426_20782# a_21487_106400# 0 $ **FLOATING
C1169 li_66210_20706# a_21487_106400# 0 $ **FLOATING
C1170 li_65994_20630# a_21487_106400# 0 $ **FLOATING
C1171 li_65778_20554# a_21487_106400# 0 $ **FLOATING
C1172 li_65562_20478# a_21487_106400# 0 $ **FLOATING
C1173 li_65778_20770# a_21487_106400# 0 $ **FLOATING
C1174 li_65562_20694# a_21487_106400# 0 $ **FLOATING
C1175 li_65346_20618# a_21487_106400# 0 $ **FLOATING
C1176 li_65130_20542# a_21487_106400# 0 $ **FLOATING
C1177 li_65130_20758# a_21487_106400# 0 $ **FLOATING
C1178 li_67506_21594# a_21487_106400# 0 $ **FLOATING
C1179 li_66858_21582# a_21487_106400# 0 $ **FLOATING
C1180 li_67506_21810# a_21487_106400# 0 $ **FLOATING
C1181 li_66210_21570# a_21487_106400# 0 $ **FLOATING
C1182 li_66858_21798# a_21487_106400# 0 $ **FLOATING
C1183 li_65562_21558# a_21487_106400# 0 $ **FLOATING
C1184 li_65346_21482# a_21487_106400# 0 $ **FLOATING
C1185 li_66210_21786# a_21487_106400# 0 $ **FLOATING
C1186 li_67506_22026# a_21487_106400# 0 $ **FLOATING
C1187 li_65562_21774# a_21487_106400# 0 $ **FLOATING
C1188 li_65346_21698# a_21487_106400# 0 $ **FLOATING
C1189 li_66858_22014# a_21487_106400# 0 $ **FLOATING
C1190 li_66210_22002# a_21487_106400# 0 $ **FLOATING
C1191 li_67506_22242# a_21487_106400# 0 $ **FLOATING
C1192 li_66858_22230# a_21487_106400# 0 $ **FLOATING
C1193 li_65562_21990# a_21487_106400# 0 $ **FLOATING
C1194 li_65346_21914# a_21487_106400# 0 $ **FLOATING
C1195 li_67506_22458# a_21487_106400# 0 $ **FLOATING
C1196 li_66210_22218# a_21487_106400# 0 $ **FLOATING
C1197 li_65562_22206# a_21487_106400# 0 $ **FLOATING
C1198 li_65346_22130# a_21487_106400# 0 $ **FLOATING
C1199 li_66858_22446# a_21487_106400# 0 $ **FLOATING
C1200 li_66210_22434# a_21487_106400# 0 $ **FLOATING
C1201 li_65562_22422# a_21487_106400# 0 $ **FLOATING
C1202 li_65346_22346# a_21487_106400# 0 $ **FLOATING
C1203 li_21066_106400# a_21487_106400# 0 $ **FLOATING
C1204 li_21066_106558# a_21487_106400# 0 $ **FLOATING
C1205 li_20850_106482# a_21487_106400# 0 $ **FLOATING
C1206 li_20140_106400# a_21487_106400# 0 $ **FLOATING
C1207 li_21066_106774# a_21487_106400# 0 $ **FLOATING
C1208 li_20850_106698# a_21487_106400# 0 $ **FLOATING
C1209 li_21066_106990# a_21487_106400# 0 $ **FLOATING
C1210 li_20850_106914# a_21487_106400# 0 $ **FLOATING
C1211 li_21066_107206# a_21487_106400# 0 $ **FLOATING
C1212 li_20850_107130# a_21487_106400# 0 $ **FLOATING
C1213 li_20140_106730# a_21487_106400# 0 $ **FLOATING
C1214 li_21066_107422# a_21487_106400# 0 $ **FLOATING
C1215 li_20850_107346# a_21487_106400# 0 $ **FLOATING
C1216 li_21066_107638# a_21487_106400# 0 $ **FLOATING
C1217 li_20850_107562# a_21487_106400# 0 $ **FLOATING
C1218 li_21066_107854# a_21487_106400# 0 $ **FLOATING
C1219 li_20850_107778# a_21487_106400# 0 $ **FLOATING
C1220 li_21066_108070# a_21487_106400# 0 $ **FLOATING
C1221 li_20850_107994# a_21487_106400# 0 $ **FLOATING
C1222 li_20140_107510# a_21487_106400# 0 $ **FLOATING
C1223 li_21066_108286# a_21487_106400# 0 $ **FLOATING
C1224 li_20850_108210# a_21487_106400# 0 $ **FLOATING
C1225 li_21066_108502# a_21487_106400# 0 $ **FLOATING
C1226 li_20850_108426# a_21487_106400# 0 $ **FLOATING
C1227 li_21066_108718# a_21487_106400# 0 $ **FLOATING
C1228 li_20850_108642# a_21487_106400# 0 $ **FLOATING
C1229 li_21066_108934# a_21487_106400# 0 $ **FLOATING
C1230 li_20850_108858# a_21487_106400# 0 $ **FLOATING
C1231 li_20140_108290# a_21487_106400# 0 $ **FLOATING
C1232 li_21066_109150# a_21487_106400# 0 $ **FLOATING
C1233 li_20850_109074# a_21487_106400# 0 $ **FLOATING
C1234 li_21066_109366# a_21487_106400# 0 $ **FLOATING
C1235 li_20850_109290# a_21487_106400# 0 $ **FLOATING
C1236 li_21066_109582# a_21487_106400# 0 $ **FLOATING
C1237 li_20850_109506# a_21487_106400# 0 $ **FLOATING
C1238 li_20140_109070# a_21487_106400# 0 $ **FLOATING
C1239 a_67560_20000# a_21487_106400# 0 $ **FLOATING
C1240 a_67276_20024# a_21487_106400# 0 $ **FLOATING
C1241 a_66844_20000# a_21487_106400# 0 $ **FLOATING
C1242 a_67060_20072# a_21487_106400# 0 $ **FLOATING
C1243 a_66628_20000# a_21487_106400# 0 $ **FLOATING
C1244 a_67276_20240# a_21487_106400# 0 $ **FLOATING
C1245 a_66844_20120# a_21487_106400# 0 $ **FLOATING
C1246 a_66412_20000# a_21487_106400# 0 $ **FLOATING
C1247 a_67060_20288# a_21487_106400# 0 $ **FLOATING
C1248 a_66628_20168# a_21487_106400# 0 $ **FLOATING
C1249 a_66196_20048# a_21487_106400# 0 $ **FLOATING
C1250 a_65288_20000# a_21487_106400# 0 $ **FLOATING
C1251 a_65100_20000# a_21487_106400# 0 $ **FLOATING
C1252 a_67276_20456# a_21487_106400# 0 $ **FLOATING
C1253 a_66844_20336# a_21487_106400# 0 $ **FLOATING
C1254 a_66412_20216# a_21487_106400# 0 $ **FLOATING
C1255 a_67060_20504# a_21487_106400# 0 $ **FLOATING
C1256 a_66628_20384# a_21487_106400# 0 $ **FLOATING
C1257 a_66196_20264# a_21487_106400# 0 $ **FLOATING
C1258 a_65764_20144# a_21487_106400# 0 $ **FLOATING
C1259 a_67276_20672# a_21487_106400# 0 $ **FLOATING
C1260 a_66844_20552# a_21487_106400# 0 $ **FLOATING
C1261 a_66412_20432# a_21487_106400# 0 $ **FLOATING
C1262 a_65980_20312# a_21487_106400# 0 $ **FLOATING
C1263 a_65548_20192# a_21487_106400# 0 $ **FLOATING
C1264 a_65100_20098# a_21487_106400# 0 $ **FLOATING
C1265 a_66628_20600# a_21487_106400# 0 $ **FLOATING
C1266 a_66196_20480# a_21487_106400# 0 $ **FLOATING
C1267 a_65764_20360# a_21487_106400# 0 $ **FLOATING
C1268 a_65332_20240# a_21487_106400# 0 $ **FLOATING
C1269 a_66412_20648# a_21487_106400# 0 $ **FLOATING
C1270 a_65980_20528# a_21487_106400# 0 $ **FLOATING
C1271 a_65548_20408# a_21487_106400# 0 $ **FLOATING
C1272 a_65116_20288# a_21487_106400# 0 $ **FLOATING
C1273 a_66196_20696# a_21487_106400# 0 $ **FLOATING
C1274 a_65764_20576# a_21487_106400# 0 $ **FLOATING
C1275 a_65332_20456# a_21487_106400# 0 $ **FLOATING
C1276 a_65548_20624# a_21487_106400# 0 $ **FLOATING
C1277 a_65116_20504# a_21487_106400# 0 $ **FLOATING
C1278 a_65332_20672# a_21487_106400# 0 $ **FLOATING
C1279 a_67263_21111# a_21487_106400# 2.6014299999999998e-16 $ **FLOATING
C1280 a_65100_21098# a_21487_106400# 3.4029800000000001e-18 $ **FLOATING
C1281 a_65931_21111# a_21487_106400# 3.7713618369964346e-18 $ **FLOATING
C1282 a_65100_21043# a_21487_106400# 1.6619739111297192e-18 $ **FLOATING
C1283 a_65266_21098# a_21487_106400# 5.1519792525559853e-18 $ **FLOATING
C1284 a_23093_106400# a_21487_106400# 2.3011199999999999e-16 $ **FLOATING
C1285 a_23093_107267# a_21487_106400# 9.5162400000000014e-17 $ **FLOATING
C1286 a_21052_106400# a_21487_106400# 0 $ **FLOATING
C1287 a_20836_106400# a_21487_106400# 0 $ **FLOATING
C1288 a_23093_108003# a_21487_106400# 3.0544800000000003e-16 $ **FLOATING
C1289 a_21052_106544# a_21487_106400# 0 $ **FLOATING
C1290 a_20836_106592# a_21487_106400# 0 $ **FLOATING
C1291 a_21052_106760# a_21487_106400# 0 $ **FLOATING
C1292 a_20836_106808# a_21487_106400# 0 $ **FLOATING
C1293 a_21052_106976# a_21487_106400# 0 $ **FLOATING
C1294 a_20836_107024# a_21487_106400# 0 $ **FLOATING
C1295 a_20000_106400# a_21487_106400# 0 $ **FLOATING
C1296 a_21052_107192# a_21487_106400# 0 $ **FLOATING
C1297 a_20836_107240# a_21487_106400# 0 $ **FLOATING
C1298 a_20636_107194# a_21487_106400# 0 $ **FLOATING
C1299 a_20404_107120# a_21487_106400# 0 $ **FLOATING
C1300 a_20188_107168# a_21487_106400# 0 $ **FLOATING
C1301 a_20000_107206# a_21487_106400# 0 $ **FLOATING
C1302 a_21052_107408# a_21487_106400# 0 $ **FLOATING
C1303 a_20836_107456# a_21487_106400# 0 $ **FLOATING
C1304 a_21052_107624# a_21487_106400# 0 $ **FLOATING
C1305 a_20836_107672# a_21487_106400# 0 $ **FLOATING
C1306 a_21052_107840# a_21487_106400# 0 $ **FLOATING
C1307 a_23093_109107# a_21487_106400# 2.2618000000000006e-16 $ **FLOATING
C1308 a_20836_107888# a_21487_106400# 0 $ **FLOATING
C1309 a_21052_108056# a_21487_106400# 0 $ **FLOATING
C1310 a_20836_108104# a_21487_106400# 0 $ **FLOATING
C1311 a_20000_107376# a_21487_106400# 0 $ **FLOATING
C1312 a_21052_108272# a_21487_106400# 0 $ **FLOATING
C1313 a_20836_108320# a_21487_106400# 0 $ **FLOATING
C1314 a_20636_108274# a_21487_106400# 0 $ **FLOATING
C1315 a_20456_108322# a_21487_106400# 0 $ **FLOATING
C1316 a_20000_108296# a_21487_106400# 0 $ **FLOATING
C1317 a_21052_108488# a_21487_106400# 0 $ **FLOATING
C1318 a_20836_108536# a_21487_106400# 0 $ **FLOATING
C1319 a_21052_108704# a_21487_106400# 0 $ **FLOATING
C1320 a_20836_108752# a_21487_106400# 0 $ **FLOATING
C1321 a_21052_108920# a_21487_106400# 0 $ **FLOATING
C1322 a_20836_108968# a_21487_106400# 0 $ **FLOATING
C1323 a_21052_109136# a_21487_106400# 0 $ **FLOATING
C1324 a_20836_109184# a_21487_106400# 0 $ **FLOATING
C1325 a_20000_108512# a_21487_106400# 0 $ **FLOATING
C1326 a_21052_109352# a_21487_106400# 0 $ **FLOATING
C1327 a_20836_109400# a_21487_106400# 0 $ **FLOATING
C1328 a_20456_109402# a_21487_106400# 0 $ **FLOATING
C1329 a_20276_109450# a_21487_106400# 0 $ **FLOATING
C1330 a_20100_109452# a_21487_106400# 0 $ **FLOATING
C1331 a_21052_109568# a_21487_106400# 0 $ **FLOATING
C1332 a_20836_109616# a_21487_106400# 0 $ **FLOATING
C1333 a_20000_109648# a_21487_106400# 0 $ **FLOATING
C1334 w_67548_20978# a_21487_106400# 2.3743199999999998e-16
C1335 w_66216_20978# a_21487_106400# 3.6528026291167593e-16 $ **FLOATING
C1336 w_65064_21062# a_21487_106400# 7.619429092248933e-18 $ **FLOATING
C1337 w_22789_106400# a_21487_106400# 3.133404723722242e-16 $ **FLOATING
C1338 w_21701_106400# a_21487_106400# 4.6630617558566274e-16 $ **FLOATING
C1339 a_21487_106400# a_21487_106400# 0 $ **FLOATING
C1340 a_21487_106400.t30 a_21487_106400# 0 $ **FLOATING
C1341 a_21487_106400.n0 a_21487_106400# 0 $ **FLOATING
C1342 a_21487_106400.n1 a_21487_106400# 0 $ **FLOATING
C1343 a_21487_106400.n2 a_21487_106400# 0 $ **FLOATING
C1344 a_21487_106400.n3 a_21487_106400# 0 $ **FLOATING
C1345 a_21487_106400.n4 a_21487_106400# 0 $ **FLOATING
C1346 a_21487_106400.n5 a_21487_106400# 0 $ **FLOATING
C1347 a_21487_106400.t34 a_21487_106400# 0 $ **FLOATING
C1348 a_21487_106400.n6 a_21487_106400# 0 $ **FLOATING
C1349 a_21487_106400.n7 a_21487_106400# 0 $ **FLOATING
C1350 a_21487_106400.n8 a_21487_106400# 0 $ **FLOATING
C1351 a_21487_106400.n9 a_21487_106400# 0 $ **FLOATING
C1352 a_21487_106400.n10 a_21487_106400# 0 $ **FLOATING
C1353 a_21487_106400.n11 a_21487_106400# 0 $ **FLOATING
C1354 a_21487_106400.n12 a_21487_106400# 0 $ **FLOATING
C1355 a_21487_106400.n13 a_21487_106400# 0 $ **FLOATING
C1356 a_21487_106400.n14 a_21487_106400# 0 $ **FLOATING
C1357 a_21487_106400.n15 a_21487_106400# 0 $ **FLOATING
C1358 a_21487_106400.t25 a_21487_106400# 0 $ **FLOATING
C1359 a_21487_106400.n16 a_21487_106400# 0 $ **FLOATING
C1360 a_21487_106400.n17 a_21487_106400# 0 $ **FLOATING
C1361 a_21487_106400.n18 a_21487_106400# 0 $ **FLOATING
C1362 a_21487_106400.n19 a_21487_106400# 0 $ **FLOATING
C1363 a_21487_106400.n20 a_21487_106400# 0 $ **FLOATING
C1364 a_21487_106400.n21 a_21487_106400# 0 $ **FLOATING
C1365 a_21487_106400.n22 a_21487_106400# 0 $ **FLOATING
C1366 a_21487_106400.n23 a_21487_106400# 0 $ **FLOATING
C1367 a_21487_106400.n24 a_21487_106400# 0 $ **FLOATING
C1368 a_21487_106400.n25 a_21487_106400# 0 $ **FLOATING
C1369 a_21487_106400.n26 a_21487_106400# 0 $ **FLOATING
C1370 a_21487_106400.n27 a_21487_106400# 0 $ **FLOATING
C1371 a_21487_106400.n28 a_21487_106400# 0 $ **FLOATING
C1372 a_21487_106400.n29 a_21487_106400# 0 $ **FLOATING
C1373 a_21487_106400.n30 a_21487_106400# 0 $ **FLOATING
C1374 a_21487_106400.n31 a_21487_106400# 0 $ **FLOATING
C1375 a_21487_106400.n32 a_21487_106400# 0 $ **FLOATING
C1376 a_21487_106400.n33 a_21487_106400# 0 $ **FLOATING
C1377 a_21487_106400.n34 a_21487_106400# 0 $ **FLOATING
C1378 a_21487_106400.n35 a_21487_106400# 0 $ **FLOATING
C1379 a_21487_106400.t36 a_21487_106400# 0 $ **FLOATING
C1380 a_21487_106400.n36 a_21487_106400# 0 $ **FLOATING
C1381 a_21487_106400.t26 a_21487_106400# 0 $ **FLOATING
C1382 a_21487_106400.n37 a_21487_106400# 0 $ **FLOATING
C1383 a_21487_106400.n38 a_21487_106400# 0 $ **FLOATING
C1384 a_21487_106400.n39 a_21487_106400# 0 $ **FLOATING
C1385 a_21487_106400.n40 a_21487_106400# 0 $ **FLOATING
C1386 a_21487_106400.n41 a_21487_106400# 0 $ **FLOATING
C1387 a_21487_106400.n42 a_21487_106400# 0 $ **FLOATING
C1388 a_21487_106400.n43 a_21487_106400# 0 $ **FLOATING
C1389 a_21487_106400.n44 a_21487_106400# 0 $ **FLOATING
C1390 a_21487_106400.n45 a_21487_106400# 0 $ **FLOATING
C1391 a_21487_106400.n46 a_21487_106400# 0 $ **FLOATING
C1392 a_21487_106400.n47 a_21487_106400# 0 $ **FLOATING
C1393 a_21487_106400.n48 a_21487_106400# 0 $ **FLOATING
C1394 a_21487_106400.n49 a_21487_106400# 0 $ **FLOATING
C1395 a_21487_106400.n50 a_21487_106400# 0 $ **FLOATING
C1396 a_21487_106400.n51 a_21487_106400# 0 $ **FLOATING
C1397 a_21487_106400.n52 a_21487_106400# 0 $ **FLOATING
C1398 a_21487_106400.n53 a_21487_106400# 0 $ **FLOATING
C1399 a_21487_106400.t13 a_21487_106400# 0 $ **FLOATING
C1400 a_21487_106400.t6 a_21487_106400# 0 $ **FLOATING
C1401 a_21487_106400.n54 a_21487_106400# 0 $ **FLOATING
C1402 a_21487_106400.n55 a_21487_106400# 0 $ **FLOATING
C1403 a_21487_106400.n56 a_21487_106400# 0 $ **FLOATING
C1404 a_21487_106400.n57 a_21487_106400# 0 $ **FLOATING
C1405 a_21487_106400.t23 a_21487_106400# 0 $ **FLOATING
C1406 a_21487_106400.n58 a_21487_106400# 0 $ **FLOATING
C1407 a_21487_106400.t42 a_21487_106400# 0 $ **FLOATING
C1408 a_21487_106400.n59 a_21487_106400# 0 $ **FLOATING
C1409 a_21487_106400.n60 a_21487_106400# 0 $ **FLOATING
C1410 a_21487_106400.n61 a_21487_106400# 0 $ **FLOATING
C1411 a_21487_106400.n62 a_21487_106400# 0 $ **FLOATING
C1412 a_21487_106400.n63 a_21487_106400# 0 $ **FLOATING
C1413 a_21487_106400.n64 a_21487_106400# 0 $ **FLOATING
C1414 a_21487_106400.n65 a_21487_106400# 0 $ **FLOATING
C1415 a_21487_106400.t37 a_21487_106400# 0 $ **FLOATING
C1416 a_21487_106400.n66 a_21487_106400# 0 $ **FLOATING
C1417 a_21487_106400.n67 a_21487_106400# 0 $ **FLOATING
C1418 a_21487_106400.n68 a_21487_106400# 0 $ **FLOATING
C1419 a_21487_106400.n69 a_21487_106400# 0 $ **FLOATING
C1420 a_21487_106400.n70 a_21487_106400# 0 $ **FLOATING
C1421 a_21487_106400.n71 a_21487_106400# 0 $ **FLOATING
C1422 a_21487_106400.n72 a_21487_106400# 0 $ **FLOATING
C1423 a_21487_106400.n73 a_21487_106400# 0 $ **FLOATING
C1424 a_21487_106400.n74 a_21487_106400# 0 $ **FLOATING
C1425 a_21487_106400.n75 a_21487_106400# 0 $ **FLOATING
C1426 a_21487_106400.t5 a_21487_106400# 0 $ **FLOATING
C1427 a_21487_106400.n76 a_21487_106400# 0 $ **FLOATING
C1428 a_21487_106400.n77 a_21487_106400# 0 $ **FLOATING
C1429 a_21487_106400.n78 a_21487_106400# 0 $ **FLOATING
C1430 a_21487_106400.n79 a_21487_106400# 0 $ **FLOATING
C1431 a_21487_106400.n80 a_21487_106400# 0 $ **FLOATING
C1432 a_21487_106400.t22 a_21487_106400# 0 $ **FLOATING
C1433 a_21487_106400.t9 a_21487_106400# 0 $ **FLOATING
C1434 a_21487_106400.n81 a_21487_106400# 0 $ **FLOATING
C1435 a_21487_106400.n82 a_21487_106400# 0 $ **FLOATING
C1436 a_21487_106400.n83 a_21487_106400# 0 $ **FLOATING
C1437 a_21487_106400.n84 a_21487_106400# 0 $ **FLOATING
C1438 a_21487_106400.t28 a_21487_106400# 0 $ **FLOATING
C1439 a_21487_106400.n85 a_21487_106400# 0 $ **FLOATING
C1440 a_21487_106400.n86 a_21487_106400# 0 $ **FLOATING
C1441 a_21487_106400.n87 a_21487_106400# 0 $ **FLOATING
C1442 a_21487_106400.n88 a_21487_106400# 0 $ **FLOATING
C1443 a_21487_106400.n89 a_21487_106400# 0 $ **FLOATING
C1444 a_21487_106400.n90 a_21487_106400# 0 $ **FLOATING
C1445 a_21487_106400.n91 a_21487_106400# 0 $ **FLOATING
C1446 a_21487_106400.n92 a_21487_106400# 0 $ **FLOATING
C1447 a_21487_106400.t35 a_21487_106400# 0 $ **FLOATING
C1448 a_21487_106400.n93 a_21487_106400# 0 $ **FLOATING
C1449 a_21487_106400.n94 a_21487_106400# 0 $ **FLOATING
C1450 a_21487_106400.n95 a_21487_106400# 0 $ **FLOATING
C1451 a_21487_106400.n96 a_21487_106400# 0 $ **FLOATING
C1452 a_21487_106400.n97 a_21487_106400# 0 $ **FLOATING
C1453 a_21487_106400.n98 a_21487_106400# 0 $ **FLOATING
C1454 a_21487_106400.n99 a_21487_106400# 0 $ **FLOATING
C1455 a_21487_106400.n100 a_21487_106400# 0 $ **FLOATING
C1456 a_21487_106400.t8 a_21487_106400# 0 $ **FLOATING
C1457 a_21487_106400.n101 a_21487_106400# 0 $ **FLOATING
C1458 a_21487_106400.n102 a_21487_106400# 0 $ **FLOATING
C1459 a_21487_106400.n103 a_21487_106400# 0 $ **FLOATING
C1460 a_21487_106400.n104 a_21487_106400# 0 $ **FLOATING
C1461 a_21487_106400.n105 a_21487_106400# 0 $ **FLOATING
C1462 a_21487_106400.n106 a_21487_106400# 0 $ **FLOATING
C1463 a_21487_106400.n107 a_21487_106400# 0 $ **FLOATING
C1464 a_21487_106400.n108 a_21487_106400# 0 $ **FLOATING
C1465 a_21487_106400.n109 a_21487_106400# 0 $ **FLOATING
C1466 a_21487_106400.n110 a_21487_106400# 0 $ **FLOATING
C1467 a_21487_106400.n111 a_21487_106400# 0 $ **FLOATING
C1468 a_21487_106400.n112 a_21487_106400# 0 $ **FLOATING
C1469 a_21487_106400.n113 a_21487_106400# 0 $ **FLOATING
C1470 a_21487_106400.n114 a_21487_106400# 0 $ **FLOATING
C1471 a_21487_106400.n115 a_21487_106400# 0 $ **FLOATING
C1472 a_21487_106400.n116 a_21487_106400# 0 $ **FLOATING
C1473 a_21487_106400.n117 a_21487_106400# 0 $ **FLOATING
C1474 a_21487_106400.n118 a_21487_106400# 0 $ **FLOATING
C1475 a_21487_106400.t41 a_21487_106400# 0 $ **FLOATING
C1476 a_21487_106400.n119 a_21487_106400# 0 $ **FLOATING
C1477 a_21487_106400.n120 a_21487_106400# 0 $ **FLOATING
C1478 a_21487_106400.n121 a_21487_106400# 0 $ **FLOATING
C1479 a_21487_106400.n122 a_21487_106400# 0 $ **FLOATING
C1480 a_21487_106400.t14 a_21487_106400# 0 $ **FLOATING
C1481 a_21487_106400.n123 a_21487_106400# 0 $ **FLOATING
C1482 a_21487_106400.t2 a_21487_106400# 0 $ **FLOATING
C1483 a_21487_106400.n124 a_21487_106400# 0 $ **FLOATING
C1484 a_21487_106400.t11 a_21487_106400# 0 $ **FLOATING
C1485 a_21487_106400.n125 a_21487_106400# 0 $ **FLOATING
C1486 a_21487_106400.n126 a_21487_106400# 0 $ **FLOATING
C1487 a_21487_106400.n127 a_21487_106400# 0 $ **FLOATING
C1488 a_21487_106400.n128 a_21487_106400# 0 $ **FLOATING
C1489 a_21487_106400.n129 a_21487_106400# 0 $ **FLOATING
C1490 a_21487_106400.n130 a_21487_106400# 0 $ **FLOATING
C1491 a_21487_106400.n131 a_21487_106400# 0 $ **FLOATING
C1492 a_21487_106400.n132 a_21487_106400# 0 $ **FLOATING
C1493 a_21487_106400.t44 a_21487_106400# 0 $ **FLOATING
C1494 a_21487_106400.n133 a_21487_106400# 0 $ **FLOATING
C1495 a_21487_106400.t3 a_21487_106400# 0 $ **FLOATING
C1496 a_21487_106400.n134 a_21487_106400# 0 $ **FLOATING
C1497 a_21487_106400.n135 a_21487_106400# 0 $ **FLOATING
C1498 a_21487_106400.n136 a_21487_106400# 0 $ **FLOATING
C1499 a_21487_106400.t43 a_21487_106400# 0 $ **FLOATING
C1500 a_21487_106400.n137 a_21487_106400# 0 $ **FLOATING
C1501 a_21487_106400.n138 a_21487_106400# 0 $ **FLOATING
C1502 a_21487_106400.n139 a_21487_106400# 0 $ **FLOATING
C1503 a_21487_106400.t38 a_21487_106400# 0 $ **FLOATING
C1504 a_21487_106400.n140 a_21487_106400# 0 $ **FLOATING
C1505 a_21487_106400.n141 a_21487_106400# 0 $ **FLOATING
C1506 a_21487_106400.n142 a_21487_106400# 0 $ **FLOATING
C1507 a_21487_106400.t27 a_21487_106400# 0 $ **FLOATING
C1508 a_21487_106400.t21 a_21487_106400# 0 $ **FLOATING
C1509 a_21487_106400.t7 a_21487_106400# 0 $ **FLOATING
C1510 a_21487_106400.t12 a_21487_106400# 0 $ **FLOATING
C1511 a_21487_106400.t4 a_21487_106400# 0 $ **FLOATING
C1512 a_21487_106400.t10 a_21487_106400# 0 $ **FLOATING
C1513 a_21487_106400.t1 a_21487_106400# 0 $ **FLOATING
C1514 a_21487_106400.n143 a_21487_106400# 0 $ **FLOATING
C1515 a_21487_106400.n144 a_21487_106400# 0 $ **FLOATING
C1516 a_21487_106400.t0 a_21487_106400# 0 $ **FLOATING
C1517 a_21487_106400.t32 a_21487_106400# 0 $ **FLOATING
C1518 a_21487_106400.t31 a_21487_106400# 0 $ **FLOATING
C1519 a_21487_106400.t33 a_21487_106400# 0 $ **FLOATING
C1520 a_21487_106400.t29 a_21487_106400# 0 $ **FLOATING
C1521 a_21487_106400.t24 a_21487_106400# 0 $ **FLOATING
C1522 a_21487_106400.t18 a_21487_106400# 0 $ **FLOATING
C1523 a_21487_106400.t15 a_21487_106400# 0 $ **FLOATING
C1524 a_21487_106400.n145 a_21487_106400# 0 $ **FLOATING
C1525 a_21487_106400.n146 a_21487_106400# 0 $ **FLOATING
C1526 a_21487_106400.n147 a_21487_106400# 0 $ **FLOATING
C1527 a_21487_106400.n148 a_21487_106400# 0 $ **FLOATING
C1528 a_21487_106400.n149 a_21487_106400# 0 $ **FLOATING
C1529 a_21487_106400.n150 a_21487_106400# 0 $ **FLOATING
C1530 a_21487_106400.n151 a_21487_106400# 0 $ **FLOATING
C1531 a_21487_106400.n152 a_21487_106400# 0 $ **FLOATING
C1532 a_21487_106400.n153 a_21487_106400# 0 $ **FLOATING
C1533 a_21487_106400.n154 a_21487_106400# 0 $ **FLOATING
C1534 a_21487_106400.n155 a_21487_106400# 0 $ **FLOATING
C1535 a_21487_106400.n156 a_21487_106400# 0 $ **FLOATING
C1536 a_21487_106400.n157 a_21487_106400# 0 $ **FLOATING
C1537 a_21487_106400.n158 a_21487_106400# 0 $ **FLOATING
C1538 a_21487_106400.n159 a_21487_106400# 0 $ **FLOATING
C1539 a_21487_106400.n160 a_21487_106400# 0 $ **FLOATING
C1540 a_21487_106400.n161 a_21487_106400# 0 $ **FLOATING
C1541 a_21487_106400.n162 a_21487_106400# 0 $ **FLOATING
C1542 a_21487_106400.n163 a_21487_106400# 0 $ **FLOATING
C1543 a_21487_106400.n164 a_21487_106400# 0 $ **FLOATING
C1544 a_21487_106400.n165 a_21487_106400# 0 $ **FLOATING
C1545 a_21487_106400.n166 a_21487_106400# 0 $ **FLOATING
C1546 a_21487_106400.n167 a_21487_106400# 0 $ **FLOATING
C1547 a_21487_106400.n168 a_21487_106400# 0 $ **FLOATING
C1548 a_21487_106400.n169 a_21487_106400# 0 $ **FLOATING
C1549 a_21487_106400.n170 a_21487_106400# 0 $ **FLOATING
C1550 a_21487_106400.n171 a_21487_106400# 0 $ **FLOATING
C1551 a_21487_106400.n172 a_21487_106400# 0 $ **FLOATING
C1552 a_21487_106400.t19 a_21487_106400# 0 $ **FLOATING
C1553 a_21487_106400.n173 a_21487_106400# 0 $ **FLOATING
C1554 a_21487_106400.t20 a_21487_106400# 0 $ **FLOATING
C1555 a_21487_106400.n174 a_21487_106400# 0 $ **FLOATING
C1556 a_21487_106400.t39 a_21487_106400# 0 $ **FLOATING
C1557 a_21487_106400.n175 a_21487_106400# 0 $ **FLOATING
C1558 a_21487_106400.t16 a_21487_106400# 0 $ **FLOATING
C1559 a_21487_106400.n176 a_21487_106400# 0 $ **FLOATING
C1560 a_21487_106400.n177 a_21487_106400# 0 $ **FLOATING
C1561 a_21487_106400.n178 a_21487_106400# 0 $ **FLOATING
C1562 a_21487_106400.n179 a_21487_106400# 0 $ **FLOATING
C1563 a_21487_106400.n180 a_21487_106400# 0 $ **FLOATING
C1564 a_21487_106400.n181 a_21487_106400# 0 $ **FLOATING
C1565 a_21487_106400.n182 a_21487_106400# 0 $ **FLOATING
C1566 a_21487_106400.n183 a_21487_106400# 0 $ **FLOATING
C1567 a_21487_106400.t40 a_21487_106400# 0 $ **FLOATING
C1568 a_21487_106400.n184 a_21487_106400# 0 $ **FLOATING
C1569 a_21487_106400.t17 a_21487_106400# 0 $ **FLOATING
C1570 a_21487_106400.n185 a_21487_106400# 0 $ **FLOATING
C1571 a_21487_106400.n186 a_21487_106400# 0 $ **FLOATING
C1572 a_21487_106400.n187 a_21487_106400# 0 $ **FLOATING
C1573 a_21487_106400.n188 a_21487_106400# 0 $ **FLOATING
C1574 a_21487_106400.n189 a_21487_106400# 0 $ **FLOATING
C1575 w_21701_106400.t1 a_21487_106400# 3.1966974313874744e-17 $ **FLOATING
C1576 w_21701_106400.n0 a_21487_106400# 7.3660541877368317e-16 $ **FLOATING
C1577 w_21701_106400.n1 a_21487_106400# 8.4931411834312087e-16 $ **FLOATING
C1578 w_21701_106400.t3 a_21487_106400# 3.1966976221223717e-17 $ **FLOATING
C1579 w_21701_106400.t21 a_21487_106400# 5.3836722376574617e-16 $ **FLOATING
C1580 w_21701_106400.t22 a_21487_106400# 5.323211411300487e-16 $ **FLOATING
C1581 w_21701_106400.n2 a_21487_106400# 3.1663003159083512e-16 $ **FLOATING
C1582 w_21701_106400.n3 a_21487_106400# 1.0306557801459239e-16 $ **FLOATING
C1583 w_21701_106400.n4 a_21487_106400# 5.8161045095684902e-18 $ **FLOATING
C1584 w_21701_106400.n5 a_21487_106400# 5.0376969859192157e-17 $ **FLOATING
C1585 w_21701_106400.n6 a_21487_106400# 8.5005947980595752e-16 $ **FLOATING
C1586 w_21701_106400.t15 a_21487_106400# 3.494166433514296e-17 $ **FLOATING
C1587 w_21701_106400.n7 a_21487_106400# 1.0823086215125641e-16 $ **FLOATING
C1588 w_21701_106400.n8 a_21487_106400# 3.9664829556452139e-16 $ **FLOATING
C1589 w_21701_106400.n9 a_21487_106400# 3.7770465047817554e-17 $ **FLOATING
C1590 w_21701_106400.n10 a_21487_106400# 6.4953686055702378e-17 $ **FLOATING
C1591 w_21701_106400.n11 a_21487_106400# 3.7770465047817554e-17 $ **FLOATING
C1592 w_21701_106400.n12 a_21487_106400# 1.7888797178414423e-16 $ **FLOATING
C1593 w_21701_106400.n13 a_21487_106400# 3.7770465047817554e-17 $ **FLOATING
C1594 w_21701_106400.n14 a_21487_106400# 1.849179106180958e-16 $ **FLOATING
C1595 w_21701_106400.n15 a_21487_106400# 3.7770465047817554e-17 $ **FLOATING
C1596 w_21701_106400.n16 a_21487_106400# 1.849179106180958e-16 $ **FLOATING
C1597 w_21701_106400.n17 a_21487_106400# 3.7770465047817554e-17 $ **FLOATING
C1598 w_21701_106400.n18 a_21487_106400# 1.849179106180958e-16 $ **FLOATING
C1599 w_21701_106400.n19 a_21487_106400# 3.7770465047817554e-17 $ **FLOATING
C1600 w_21701_106400.n20 a_21487_106400# 1.0591342551415663e-16 $ **FLOATING
C1601 w_21701_106400.t4 a_21487_106400# 3.1966970499176792e-17 $ **FLOATING
C1602 w_21701_106400.t2 a_21487_106400# 3.1966966684478834e-17 $ **FLOATING
C1603 w_21701_106400.n21 a_21487_106400# 8.7783829342026508e-17 $ **FLOATING
C1604 w_21701_106400.n22 a_21487_106400# 4.0133258443603087e-17 $ **FLOATING
C1605 w_21701_106400.n23 a_21487_106400# 1.1325640627243037e-16 $ **FLOATING
C1606 w_21701_106400.t11 a_21487_106400# 3.1966974313874744e-17 $ **FLOATING
C1607 w_21701_106400.n24 a_21487_106400# 4.6640091742407477e-17 $ **FLOATING
C1608 w_21701_106400.n25 a_21487_106400# 4.1835323265383089e-17 $ **FLOATING
C1609 w_21701_106400.n26 a_21487_106400# 8.6732788502654337e-17 $ **FLOATING
C1610 w_21701_106400.t6 a_21487_106400# 3.2227907283397305e-17 $ **FLOATING
C1611 w_21701_106400.n27 a_21487_106400# 1.7537857173581618e-16 $ **FLOATING
C1612 w_21701_106400.n28 a_21487_106400# 0 $ **FLOATING
C1613 w_21701_106400.t7 a_21487_106400# 3.2227907283397305e-17 $ **FLOATING
C1614 w_21701_106400.t23 a_21487_106400# 9.4642793594365273e-17 $ **FLOATING
C1615 w_21701_106400.n29 a_21487_106400# 8.1134726882987844e-17 $ **FLOATING
C1616 w_21701_106400.t14 a_21487_106400# 3.1966976221223717e-17 $ **FLOATING
C1617 w_21701_106400.n30 a_21487_106400# 1.8369038659253034e-16 $ **FLOATING
C1618 w_21701_106400.n31 a_21487_106400# 1.563719154686486e-16 $ **FLOATING
C1619 w_21701_106400.t12 a_21487_106400# 3.1966974313874744e-17 $ **FLOATING
C1620 w_21701_106400.n32 a_21487_106400# 8.1134726882987844e-17 $ **FLOATING
C1621 w_21701_106400.n33 a_21487_106400# 1.0330797918144924e-16 $ **FLOATING
C1622 w_21701_106400.t25 a_21487_106400# 2.7095805678365249e-16 $ **FLOATING
C1623 w_21701_106400.n34 a_21487_106400# 3.6171252875241697e-16 $ **FLOATING
C1624 w_21701_106400.n35 a_21487_106400# 9.1047509436276792e-17 $ **FLOATING
C1625 w_21701_106400.n36 a_21487_106400# 4.0652858452062904e-17 $ **FLOATING
C1626 w_21701_106400.n37 a_21487_106400# 2.0681383056052578e-17 $ **FLOATING
C1627 w_21701_106400.n38 a_21487_106400# 9.9888377122983483e-17 $ **FLOATING
C1628 w_21701_106400.n39 a_21487_106400# 2.4539730692471524e-16 $ **FLOATING
C1629 w_21701_106400.t24 a_21487_106400# 3.9061081888741055e-16 $ **FLOATING
C1630 w_21701_106400.n40 a_21487_106400# 7.7558925150295494e-16 $ **FLOATING
C1631 w_21701_106400.t17 a_21487_106400# 3.1966974313874744e-17 $ **FLOATING
C1632 w_21701_106400.t26 a_21487_106400# 4.4789827430952263e-16 $ **FLOATING
C1633 w_21701_106400.n41 a_21487_106400# 1.9245810363125064e-16 $ **FLOATING
C1634 w_21701_106400.n42 a_21487_106400# 4.4355114370207386e-17 $ **FLOATING
C1635 w_21701_106400.n43 a_21487_106400# 1.1297782651016767e-16 $ **FLOATING
C1636 w_21701_106400.n44 a_21487_106400# 1.4207752506779299e-16 $ **FLOATING
C1637 w_21701_106400.n45 a_21487_106400# 9.8814831091555572e-16 $ **FLOATING
C1638 w_21701_106400.t8 a_21487_106400# 1.9165561325183919e-15 $ **FLOATING
C1639 w_21701_106400.t0 a_21487_106400# 1.8456509683362747e-15 $ **FLOATING
C1640 w_21701_106400.t5 a_21487_106400# 5.0104885764607331e-16 $ **FLOATING
C1641 w_21701_106400.t13 a_21487_106400# 8.5928665432517803e-16 $ **FLOATING
C1642 w_21701_106400.t10 a_21487_106400# 8.3508138872001076e-16 $ **FLOATING
C1643 w_21701_106400.t16 a_21487_106400# 7.3099878934240956e-16 $ **FLOATING
C1644 w_21701_106400.n46 a_21487_106400# 1.5376325716026301e-16 $ **FLOATING
C1645 w_21701_106400.n47 a_21487_106400# 9.9585261223473761e-17 $ **FLOATING
C1646 w_21701_106400.n48 a_21487_106400# 6.5071804363183096e-17 $ **FLOATING
C1647 w_21701_106400.n49 a_21487_106400# 2.6223039407346043e-16 $ **FLOATING
C1648 w_21701_106400.n50 a_21487_106400# 6.2572502764015053e-16 $ **FLOATING
C1649 w_21701_106400.n51 a_21487_106400# 3.1385937068969369e-16 $ **FLOATING
C1650 w_21701_106400.t9 a_21487_106400# 3.1966970499176792e-17 $ **FLOATING
C1651 w_21701_106400.t18 a_21487_106400# 3.1966966684478834e-17 $ **FLOATING
C1652 w_21701_106400.t20 a_21487_106400# 3.9426645919654412e-16 $ **FLOATING
C1653 w_21701_106400.t19 a_21487_106400# 3.9426645919654412e-16 $ **FLOATING
C1654 w_21701_106400.n52 a_21487_106400# 5.9021311936649639e-16 $ **FLOATING
C1655 w_21701_106400.n53 a_21487_106400# 2.0105980501496639e-16 $ **FLOATING
C1656 w_22789_106400.t4 a_21487_106400# 1.4430073174098549e-17 $ **FLOATING
C1657 w_22789_106400.n0 a_21487_106400# 6.7650517680585674e-17 $ **FLOATING
C1658 w_22789_106400.t2 a_21487_106400# 2.7676791063027657e-17 $ **FLOATING
C1659 w_22789_106400.n1 a_21487_106400# 5.1636793025720595e-17 $ **FLOATING
C1660 w_22789_106400.n2 a_21487_106400# 3.2701418552186907e-17 $ **FLOATING
C1661 w_22789_106400.n3 a_21487_106400# 1.1962010488275211e-16 $ **FLOATING
C1662 w_22789_106400.n4 a_21487_106400# 3.2701418552186907e-17 $ **FLOATING
C1663 w_22789_106400.n5 a_21487_106400# 1.1962010488275211e-16 $ **FLOATING
C1664 w_22789_106400.n6 a_21487_106400# 3.2701418552186907e-17 $ **FLOATING
C1665 w_22789_106400.n7 a_21487_106400# 1.2260483834763676e-16 $ **FLOATING
C1666 w_22789_106400.n8 a_21487_106400# 4.3616045200783889e-17 $ **FLOATING
C1667 w_22789_106400.n9 a_21487_106400# 6.634349563694409e-17 $ **FLOATING
C1668 w_22789_106400.t15 a_21487_106400# 2.7676791063027657e-17 $ **FLOATING
C1669 w_22789_106400.n10 a_21487_106400# 7.8184628291809051e-17 $ **FLOATING
C1670 w_22789_106400.n11 a_21487_106400# 7.9539387455166871e-17 $ **FLOATING
C1671 w_22789_106400.n12 a_21487_106400# 3.5196978147030734e-17 $ **FLOATING
C1672 w_22789_106400.n13 a_21487_106400# 7.9539387455166871e-17 $ **FLOATING
C1673 w_22789_106400.n14 a_21487_106400# 6.0386243367341957e-17 $ **FLOATING
C1674 w_22789_106400.n15 a_21487_106400# 7.9539387455166871e-17 $ **FLOATING
C1675 w_22789_106400.n16 a_21487_106400# 1.6577309532739704e-16 $ **FLOATING
C1676 w_22789_106400.t20 a_21487_106400# 3.3818824972136101e-16 $ **FLOATING
C1677 w_22789_106400.n17 a_21487_106400# 8.5085461151972714e-17 $ **FLOATING
C1678 w_22789_106400.n18 a_21487_106400# 3.1988667191494992e-17 $ **FLOATING
C1679 w_22789_106400.n19 a_21487_106400# 4.3616045200783889e-17 $ **FLOATING
C1680 w_22789_106400.n20 a_21487_106400# 1.1066350122891485e-16 $ **FLOATING
C1681 w_22789_106400.n21 a_21487_106400# 3.2701418552186907e-17 $ **FLOATING
C1682 w_22789_106400.n22 a_21487_106400# 1.1066350122891485e-16 $ **FLOATING
C1683 w_22789_106400.n23 a_21487_106400# 3.2701418552186907e-17 $ **FLOATING
C1684 w_22789_106400.n24 a_21487_106400# 9.1643207782870136e-17 $ **FLOATING
C1685 w_22789_106400.n25 a_21487_106400# 3.2701418552186907e-17 $ **FLOATING
C1686 w_22789_106400.n26 a_21487_106400# 9.8559680901211574e-17 $ **FLOATING
C1687 w_22789_106400.n27 a_21487_106400# 3.2701418552186907e-17 $ **FLOATING
C1688 w_22789_106400.n28 a_21487_106400# 6.3766042124402637e-17 $ **FLOATING
C1689 w_22789_106400.n29 a_21487_106400# 3.2701418552186907e-17 $ **FLOATING
C1690 w_22789_106400.t5 a_21487_106400# 1.4933720958673725e-17 $ **FLOATING
C1691 w_22789_106400.n30 a_21487_106400# 1.0511217850887664e-16 $ **FLOATING
C1692 w_22789_106400.n31 a_21487_106400# 4.3573595251271166e-17 $ **FLOATING
C1693 w_22789_106400.n32 a_21487_106400# 2.728470123460249e-17 $ **FLOATING
C1694 w_22789_106400.t16 a_21487_106400# 2.7676791063027657e-17 $ **FLOATING
C1695 w_22789_106400.n33 a_21487_106400# 8.5841228944699161e-17 $ **FLOATING
C1696 w_22789_106400.n34 a_21487_106400# 3.2701418552186907e-17 $ **FLOATING
C1697 w_22789_106400.n35 a_21487_106400# 2.8372732960875585e-17 $ **FLOATING
C1698 w_22789_106400.n36 a_21487_106400# 3.2701418552186907e-17 $ **FLOATING
C1699 w_22789_106400.n37 a_21487_106400# 6.438091789382725e-17 $ **FLOATING
C1700 w_22789_106400.n38 a_21487_106400# 3.2701418552186907e-17 $ **FLOATING
C1701 w_22789_106400.t6 a_21487_106400# 3.624592448664789e-16 $ **FLOATING
C1702 w_22789_106400.t8 a_21487_106400# 1.0030916355988381e-15 $ **FLOATING
C1703 w_22789_106400.t11 a_21487_106400# 2.5819014493793177e-16 $ **FLOATING
C1704 w_22789_106400.t17 a_21487_106400# 5.5176426066084933e-16 $ **FLOATING
C1705 w_22789_106400.t0 a_21487_106400# 1.1826662135411006e-15 $ **FLOATING
C1706 w_22789_106400.t3 a_21487_106400# 4.8658912282736095e-16 $ **FLOATING
C1707 w_22789_106400.t14 a_21487_106400# 1.2162586194546968e-15 $ **FLOATING
C1708 w_22789_106400.n39 a_21487_106400# 2.6525447571650979e-16 $ **FLOATING
C1709 w_22789_106400.n40 a_21487_106400# 4.3616045200783889e-17 $ **FLOATING
C1710 w_22789_106400.n41 a_21487_106400# 9.1054630535366863e-17 $ **FLOATING
C1711 w_22789_106400.n42 a_21487_106400# 6.4396878586562791e-17 $ **FLOATING
C1712 w_22789_106400.n43 a_21487_106400# 5.1958867903269003e-17 $ **FLOATING
C1713 w_22789_106400.t9 a_21487_106400# 2.7676791063027657e-17 $ **FLOATING
C1714 w_22789_106400.n44 a_21487_106400# 7.8184628291809051e-17 $ **FLOATING
C1715 w_22789_106400.n45 a_21487_106400# 2.8998812495731431e-17 $ **FLOATING
C1716 w_22789_106400.n46 a_21487_106400# 3.5196978147030734e-17 $ **FLOATING
C1717 w_22789_106400.n47 a_21487_106400# 6.0633882060055579e-17 $ **FLOATING
C1718 w_22789_106400.n48 a_21487_106400# 6.0386243367341957e-17 $ **FLOATING
C1719 w_22789_106400.n49 a_21487_106400# 6.0633882060055579e-17 $ **FLOATING
C1720 w_22789_106400.n50 a_21487_106400# 1.6577309532739704e-16 $ **FLOATING
C1721 w_22789_106400.t21 a_21487_106400# 3.3818824972136101e-16 $ **FLOATING
C1722 w_22789_106400.n51 a_21487_106400# 6.7412923085379879e-17 $ **FLOATING
C1723 w_22789_106400.n52 a_21487_106400# 6.0340329672847427e-17 $ **FLOATING
C1724 w_22789_106400.n53 a_21487_106400# 3.2701418552186907e-17 $ **FLOATING
C1725 w_22789_106400.n54 a_21487_106400# 5.9315755433107781e-17 $ **FLOATING
C1726 w_22789_106400.n55 a_21487_106400# 3.2701418552186907e-17 $ **FLOATING
C1727 w_22789_106400.n56 a_21487_106400# 8.4360180418601578e-17 $ **FLOATING
C1728 w_22789_106400.n57 a_21487_106400# 3.2701418552186907e-17 $ **FLOATING
C1729 w_22789_106400.n58 a_21487_106400# 3.8884771734582722e-17 $ **FLOATING
C1730 w_22789_106400.n59 a_21487_106400# 3.2701418552186907e-17 $ **FLOATING
C1731 w_22789_106400.n60 a_21487_106400# 4.547541249871597e-17 $ **FLOATING
C1732 w_22789_106400.n61 a_21487_106400# 3.2701418552186907e-17 $ **FLOATING
C1733 w_22789_106400.n62 a_21487_106400# 3.9278288259729474e-17 $ **FLOATING
C1734 w_22789_106400.n63 a_21487_106400# 3.2701418552186907e-17 $ **FLOATING
C1735 w_22789_106400.t12 a_21487_106400# 1.4597391511675119e-17 $ **FLOATING
C1736 w_22789_106400.t13 a_21487_106400# 1.5393705720053124e-17 $ **FLOATING
C1737 w_22789_106400.n64 a_21487_106400# 1.6687079731086053e-16 $ **FLOATING
C1738 w_22789_106400.n65 a_21487_106400# 1.6082749310370379e-16 $ **FLOATING
C1739 w_22789_106400.n66 a_21487_106400# 7.6605488644057078e-17 $ **FLOATING
C1740 w_22789_106400.t10 a_21487_106400# 2.7676791063027657e-17 $ **FLOATING
C1741 w_22789_106400.n67 a_21487_106400# 8.3042057606350876e-17 $ **FLOATING
C1742 w_22789_106400.n68 a_21487_106400# 1.0307370355192938e-16 $ **FLOATING
C1743 w_22789_106400.n69 a_21487_106400# 7.1845372252957848e-17 $ **FLOATING
C1744 w_22789_106400.n70 a_21487_106400# 3.2701418552186907e-17 $ **FLOATING
C1745 w_22789_106400.n71 a_21487_106400# 5.6916467349393749e-17 $ **FLOATING
C1746 w_22789_106400.n72 a_21487_106400# 3.2701418552186907e-17 $ **FLOATING
C1747 w_22789_106400.n73 a_21487_106400# 8.5841228944699161e-17 $ **FLOATING
C1748 w_22789_106400.n74 a_21487_106400# 3.2701418552186907e-17 $ **FLOATING
C1749 w_22789_106400.n75 a_21487_106400# 8.4313099426789389e-17 $ **FLOATING
C1750 w_22789_106400.n76 a_21487_106400# 3.2701418552186907e-17 $ **FLOATING
C1751 w_22789_106400.n77 a_21487_106400# 1.9669179529081426e-16 $ **FLOATING
C1752 w_22789_106400.n78 a_21487_106400# 1.0767095526433559e-16 $ **FLOATING
C1753 w_22789_106400.n79 a_21487_106400# 1.0511217850887664e-16 $ **FLOATING
C1754 w_22789_106400.n80 a_21487_106400# 4.3573595251271166e-17 $ **FLOATING
C1755 w_22789_106400.n81 a_21487_106400# 3.1988667191494992e-17 $ **FLOATING
C1756 w_22789_106400.n82 a_21487_106400# 4.3616045200783889e-17 $ **FLOATING
C1757 w_22789_106400.n83 a_21487_106400# 1.1066350122891485e-16 $ **FLOATING
C1758 w_22789_106400.n84 a_21487_106400# 3.2701418552186907e-17 $ **FLOATING
C1759 w_22789_106400.n85 a_21487_106400# 1.1066350122891485e-16 $ **FLOATING
C1760 w_22789_106400.n86 a_21487_106400# 1.0540300338764648e-16 $ **FLOATING
C1761 w_22789_106400.t1 a_21487_106400# 6.157739875444042e-18 $ **FLOATING
C1762 w_22789_106400.n87 a_21487_106400# 7.8184628291809051e-17 $ **FLOATING
C1763 w_22789_106400.n88 a_21487_106400# 7.9539387455166871e-17 $ **FLOATING
C1764 w_22789_106400.n89 a_21487_106400# 3.5196978147030734e-17 $ **FLOATING
C1765 w_22789_106400.n90 a_21487_106400# 7.9539387455166871e-17 $ **FLOATING
C1766 w_22789_106400.n91 a_21487_106400# 6.0386243367341957e-17 $ **FLOATING
C1767 w_22789_106400.n92 a_21487_106400# 1.4755365939399612e-16 $ **FLOATING
C1768 w_22789_106400.n93 a_21487_106400# 1.6577309532739704e-16 $ **FLOATING
C1769 w_22789_106400.t19 a_21487_106400# 3.3818824972136101e-16 $ **FLOATING
C1770 w_22789_106400.n94 a_21487_106400# 1.8756801635054224e-16 $ **FLOATING
C1771 w_22789_106400.t18 a_21487_106400# 1.4933720958673725e-17 $ **FLOATING
C1772 w_22789_106400.n95 a_21487_106400# 1.1868477929675076e-16 $ **FLOATING
C1773 w_22789_106400.n96 a_21487_106400# 6.0448339007004798e-17 $ **FLOATING
C1774 w_22789_106400.t7 a_21487_106400# 1.4605695153623522e-17 $ **FLOATING
C1775 w_22789_106400.n97 a_21487_106400# 1.2366488164116588e-16 $ **FLOATING
C1776 w_22789_106400.n98 a_21487_106400# 6.2991429727920558e-17 $ **FLOATING
C1777 w_65064_21062.t0 a_21487_106400# 7.3861926083100451e-16 $ **FLOATING
C1778 w_65064_21062.t1 a_21487_106400# 1.3469713100767467e-15 $ **FLOATING
C1779 w_66216_20978.t0 a_21487_106400# 1.5250450000000003e-15 $ **FLOATING
C1780 w_66216_20978.t1 a_21487_106400# 1.1597647370883241e-15 $ **FLOATING
C1781 a_65266_21098.t4 a_21487_106400# 8.61144097491914e-18 $ **FLOATING
C1782 a_65266_21098.t0 a_21487_106400# 8.6114428822680543e-18 $ **FLOATING
C1783 a_65266_21098.n0 a_21487_106400# 2.653782434839579e-16 $ **FLOATING
C1784 a_65266_21098.n1 a_21487_106400# 5.718430790259435e-17 $ **FLOATING
C1785 a_65266_21098.n2 a_21487_106400# 3.1297606315632085e-17 $ **FLOATING
C1786 a_65266_21098.t8 a_21487_106400# 9.2787496899726963e-17 $ **FLOATING
C1787 a_65266_21098.t1 a_21487_106400# 6.8766146311135172e-18 $ **FLOATING
C1788 a_65266_21098.n3 a_21487_106400# 5.7403492810408255e-17 $ **FLOATING
C1789 a_65266_21098.t9 a_21487_106400# 9.7939467569212824e-17 $ **FLOATING
C1790 a_65266_21098.t5 a_21487_106400# 6.8766146311135172e-18 $ **FLOATING
C1791 a_65266_21098.n4 a_21487_106400# 5.7403492810408255e-17 $ **FLOATING
C1792 a_65266_21098.n5 a_21487_106400# 1.0652160308174112e-17 $ **FLOATING
C1793 a_65266_21098.n6 a_21487_106400# 3.3074116816281131e-17 $ **FLOATING
C1794 a_65266_21098.n7 a_21487_106400# 5.260176480732261e-18 $ **FLOATING
C1795 a_65266_21098.n8 a_21487_106400# 1.0918420494537163e-17 $ **FLOATING
C1796 a_65266_21098.n9 a_21487_106400# 5.260176480732261e-18 $ **FLOATING
C1797 a_65266_21098.n10 a_21487_106400# 1.0918420494537163e-17 $ **FLOATING
C1798 a_65266_21098.n11 a_21487_106400# 5.260176480732261e-18 $ **FLOATING
C1799 a_65266_21098.n12 a_21487_106400# 1.2738981981297152e-16 $ **FLOATING
C1800 a_65266_21098.n13 a_21487_106400# 7.9667479820425281e-18 $ **FLOATING
C1801 a_65266_21098.n14 a_21487_106400# 4.2081409938509178e-18 $ **FLOATING
C1802 a_65266_21098.n15 a_21487_106400# 9.3830179701207967e-18 $ **FLOATING
C1803 a_65266_21098.n16 a_21487_106400# 4.2081409938509178e-18 $ **FLOATING
C1804 a_65266_21098.n17 a_21487_106400# 9.3830179701207967e-18 $ **FLOATING
C1805 a_65266_21098.n18 a_21487_106400# 7.7012860212000312e-18 $ **FLOATING
C1806 a_65266_21098.n19 a_21487_106400# 9.3830179701207967e-18 $ **FLOATING
C1807 a_65266_21098.n20 a_21487_106400# 9.0719589261375798e-18 $ **FLOATING
C1808 a_65266_21098.n21 a_21487_106400# 9.1995243288621893e-18 $ **FLOATING
C1809 a_65266_21098.n22 a_21487_106400# 1.0307102350180124e-15 $ **FLOATING
C1810 a_65266_21098.n23 a_21487_106400# 9.2758659691494524e-18 $ **FLOATING
C1811 a_65266_21098.n24 a_21487_106400# 7.4637639181463486e-16 $ **FLOATING
C1812 a_65266_21098.n25 a_21487_106400# 9.0719589261375798e-18 $ **FLOATING
C1813 a_65266_21098.n26 a_21487_106400# 9.3830179701207967e-18 $ **FLOATING
C1814 a_65266_21098.n27 a_21487_106400# 9.3830179701207967e-18 $ **FLOATING
C1815 a_65266_21098.n28 a_21487_106400# 0 $ **FLOATING
C1816 a_65266_21098.n29 a_21487_106400# 9.3830179701207967e-18 $ **FLOATING
C1817 a_65266_21098.n30 a_21487_106400# 7.9667479820425281e-18 $ **FLOATING
C1818 a_65266_21098.n31 a_21487_106400# 4.2081409938509178e-18 $ **FLOATING
C1819 a_65266_21098.n32 a_21487_106400# 4.2081409938509178e-18 $ **FLOATING
C1820 a_65266_21098.n33 a_21487_106400# 1.0575819621561306e-17 $ **FLOATING
C1821 a_65266_21098.n34 a_21487_106400# 3.3074116816281131e-17 $ **FLOATING
C1822 a_65266_21098.n35 a_21487_106400# 5.260176480732261e-18 $ **FLOATING
C1823 a_65266_21098.n36 a_21487_106400# 1.0918420494537163e-17 $ **FLOATING
C1824 a_65266_21098.n37 a_21487_106400# 5.260176480732261e-18 $ **FLOATING
C1825 a_65266_21098.n38 a_21487_106400# 1.0918420494537163e-17 $ **FLOATING
C1826 a_65266_21098.n39 a_21487_106400# 5.260176480732261e-18 $ **FLOATING
C1827 a_65266_21098.n40 a_21487_106400# 2.653609094970264e-16 $ **FLOATING
C1828 a_65266_21098.n41 a_21487_106400# 9.9139479953223139e-17 $ **FLOATING
C1829 a_65266_21098.t10 a_21487_106400# 9.7939467569212824e-17 $ **FLOATING
C1830 a_65266_21098.t3 a_21487_106400# 6.8766146311135172e-18 $ **FLOATING
C1831 a_65266_21098.n42 a_21487_106400# 5.7403492810408255e-17 $ **FLOATING
C1832 a_65266_21098.t7 a_21487_106400# 1.1210031255317656e-17 $ **FLOATING
C1833 a_65266_21098.n43 a_21487_106400# 5.7199078412585224e-17 $ **FLOATING
C1834 a_65266_21098.t2 a_21487_106400# 8.6114428822680543e-18 $ **FLOATING
C1835 a_65266_21098.t6 a_21487_106400# 8.6114428822680543e-18 $ **FLOATING
C1836 a_65266_21098.n44 a_21487_106400# 1.2739239091930776e-16 $ **FLOATING
C1837 a_65266_21098.n45 a_21487_106400# 7.7012860212000312e-18 $ **FLOATING
C1838 a_65100_21043.t0 a_21487_106400# 6.9518521454525598e-18 $ **FLOATING
C1839 a_65100_21043.n0 a_21487_106400# 1.1954219515174222e-16 $ **FLOATING
C1840 a_65100_21043.t2 a_21487_106400# 3.1176789447351913e-17 $ **FLOATING
C1841 a_65100_21043.t4 a_21487_106400# 1.1312032794387819e-16 $ **FLOATING
C1842 a_65100_21043.n1 a_21487_106400# 6.4588743480394785e-16 $ **FLOATING
C1843 a_65100_21043.n2 a_21487_106400# 3.7361800200647009e-16 $ **FLOATING
C1844 a_65100_21043.t1 a_21487_106400# 1.9943687410393777e-18 $ **FLOATING
C1845 a_65100_21043.n3 a_21487_106400# 4.0934094345348263e-18 $ **FLOATING
C1846 a_65100_21043.t3 a_21487_106400# 3.5273646414453181e-17 $ **FLOATING
C1847 a_65931_21111.t0 a_21487_106400# 2.0479270984723763e-17 $ **FLOATING
C1848 a_65931_21111.n0 a_21487_106400# 7.852436084717112e-17 $ **FLOATING
C1849 a_65931_21111.t4 a_21487_106400# 7.0534622363439392e-17 $ **FLOATING
C1850 a_65931_21111.n1 a_21487_106400# 7.8524337958987464e-17 $ **FLOATING
C1851 a_65931_21111.t2 a_21487_106400# 2.0479270984723763e-17 $ **FLOATING
C1852 a_65931_21111.t5 a_21487_106400# 7.4305923642116566e-17 $ **FLOATING
C1853 a_65931_21111.n2 a_21487_106400# 4.189357920316043e-16 $ **FLOATING
C1854 a_65931_21111.n3 a_21487_106400# 2.6559426944293233e-16 $ **FLOATING
C1855 a_65931_21111.t3 a_21487_106400# 2.3170393046303827e-17 $ **FLOATING
C1856 a_65931_21111.t1 a_21487_106400# 2.3170396861001104e-17 $ **FLOATING
.ends
