* NGSPICE file created from RotatedCrop.ext - technology: sky130A

.subckt RotatedCrop
* OPENPLL_ORIGIN X0 sky130_fd_pr__pfet_01v8 21098 22108 21099 22109
X0 a_21043_22108# a_21058_20215# a_21043_22108# w_20978_22048# sky130_fd_pr__pfet_01v8 ad=0.275 pd=2.55 as=0 ps=0 w=1 l=1
* OPENPLL_ORIGIN X1 sky130_fd_pr__nfet_01v8 107267 65119 107268 65120
X1 a_106400_64915# w_106364_65359# a_106400_64915# a_106400_64915# sky130_fd_pr__nfet_01v8 ad=0.143 pd=1.62 as=0 ps=0 w=0.55 l=1.97
* OPENPLL_ORIGIN X2 sky130_fd_pr__nfet_01v8 109107 66003 109108 66004
X2 a_106400_64915# w_106364_65359# a_106400_64915# a_106400_64915# sky130_fd_pr__nfet_01v8 ad=0.143 pd=1.62 as=0 ps=0 w=0.55 l=2.69
* OPENPLL_ORIGIN X3 sky130_fd_pr__pfet_01v8_hvt 106531 65663 106532 65664
X3 w_106364_65359# a_106400_64915# w_106364_65359# w_106364_65359# sky130_fd_pr__pfet_01v8_hvt ad=0.2262 pd=2.26 as=0 ps=0 w=0.87 l=4.73
* OPENPLL_ORIGIN X4 sky130_fd_pr__pfet_01v8_hvt 108003 64400 108004 64401
X4 w_106364_64364# a_108003_64400# w_106364_64364# w_106364_64364# sky130_fd_pr__pfet_01v8_hvt ad=0.1053 pd=1.33 as=0 ps=0 w=0.405 l=4.73
* OPENPLL_ORIGIN X5 sky130_fd_pr__pfet_01v8 21098 21124 21099 21125
X5 a_21043_20776# a_21058_20215# a_21043_20776# w_20978_20716# sky130_fd_pr__pfet_01v8 ad=0.275 pd=2.55 as=0 ps=0 w=1 l=1
* OPENPLL_ORIGIN X6 sky130_fd_pr__pfet_01v8_hvt 108739 64575 108740 64576
X6 w_106364_64364# a_106400_64915# w_106364_64364# w_106364_64364# sky130_fd_pr__pfet_01v8_hvt ad=0.2262 pd=2.26 as=0 ps=0 w=0.87 l=4.73
* OPENPLL_ORIGIN X7 sky130_fd_pr__nfet_01v8 107635 64915 107636 64916
X7 a_106400_64915# w_106364_64364# a_106400_64915# a_106400_64915# sky130_fd_pr__nfet_01v8 ad=0.143 pd=1.62 as=0 ps=0 w=0.55 l=4.73
* OPENPLL_ORIGIN X8 sky130_fd_pr__pfet_01v8_hvt 107267 64400 107268 64401
X8 w_106364_64364# a_107267_64400# w_106364_64364# w_106364_64364# sky130_fd_pr__pfet_01v8_hvt ad=0.1053 pd=1.33 as=0 ps=0 w=0.405 l=1.97
* OPENPLL_ORIGIN X9 sky130_fd_pr__pfet_01v8_hvt 109107 65663 109108 65664
X9 w_106364_65359# a_106400_64915# w_106364_65359# w_106364_65359# sky130_fd_pr__pfet_01v8_hvt ad=0.2262 pd=2.26 as=0 ps=0 w=0.87 l=2.53
* OPENPLL_ORIGIN X10 sky130_fd_pr__pfet_01v8_hvt 108003 65395 108004 65396
X10 w_106364_65359# a_106400_64915# w_106364_65359# w_106364_65359# sky130_fd_pr__pfet_01v8_hvt ad=0.2262 pd=2.26 as=0 ps=0 w=0.87 l=4.73
* OPENPLL_ORIGIN X11 sky130_fd_pr__nfet_01v8_lvt 21111 21547 21112 21548
X11 a_21058_20215# a_21043_20776# a_21058_20215# a_106400_64915# sky130_fd_pr__nfet_01v8_lvt ad=0.1113 pd=1.37 as=0 ps=0 w=0.42 l=1
* OPENPLL_ORIGIN X12 sky130_fd_pr__nfet_01v8 108003 66003 108004 66004
X12 a_106400_64915# w_106364_65359# a_106400_64915# a_106400_64915# sky130_fd_pr__nfet_01v8 ad=0.143 pd=1.62 as=0 ps=0 w=0.55 l=4.73
* OPENPLL_ORIGIN X13 sky130_fd_pr__pfet_01v8 21098 20776 21099 20777
X13 a_21043_20776# a_21058_20215# a_21043_20776# w_20978_20716# sky130_fd_pr__pfet_01v8 ad=0.275 pd=2.55 as=0 ps=0 w=1 l=1
* OPENPLL_ORIGIN X14 sky130_fd_pr__nfet_01v8 106400 65119 106401 65120
X14 a_106400_64915# w_106364_65359# a_106400_64915# a_106400_64915# sky130_fd_pr__nfet_01v8 ad=0.143 pd=1.62 as=0 ps=0 w=0.55 l=3.27
* OPENPLL_ORIGIN X15 sky130_fd_pr__pfet_01v8_hvt 107267 65395 107268 65396
X15 w_106364_65359# a_106400_64915# w_106364_65359# w_106364_65359# sky130_fd_pr__pfet_01v8_hvt ad=0.2262 pd=2.26 as=0 ps=0 w=0.87 l=1.97
* OPENPLL_ORIGIN X16 sky130_fd_pr__pfet_01v8_hvt 107635 64575 107636 64576
X16 w_106364_64364# a_106400_64915# w_106364_64364# w_106364_64364# sky130_fd_pr__pfet_01v8_hvt ad=0.2262 pd=2.26 as=0 ps=0 w=0.87 l=4.73
* OPENPLL_ORIGIN X17 sky130_fd_pr__nfet_01v8 106531 64915 106532 64916
X17 a_106400_64915# w_106364_64364# a_106400_64915# a_106400_64915# sky130_fd_pr__nfet_01v8 ad=0.143 pd=1.62 as=0 ps=0 w=0.55 l=4.73
* OPENPLL_ORIGIN X18 sky130_fd_pr__nfet_01v8_lvt 21111 20215 21112 20216
X18 a_21058_20215# a_21111_20175# a_21058_20215# a_106400_64915# sky130_fd_pr__nfet_01v8_lvt ad=0.1113 pd=1.37 as=0 ps=0 w=0.42 l=1
* OPENPLL_ORIGIN X19 sky130_fd_pr__nfet_01v8 107635 66003 107636 66004
X19 a_106400_64915# w_106364_65359# a_106400_64915# a_106400_64915# sky130_fd_pr__nfet_01v8 ad=0.143 pd=1.62 as=0 ps=0 w=0.55 l=0.59
* OPENPLL_ORIGIN X20 sky130_fd_pr__nfet_01v8 109107 65119 109108 65120
X20 a_106400_64915# w_106364_65359# a_106400_64915# a_106400_64915# sky130_fd_pr__nfet_01v8 ad=0.143 pd=1.62 as=0 ps=0 w=0.55 l=2.69
* OPENPLL_ORIGIN X21 sky130_fd_pr__nfet_01v8_lvt 21111 21801 21112 21802
X21 a_21058_20215# a_21043_22108# a_21058_20215# a_106400_64915# sky130_fd_pr__nfet_01v8_lvt ad=0.1113 pd=1.37 as=0 ps=0 w=0.42 l=1
* OPENPLL_ORIGIN X22 sky130_fd_pr__pfet_01v8_hvt 108003 65663 108004 65664
X22 w_106364_65359# a_106400_64915# w_106364_65359# w_106364_65359# sky130_fd_pr__pfet_01v8_hvt ad=0.2262 pd=2.26 as=0 ps=0 w=0.87 l=4.73
* OPENPLL_ORIGIN X23 sky130_fd_pr__pfet_01v8_hvt 106400 64400 106401 64401
X23 w_106364_64364# a_106400_64400# w_106364_64364# w_106364_64364# sky130_fd_pr__pfet_01v8_hvt ad=0.1053 pd=1.33 as=0 ps=0 w=0.405 l=1.57
* OPENPLL_ORIGIN X24 sky130_fd_pr__nfet_01v8_lvt 21111 20469 21112 20470
X24 a_21058_20215# a_21043_20776# a_21058_20215# a_106400_64915# sky130_fd_pr__nfet_01v8_lvt ad=0.1113 pd=1.37 as=0 ps=0 w=0.42 l=1
* OPENPLL_ORIGIN X25 sky130_fd_pr__pfet_01v8_hvt 107635 65663 107636 65664
X25 w_106364_65359# a_106400_64915# w_106364_65359# w_106364_65359# sky130_fd_pr__pfet_01v8_hvt ad=0.2262 pd=2.26 as=0 ps=0 w=0.87 l=0.59
* OPENPLL_ORIGIN X26 sky130_fd_pr__pfet_01v8_hvt 109107 64400 109108 64401
X26 w_106364_64364# a_109107_64400# w_106364_64364# w_106364_64364# sky130_fd_pr__pfet_01v8_hvt ad=0.1053 pd=1.33 as=0 ps=0 w=0.405 l=1.28
* OPENPLL_ORIGIN X27 sky130_fd_pr__pfet_01v8_hvt 106531 64575 106532 64576
X27 w_106364_64364# a_106400_64915# w_106364_64364# w_106364_64364# sky130_fd_pr__pfet_01v8_hvt ad=0.2262 pd=2.26 as=0 ps=0 w=0.87 l=4.73
* OPENPLL_ORIGIN X28 sky130_fd_pr__nfet_01v8 106531 66003 106532 66004
X28 a_106400_64915# w_106364_65359# a_106400_64915# a_106400_64915# sky130_fd_pr__nfet_01v8 ad=0.143 pd=1.62 as=0 ps=0 w=0.55 l=4.73
* OPENPLL_ORIGIN X29 sky130_fd_pr__pfet_01v8_hvt 106400 65395 106401 65396
X29 w_106364_65359# a_106400_64915# w_106364_65359# w_106364_65359# sky130_fd_pr__pfet_01v8_hvt ad=0.2262 pd=2.26 as=0 ps=0 w=0.87 l=3.11
* OPENPLL_ORIGIN X30 sky130_fd_pr__nfet_01v8 108003 65119 108004 65120
X30 a_106400_64915# w_106364_65359# a_106400_64915# a_106400_64915# sky130_fd_pr__nfet_01v8 ad=0.143 pd=1.62 as=0 ps=0 w=0.55 l=4.73
* OPENPLL_ORIGIN X31 sky130_fd_pr__pfet_01v8 21098 22456 21099 22457
X31 a_21043_22108# a_21098_22430# a_21043_22108# w_20978_22048# sky130_fd_pr__pfet_01v8 ad=0.0605 pd=0.99 as=0 ps=0 w=0.22 l=1
* OPENPLL_ORIGIN X32 sky130_fd_pr__nfet_01v8 108739 64915 108740 64916
X32 a_106400_64915# w_106364_64364# a_106400_64915# a_106400_64915# sky130_fd_pr__nfet_01v8 ad=0.143 pd=1.62 as=0 ps=0 w=0.55 l=4.73
* OPENPLL_ORIGIN X33 sky130_fd_pr__pfet_01v8_hvt 109107 65395 109108 65396
X33 w_106364_65359# a_106400_64915# w_106364_65359# w_106364_65359# sky130_fd_pr__pfet_01v8_hvt ad=0.2262 pd=2.26 as=0 ps=0 w=0.87 l=2.53
C0 m3_22226_21536# m2_22346_20000# 5.1122700000000006e-17
C1 m3_22226_21536# m4_22042_20000# 6.140160000000001e-16
C2 w_106364_64364# a_108003_64400# 4.4880300000000007e-16
C3 w_20978_20000# m1_22136_21172# 3.2119600000000002e-18
C4 m2_22346_20000# m1_21080_20136# 2.2759100000000004e-17
C5 w_20978_20000# m4_21658_20000# 2.5581000000000003e-18
C6 a_21043_20776# m2_22346_20000# 6.8070499999999998e-17
C7 m1_20000_20222# m4_22426_20000# 9.9906400000000019e-19
C8 a_21043_22108# a_21058_20215# 6.3762400000000006e-16
C9 m4_22042_20000# m1_21080_20136# 1.6285e-18
C10 a_21043_20776# m4_22042_20000# 8.8562999999999996e-18
C11 a_107267_64400# a_108003_64400# 1.2163700000000001e-18
C12 w_20978_20716# m2_22346_20000# 3.2141400000000004e-17
C13 a_21058_20215# m2_21674_20000# 1.5544400000000001e-16
C14 w_20978_20716# m4_22042_20000# 9.0080500000000004e-18
C15 w_20978_22048# m3_22226_21536# 4.9466100000000001e-18
C16 m2_21482_20000# a_21111_20175# 1.1578200000000001e-17
C17 m3_22226_21536# m4_22426_20000# 6.5634300000000008e-16
C18 a_21058_20215# m1_22136_21172# 1.08716e-16
C19 a_21058_20215# m4_21658_20000# 2.27618e-16
C20 m2_22346_20000# m4_22042_20000# 1.0591400000000002e-17
C21 m2_21482_20000# m1_20000_20222# 2.4562000000000002e-17
C22 m4_22426_20000# m1_21080_20136# 1.3892400000000002e-18
C23 a_21043_20776# m4_22426_20000# 5.7916999999999998e-18
C24 a_21111_20175# m5_20000_20864# 3.5281500000000001e-19
C25 w_106364_64364# a_109107_64400# 2.63403e-16
C26 w_20978_20716# m4_22426_20000# 4.9793700000000006e-18
C27 a_106400_64400# w_106364_65359# 3.5767900000000004e-18
C28 a_21098_22430# m2_22346_20000# 7.8486300000000013e-21
C29 w_20978_22048# m2_22346_20000# 3.1349100000000002e-17
C30 a_21098_22430# m4_22042_20000# 1.0612000000000001e-20
C31 m1_20000_20222# m5_20000_20864# 2.3707300000000004e-18
C32 w_20978_22048# m4_22042_20000# 6.5861000000000007e-18
C33 w_20978_20000# a_21111_20175# 2.2428400000000003e-17
C34 m2_21482_20000# m3_22226_21536# 8.4636000000000015e-20
C35 m2_22346_20000# m4_22426_20000# 2.5023100000000001e-17
C36 w_20978_20000# m1_20000_20222# 1.4063000000000002e-18
C37 m2_21482_20000# m1_21080_20136# 4.8298300000000001e-17
C38 m4_22042_20000# m4_22426_20000# 1.9293600000000002e-16
C39 m2_21482_20000# a_21043_20776# 1.1764e-16
C40 w_20978_22048# a_21098_22430# 5.2726700000000005e-17
C41 m2_21482_20000# w_20978_20716# 3.0487600000000004e-17
C42 a_21043_22108# m2_21674_20000# 7.6047300000000016e-17
C43 m3_22226_21536# m5_20000_20864# 1.7783400000000002e-16
C44 a_21098_22430# m4_22426_20000# 9.3524300000000013e-22
C45 a_21058_20215# a_21111_20175# 2.1590700000000004e-16
C46 w_20978_22048# m4_22426_20000# 4.0374999999999995e-18
C47 m5_20000_20864# m1_21080_20136# 1.4143500000000001e-18
C48 a_21043_20776# m5_20000_20864# 2.8862400000000001e-17
C49 w_20978_20000# m3_22226_21536# 8.4649000000000005e-19
C50 a_21058_20215# m1_20000_20222# 8.5240000000000001e-16
C51 a_21043_22108# m1_22136_21172# 6.1075300000000006e-20
C52 a_21043_22108# m4_21658_20000# 1.6507000000000003e-17
C53 w_20978_20716# m5_20000_20864# 2.0536599999999999e-17
C54 w_20978_20000# m1_21080_20136# 1.4178000000000003e-17
C55 m1_22136_21172# m2_21674_20000# 1.1905800000000002e-16
C56 m2_21674_20000# m4_21658_20000# 2.66712e-17
C57 w_106364_64364# a_106400_64400# 3.3554199999999996e-16
C58 m2_21482_20000# a_21098_22430# 2.0855700000000003e-18
C59 m2_22346_20000# m5_20000_20864# 8.1952200000000019e-18
C60 w_20978_22048# m2_21482_20000# 1.8931300000000003e-17
C61 m5_20000_20864# m4_22042_20000# 1.98648e-16
C62 a_107267_64400# a_106400_64400# 2.6329100000000002e-18
C63 m1_22136_21172# m4_21658_20000# 4.7e-19
C64 a_21058_20215# m3_22226_21536# 2.8119599999999999e-17
C65 w_20978_20000# m2_22346_20000# 1.8978e-18
C66 a_21058_20215# m1_21080_20136# 7.302050000000001e-17
C67 a_21058_20215# a_21043_20776# 1.2381600000000002e-15
C68 w_20978_20000# m4_22042_20000# 1.08472e-18
C69 w_20978_22048# m5_20000_20864# 4.8700000000000003e-18
C70 a_21058_20215# w_20978_20716# 4.0230400000000002e-16
C71 m5_20000_20864# m4_22426_20000# 1.3577300000000001e-16
C72 a_21058_20215# m2_22346_20000# 1.4475200000000002e-16
C73 a_21111_20175# m2_21674_20000# 5.5591599999999995e-19
C74 a_21058_20215# m4_22042_20000# 1.6941400000000004e-17
C75 w_20978_20000# m4_22426_20000# 5.92231e-19
C76 a_108003_64400# a_109107_64400# 2.6329100000000002e-18
C77 w_106364_64364# w_106364_65359# 8.8069700000000004e-16
C78 m2_21674_20000# m1_20000_20222# 2.3884200000000004e-17
C79 a_107267_64400# w_106364_65359# 4.3139900000000006e-18
C80 a_21111_20175# m1_22136_21172# 1.6522900000000002e-19
C81 a_21111_20175# m4_21658_20000# 1.9722600000000002e-18
C82 a_21058_20215# a_21098_22430# 3.35961e-17
C83 w_20978_22048# a_21058_20215# 2.0189100000000001e-16
C84 m2_21482_20000# m5_20000_20864# 1.3326700000000002e-17
C85 m1_22136_21172# m1_20000_20222# 2.3896500000000002e-17
C86 m1_20000_20222# m4_21658_20000# 3.8046000000000005e-18
C87 a_21043_22108# m3_22226_21536# 1.61041e-18
C88 a_21058_20215# m4_22426_20000# 1.4939600000000003e-17
C89 m2_21482_20000# w_20978_20000# 3.3428399999999998e-18
C90 m3_22226_21536# m2_21674_20000# 1.63333e-18
C91 a_21043_22108# a_21043_20776# 4.1432899999999998e-17
C92 m2_21674_20000# m1_21080_20136# 2.49988e-17
C93 a_21043_20776# m2_21674_20000# 7.9094400000000003e-17
C94 m1_22136_21172# m3_22226_21536# 1.9391000000000001e-17
C95 m3_22226_21536# m4_21658_20000# 2.0485600000000002e-19
C96 w_20978_20000# m5_20000_20864# 1.5137900000000001e-18
C97 m2_21674_20000# w_20978_20716# 4.7392200000000009e-17
C98 m1_22136_21172# m1_21080_20136# 2.4991099999999999e-17
C99 a_21043_20776# m1_22136_21172# 2.0253100000000003e-16
C100 m4_21658_20000# m1_21080_20136# 2.9948400000000002e-18
C101 m2_21482_20000# a_21058_20215# 2.31152e-16
C102 a_21043_20776# m4_21658_20000# 1.6397200000000001e-17
C103 a_21043_22108# m2_22346_20000# 7.3327300000000006e-17
C104 a_21043_22108# m4_22042_20000# 9.049500000000001e-18
C105 m2_21674_20000# m2_22346_20000# 9.1264200000000011e-17
C106 m1_22136_21172# w_20978_20716# 8.1488200000000022e-17
C107 w_20978_20716# m4_21658_20000# 1.1378399999999999e-17
C108 m2_21674_20000# m4_22042_20000# 1.0179600000000001e-17
C109 w_106364_64364# a_107267_64400# 2.1416300000000004e-16
C110 a_21111_20175# m1_20000_20222# 1.7539699999999999e-17
C111 a_21058_20215# m5_20000_20864# 7.4302000000000009e-16
C112 a_21043_22108# a_21098_22430# 5.9348399999999998e-17
C113 w_20978_22048# a_21043_22108# 5.3274900000000011e-16
C114 m1_22136_21172# m2_22346_20000# 3.00859e-16
C115 m2_22346_20000# m4_21658_20000# 8.7285199999999993e-19
C116 a_21098_22430# m2_21674_20000# 3.1880400000000006e-20
C117 m1_22136_21172# m4_22042_20000# 1.4423900000000002e-17
C118 m4_22042_20000# m4_21658_20000# 5.3652999999999996e-16
C119 w_20978_22048# m2_21674_20000# 3.3636200000000009e-17
C120 w_20978_20000# a_21058_20215# 6.0162100000000004e-17
C121 a_21043_22108# m4_22426_20000# 4.5276800000000007e-18
C122 a_21111_20175# m3_22226_21536# 9.1782600000000015e-20
C123 a_21098_22430# m4_21658_20000# 2.8074700000000005e-19
C124 w_20978_22048# m1_22136_21172# 3.8351200000000004e-19
C125 w_20978_22048# m4_21658_20000# 8.1896100000000012e-18
C126 a_21111_20175# m1_21080_20136# 4.1616900000000002e-17
C127 a_21043_20776# a_21111_20175# 3.4042600000000001e-17
C128 m3_22226_21536# m1_20000_20222# 1.5272800000000001e-18
C129 m1_22136_21172# m4_22426_20000# 2.3672700000000001e-18
C130 a_108003_64400# w_106364_65359# 4.3139900000000006e-18
C131 m1_20000_20222# m1_21080_20136# 6.5872900000000004e-16
C132 a_21043_20776# m1_20000_20222# 1.1850400000000001e-17
C133 m2_21482_20000# a_21043_22108# 1.01416e-16
C134 m2_21482_20000# m2_21674_20000# 5.5803600000000002e-16
C135 a_21111_20175# m2_22346_20000# 1.10534e-19
C136 a_21111_20175# m4_22042_20000# 1.2061800000000001e-19
C137 a_21043_22108# m5_20000_20864# 5.1755800000000002e-18
C138 m1_20000_20222# m2_22346_20000# 2.1664900000000002e-17
C139 m2_21482_20000# m1_22136_21172# 4.0203900000000004e-20
C140 m3_22226_21536# m1_21080_20136# 1.6020600000000002e-18
C141 a_21043_20776# m3_22226_21536# 1.24753e-17
C142 m2_21482_20000# m4_21658_20000# 1.4945500000000001e-17
C143 m1_20000_20222# m4_22042_20000# 2.5642200000000004e-18
C144 m2_21674_20000# m5_20000_20864# 8.1286e-18
C145 a_21043_20776# m1_21080_20136# 4.434400000000001e-19
C146 m3_22226_21536# w_20978_20716# 1.6701200000000002e-17
C147 w_106364_65359# a_109107_64400# 4.0955600000000003e-19
C148 w_20978_20000# m2_21674_20000# 2.9277600000000006e-18
C149 w_20978_20716# m1_21080_20136# 8.5384699999999998e-20
C150 a_21043_20776# w_20978_20716# 7.2327600000000002e-16
C151 m1_22136_21172# m5_20000_20864# 1.1621500000000001e-17
C152 m5_20000_20864# m4_21658_20000# 2.4036099999999999e-16
C153 a_21111_20175# m4_22426_20000# 1.0530900000000002e-19
C154 m5_21500_20000# a_106400_64915# 0 $ **FLOATING
C155 m5_20000_20000# a_106400_64915# 0 $ **FLOATING
C156 m5_20000_20864# a_106400_64915# 8.8871e-16
C157 m5_21500_21584# a_106400_64915# 0 $ **FLOATING
C158 m5_20000_21584# a_106400_64915# 0 $ **FLOATING
C159 m5_109500_64400# a_106400_64915# 0 $ **FLOATING
C160 m5_107500_64400# a_106400_64915# 0 $ **FLOATING
C161 m5_106400_64400# a_106400_64915# 0 $ **FLOATING
C162 m5_109500_64900# a_106400_64915# 0 $ **FLOATING
C163 m5_107500_64900# a_106400_64915# 0 $ **FLOATING
C164 m5_106400_64900# a_106400_64915# 0 $ **FLOATING
C165 m5_109500_66900# a_106400_64915# 0 $ **FLOATING
C166 m5_107500_66900# a_106400_64915# 0 $ **FLOATING
C167 m5_106400_66900# a_106400_64915# 0 $ **FLOATING
C168 m4_22426_20000# a_106400_64915# 5.1146899999999999e-16
C169 m4_22220_21770# a_106400_64915# 0 $ **FLOATING
C170 m4_22204_22056# a_106400_64915# 0 $ **FLOATING
C171 m4_22042_20000# a_106400_64915# 1.1617500000000001e-16
C172 m4_21824_20472# a_106400_64915# 0 $ **FLOATING
C173 m4_21850_20650# a_106400_64915# 0 $ **FLOATING
C174 m4_21820_21352# a_106400_64915# 0 $ **FLOATING
C175 m4_21800_22090# a_106400_64915# 0 $ **FLOATING
C176 m4_21830_22250# a_106400_64915# 0 $ **FLOATING
C177 m4_21860_22410# a_106400_64915# 0 $ **FLOATING
C178 m4_21658_20000# a_106400_64915# 2.46726e-16
C179 m4_21404_20000# a_106400_64915# 0 $ **FLOATING
C180 m4_21228_20000# a_106400_64915# 0 $ **FLOATING
C181 m4_21052_20000# a_106400_64915# 0 $ **FLOATING
C182 m4_20876_20000# a_106400_64915# 0 $ **FLOATING
C183 m4_21368_20120# a_106400_64915# 0 $ **FLOATING
C184 m4_21192_20120# a_106400_64915# 0 $ **FLOATING
C185 m4_21016_20120# a_106400_64915# 0 $ **FLOATING
C186 m4_20840_20120# a_106400_64915# 0 $ **FLOATING
C187 m4_21332_20296# a_106400_64915# 0 $ **FLOATING
C188 m4_21156_20296# a_106400_64915# 0 $ **FLOATING
C189 m4_20980_20296# a_106400_64915# 0 $ **FLOATING
C190 m4_20804_20296# a_106400_64915# 0 $ **FLOATING
C191 m4_21296_20472# a_106400_64915# 0 $ **FLOATING
C192 m4_21120_20472# a_106400_64915# 0 $ **FLOATING
C193 m4_20944_20472# a_106400_64915# 0 $ **FLOATING
C194 m4_20768_20472# a_106400_64915# 0 $ **FLOATING
C195 m4_21436_20648# a_106400_64915# 0 $ **FLOATING
C196 m4_21260_20648# a_106400_64915# 0 $ **FLOATING
C197 m4_21084_20648# a_106400_64915# 0 $ **FLOATING
C198 m4_20908_20648# a_106400_64915# 0 $ **FLOATING
C199 m4_20732_20648# a_106400_64915# 0 $ **FLOATING
C200 m4_21400_20824# a_106400_64915# 0 $ **FLOATING
C201 m4_21224_20824# a_106400_64915# 0 $ **FLOATING
C202 m4_21048_20824# a_106400_64915# 0 $ **FLOATING
C203 m4_20872_20824# a_106400_64915# 0 $ **FLOATING
C204 m4_21364_21000# a_106400_64915# 0 $ **FLOATING
C205 m4_21188_21000# a_106400_64915# 0 $ **FLOATING
C206 m4_21012_21000# a_106400_64915# 0 $ **FLOATING
C207 m4_20836_21000# a_106400_64915# 0 $ **FLOATING
C208 m4_21328_21176# a_106400_64915# 0 $ **FLOATING
C209 m4_21152_21176# a_106400_64915# 0 $ **FLOATING
C210 m4_20976_21176# a_106400_64915# 0 $ **FLOATING
C211 m4_20800_21176# a_106400_64915# 0 $ **FLOATING
C212 m4_21292_21352# a_106400_64915# 0 $ **FLOATING
C213 m4_21116_21352# a_106400_64915# 0 $ **FLOATING
C214 m4_20940_21352# a_106400_64915# 0 $ **FLOATING
C215 m4_20764_21352# a_106400_64915# 0 $ **FLOATING
C216 m4_21432_21528# a_106400_64915# 0 $ **FLOATING
C217 m4_21256_21528# a_106400_64915# 0 $ **FLOATING
C218 m4_21080_21528# a_106400_64915# 0 $ **FLOATING
C219 m4_20904_21528# a_106400_64915# 0 $ **FLOATING
C220 m4_20728_21528# a_106400_64915# 0 $ **FLOATING
C221 m4_20000_20650# a_106400_64915# 0 $ **FLOATING
C222 m4_20000_20824# a_106400_64915# 0 $ **FLOATING
C223 m4_20000_21000# a_106400_64915# 0 $ **FLOATING
C224 m4_20000_21176# a_106400_64915# 0 $ **FLOATING
C225 m4_20000_21450# a_106400_64915# 0 $ **FLOATING
C226 m4_21396_21704# a_106400_64915# 0 $ **FLOATING
C227 m4_21220_21704# a_106400_64915# 0 $ **FLOATING
C228 m4_21044_21704# a_106400_64915# 0 $ **FLOATING
C229 m4_20868_21704# a_106400_64915# 0 $ **FLOATING
C230 m4_21360_21880# a_106400_64915# 0 $ **FLOATING
C231 m4_21184_21880# a_106400_64915# 0 $ **FLOATING
C232 m4_21008_21880# a_106400_64915# 0 $ **FLOATING
C233 m4_20832_21880# a_106400_64915# 0 $ **FLOATING
C234 m4_21324_22056# a_106400_64915# 0 $ **FLOATING
C235 m4_21148_22056# a_106400_64915# 0 $ **FLOATING
C236 m4_20972_22056# a_106400_64915# 0 $ **FLOATING
C237 m4_20796_22056# a_106400_64915# 0 $ **FLOATING
C238 m4_21288_22232# a_106400_64915# 0 $ **FLOATING
C239 m4_21112_22232# a_106400_64915# 0 $ **FLOATING
C240 m4_20936_22232# a_106400_64915# 0 $ **FLOATING
C241 m4_20760_22232# a_106400_64915# 0 $ **FLOATING
C242 m4_21428_22408# a_106400_64915# 0 $ **FLOATING
C243 m4_21252_22408# a_106400_64915# 0 $ **FLOATING
C244 m4_21076_22408# a_106400_64915# 0 $ **FLOATING
C245 m4_20900_22408# a_106400_64915# 0 $ **FLOATING
C246 m4_20724_22408# a_106400_64915# 0 $ **FLOATING
C247 m4_20000_21704# a_106400_64915# 0 $ **FLOATING
C248 m4_20000_21880# a_106400_64915# 0 $ **FLOATING
C249 m4_20000_22056# a_106400_64915# 0 $ **FLOATING
C250 m4_20000_22250# a_106400_64915# 0 $ **FLOATING
C251 m4_20000_22410# a_106400_64915# 0 $ **FLOATING
C252 m4_109430_64510# a_106400_64915# 0 $ **FLOATING
C253 m4_108870_64510# a_106400_64915# 0 $ **FLOATING
C254 m4_108310_64510# a_106400_64915# 0 $ **FLOATING
C255 m4_107750_64510# a_106400_64915# 0 $ **FLOATING
C256 m4_107190_64510# a_106400_64915# 0 $ **FLOATING
C257 m4_106630_64510# a_106400_64915# 0 $ **FLOATING
C258 m4_106400_64510# a_106400_64915# 0 $ **FLOATING
C259 m4_109570_65070# a_106400_64915# 0 $ **FLOATING
C260 m4_109010_65070# a_106400_64915# 0 $ **FLOATING
C261 m4_108450_65070# a_106400_64915# 0 $ **FLOATING
C262 m4_107890_65070# a_106400_64915# 0 $ **FLOATING
C263 m4_107330_65070# a_106400_64915# 0 $ **FLOATING
C264 m4_106770_65070# a_106400_64915# 0 $ **FLOATING
C265 m4_106400_65070# a_106400_64915# 0 $ **FLOATING
C266 m4_109150_65630# a_106400_64915# 0 $ **FLOATING
C267 m4_108590_65630# a_106400_64915# 0 $ **FLOATING
C268 m4_108030_65630# a_106400_64915# 0 $ **FLOATING
C269 m4_107470_65630# a_106400_64915# 0 $ **FLOATING
C270 m4_106910_65630# a_106400_64915# 0 $ **FLOATING
C271 m4_106400_65630# a_106400_64915# 0 $ **FLOATING
C272 m4_109290_66190# a_106400_64915# 0 $ **FLOATING
C273 m4_108730_66190# a_106400_64915# 0 $ **FLOATING
C274 m4_108170_66190# a_106400_64915# 0 $ **FLOATING
C275 m4_107610_66190# a_106400_64915# 0 $ **FLOATING
C276 m4_107050_66190# a_106400_64915# 0 $ **FLOATING
C277 m4_106490_66190# a_106400_64915# 0 $ **FLOATING
C278 m4_109430_66750# a_106400_64915# 0 $ **FLOATING
C279 m4_108870_66750# a_106400_64915# 0 $ **FLOATING
C280 m4_108310_66750# a_106400_64915# 0 $ **FLOATING
C281 m4_107750_66750# a_106400_64915# 0 $ **FLOATING
C282 m4_107190_66750# a_106400_64915# 0 $ **FLOATING
C283 m4_106630_66750# a_106400_64915# 0 $ **FLOATING
C284 m4_106400_66750# a_106400_64915# 0 $ **FLOATING
C285 m4_109570_67310# a_106400_64915# 0 $ **FLOATING
C286 m4_109010_67310# a_106400_64915# 0 $ **FLOATING
C287 m4_108450_67310# a_106400_64915# 0 $ **FLOATING
C288 m4_107890_67310# a_106400_64915# 0 $ **FLOATING
C289 m4_107330_67310# a_106400_64915# 0 $ **FLOATING
C290 m4_106770_67310# a_106400_64915# 0 $ **FLOATING
C291 m4_106400_67310# a_106400_64915# 0 $ **FLOATING
C292 m3_22354_20050# a_106400_64915# 0 $ **FLOATING
C293 m3_22178_20050# a_106400_64915# 0 $ **FLOATING
C294 m3_22002_20050# a_106400_64915# 0 $ **FLOATING
C295 m3_21826_20050# a_106400_64915# 0 $ **FLOATING
C296 m3_21650_20050# a_106400_64915# 0 $ **FLOATING
C297 m3_21474_20050# a_106400_64915# 0 $ **FLOATING
C298 m3_21298_20050# a_106400_64915# 0 $ **FLOATING
C299 m3_21122_20050# a_106400_64915# 0 $ **FLOATING
C300 m3_20946_20050# a_106400_64915# 0 $ **FLOATING
C301 m3_20770_20050# a_106400_64915# 0 $ **FLOATING
C302 m3_20594_20050# a_106400_64915# 0 $ **FLOATING
C303 m3_20418_20050# a_106400_64915# 0 $ **FLOATING
C304 m3_20242_20050# a_106400_64915# 0 $ **FLOATING
C305 m3_20066_20050# a_106400_64915# 0 $ **FLOATING
C306 m3_20000_20050# a_106400_64915# 0 $ **FLOATING
C307 m3_22494_20226# a_106400_64915# 0 $ **FLOATING
C308 m3_22318_20226# a_106400_64915# 0 $ **FLOATING
C309 m3_22142_20226# a_106400_64915# 0 $ **FLOATING
C310 m3_22458_20402# a_106400_64915# 0 $ **FLOATING
C311 m3_22282_20402# a_106400_64915# 0 $ **FLOATING
C312 m3_22422_20578# a_106400_64915# 0 $ **FLOATING
C313 m3_22246_20578# a_106400_64915# 0 $ **FLOATING
C314 m3_21650_20270# a_106400_64915# 0 $ **FLOATING
C315 m3_21320_20270# a_106400_64915# 0 $ **FLOATING
C316 m3_21086_20226# a_106400_64915# 0 $ **FLOATING
C317 m3_20910_20226# a_106400_64915# 0 $ **FLOATING
C318 m3_20734_20226# a_106400_64915# 0 $ **FLOATING
C319 m3_21050_20402# a_106400_64915# 0 $ **FLOATING
C320 m3_20874_20402# a_106400_64915# 0 $ **FLOATING
C321 m3_21366_20578# a_106400_64915# 0 $ **FLOATING
C322 m3_21190_20578# a_106400_64915# 0 $ **FLOATING
C323 m3_21014_20578# a_106400_64915# 0 $ **FLOATING
C324 m3_20838_20578# a_106400_64915# 0 $ **FLOATING
C325 m3_20662_20578# a_106400_64915# 0 $ **FLOATING
C326 m3_20486_20578# a_106400_64915# 0 $ **FLOATING
C327 m3_20310_20578# a_106400_64915# 0 $ **FLOATING
C328 m3_20134_20578# a_106400_64915# 0 $ **FLOATING
C329 m3_20000_20578# a_106400_64915# 0 $ **FLOATING
C330 m3_22386_20754# a_106400_64915# 0 $ **FLOATING
C331 m3_22210_20754# a_106400_64915# 0 $ **FLOATING
C332 m3_22034_20754# a_106400_64915# 0 $ **FLOATING
C333 m3_21858_20754# a_106400_64915# 0 $ **FLOATING
C334 m3_21682_20754# a_106400_64915# 0 $ **FLOATING
C335 m3_22350_20930# a_106400_64915# 0 $ **FLOATING
C336 m3_22174_20930# a_106400_64915# 0 $ **FLOATING
C337 m3_21998_20930# a_106400_64915# 0 $ **FLOATING
C338 m3_21822_20930# a_106400_64915# 0 $ **FLOATING
C339 m3_21646_20930# a_106400_64915# 0 $ **FLOATING
C340 m3_21340_20790# a_106400_64915# 0 $ **FLOATING
C341 m3_21154_20754# a_106400_64915# 0 $ **FLOATING
C342 m3_20978_20754# a_106400_64915# 0 $ **FLOATING
C343 m3_20802_20754# a_106400_64915# 0 $ **FLOATING
C344 m3_20626_20754# a_106400_64915# 0 $ **FLOATING
C345 m3_20450_20754# a_106400_64915# 0 $ **FLOATING
C346 m3_20274_20754# a_106400_64915# 0 $ **FLOATING
C347 m3_20098_20754# a_106400_64915# 0 $ **FLOATING
C348 m3_20000_20754# a_106400_64915# 0 $ **FLOATING
C349 m3_20942_20930# a_106400_64915# 0 $ **FLOATING
C350 m3_20766_20930# a_106400_64915# 0 $ **FLOATING
C351 m3_20590_20930# a_106400_64915# 0 $ **FLOATING
C352 m3_20414_20930# a_106400_64915# 0 $ **FLOATING
C353 m3_20238_20930# a_106400_64915# 0 $ **FLOATING
C354 m3_20062_20930# a_106400_64915# 0 $ **FLOATING
C355 m3_22490_21106# a_106400_64915# 0 $ **FLOATING
C356 m3_22314_21106# a_106400_64915# 0 $ **FLOATING
C357 m3_22138_21106# a_106400_64915# 0 $ **FLOATING
C358 m3_21962_21106# a_106400_64915# 0 $ **FLOATING
C359 m3_21786_21106# a_106400_64915# 0 $ **FLOATING
C360 m3_21610_21106# a_106400_64915# 0 $ **FLOATING
C361 m3_21220_21050# a_106400_64915# 0 $ **FLOATING
C362 m3_20906_21106# a_106400_64915# 0 $ **FLOATING
C363 m3_20730_21106# a_106400_64915# 0 $ **FLOATING
C364 m3_20554_21106# a_106400_64915# 0 $ **FLOATING
C365 m3_20378_21106# a_106400_64915# 0 $ **FLOATING
C366 m3_20202_21106# a_106400_64915# 0 $ **FLOATING
C367 m3_20026_21106# a_106400_64915# 0 $ **FLOATING
C368 m3_22454_21282# a_106400_64915# 0 $ **FLOATING
C369 m3_22278_21282# a_106400_64915# 0 $ **FLOATING
C370 m3_22102_21282# a_106400_64915# 0 $ **FLOATING
C371 m3_21926_21282# a_106400_64915# 0 $ **FLOATING
C372 m3_21750_21282# a_106400_64915# 0 $ **FLOATING
C373 m3_22226_21536# a_106400_64915# 1.5996000000000004e-16
C374 m3_21890_21458# a_106400_64915# 0 $ **FLOATING
C375 m3_21714_21458# a_106400_64915# 0 $ **FLOATING
C376 m3_21360_21310# a_106400_64915# 0 $ **FLOATING
C377 m3_20870_21282# a_106400_64915# 0 $ **FLOATING
C378 m3_20694_21282# a_106400_64915# 0 $ **FLOATING
C379 m3_20518_21282# a_106400_64915# 0 $ **FLOATING
C380 m3_20342_21282# a_106400_64915# 0 $ **FLOATING
C381 m3_20166_21282# a_106400_64915# 0 $ **FLOATING
C382 m3_20000_21282# a_106400_64915# 0 $ **FLOATING
C383 m3_21854_21634# a_106400_64915# 0 $ **FLOATING
C384 m3_21678_21634# a_106400_64915# 0 $ **FLOATING
C385 m3_21502_21634# a_106400_64915# 0 $ **FLOATING
C386 m3_21240_21570# a_106400_64915# 0 $ **FLOATING
C387 m3_21010_21458# a_106400_64915# 0 $ **FLOATING
C388 m3_20834_21458# a_106400_64915# 0 $ **FLOATING
C389 m3_20658_21458# a_106400_64915# 0 $ **FLOATING
C390 m3_20482_21458# a_106400_64915# 0 $ **FLOATING
C391 m3_20306_21458# a_106400_64915# 0 $ **FLOATING
C392 m3_20130_21458# a_106400_64915# 0 $ **FLOATING
C393 m3_20000_21458# a_106400_64915# 0 $ **FLOATING
C394 m3_20974_21634# a_106400_64915# 0 $ **FLOATING
C395 m3_20798_21634# a_106400_64915# 0 $ **FLOATING
C396 m3_20000_21634# a_106400_64915# 0 $ **FLOATING
C397 m3_22346_21810# a_106400_64915# 0 $ **FLOATING
C398 m3_22170_21810# a_106400_64915# 0 $ **FLOATING
C399 m3_21994_21810# a_106400_64915# 0 $ **FLOATING
C400 m3_21818_21810# a_106400_64915# 0 $ **FLOATING
C401 m3_21642_21810# a_106400_64915# 0 $ **FLOATING
C402 m3_22486_21986# a_106400_64915# 0 $ **FLOATING
C403 m3_22310_21986# a_106400_64915# 0 $ **FLOATING
C404 m3_22134_21986# a_106400_64915# 0 $ **FLOATING
C405 m3_21958_21986# a_106400_64915# 0 $ **FLOATING
C406 m3_21782_21986# a_106400_64915# 0 $ **FLOATING
C407 m3_21380_21830# a_106400_64915# 0 $ **FLOATING
C408 m3_20938_21810# a_106400_64915# 0 $ **FLOATING
C409 m3_20762_21810# a_106400_64915# 0 $ **FLOATING
C410 m3_22450_22162# a_106400_64915# 0 $ **FLOATING
C411 m3_22274_22162# a_106400_64915# 0 $ **FLOATING
C412 m3_22098_22162# a_106400_64915# 0 $ **FLOATING
C413 m3_21922_22162# a_106400_64915# 0 $ **FLOATING
C414 m3_21746_22162# a_106400_64915# 0 $ **FLOATING
C415 m3_21570_22162# a_106400_64915# 0 $ **FLOATING
C416 m3_21260_22090# a_106400_64915# 0 $ **FLOATING
C417 m3_21078_21986# a_106400_64915# 0 $ **FLOATING
C418 m3_20902_21986# a_106400_64915# 0 $ **FLOATING
C419 m3_20726_21986# a_106400_64915# 0 $ **FLOATING
C420 m3_20550_21986# a_106400_64915# 0 $ **FLOATING
C421 m3_20374_21986# a_106400_64915# 0 $ **FLOATING
C422 m3_20198_21986# a_106400_64915# 0 $ **FLOATING
C423 m3_20022_21986# a_106400_64915# 0 $ **FLOATING
C424 m3_21042_22162# a_106400_64915# 0 $ **FLOATING
C425 m3_20866_22162# a_106400_64915# 0 $ **FLOATING
C426 m3_20690_22162# a_106400_64915# 0 $ **FLOATING
C427 m3_20514_22162# a_106400_64915# 0 $ **FLOATING
C428 m3_20338_22162# a_106400_64915# 0 $ **FLOATING
C429 m3_20162_22162# a_106400_64915# 0 $ **FLOATING
C430 m3_20000_22162# a_106400_64915# 0 $ **FLOATING
C431 m3_22414_22338# a_106400_64915# 0 $ **FLOATING
C432 m3_22238_22338# a_106400_64915# 0 $ **FLOATING
C433 m3_21360_22390# a_106400_64915# 0 $ **FLOATING
C434 m3_21200_22390# a_106400_64915# 0 $ **FLOATING
C435 m3_21006_22338# a_106400_64915# 0 $ **FLOATING
C436 m3_20830_22338# a_106400_64915# 0 $ **FLOATING
C437 m3_20654_22338# a_106400_64915# 0 $ **FLOATING
C438 m3_20478_22338# a_106400_64915# 0 $ **FLOATING
C439 m3_20302_22338# a_106400_64915# 0 $ **FLOATING
C440 m3_20126_22338# a_106400_64915# 0 $ **FLOATING
C441 m3_20000_22338# a_106400_64915# 0 $ **FLOATING
C442 m3_109430_64510# a_106400_64915# 0 $ **FLOATING
C443 m3_108870_64510# a_106400_64915# 0 $ **FLOATING
C444 m3_108310_64510# a_106400_64915# 0 $ **FLOATING
C445 m3_107750_64510# a_106400_64915# 0 $ **FLOATING
C446 m3_107190_64510# a_106400_64915# 0 $ **FLOATING
C447 m3_106630_64510# a_106400_64915# 0 $ **FLOATING
C448 m3_106400_64510# a_106400_64915# 0 $ **FLOATING
C449 m3_109570_65070# a_106400_64915# 0 $ **FLOATING
C450 m3_109010_65070# a_106400_64915# 0 $ **FLOATING
C451 m3_108450_65070# a_106400_64915# 0 $ **FLOATING
C452 m3_107890_65070# a_106400_64915# 0 $ **FLOATING
C453 m3_107330_65070# a_106400_64915# 0 $ **FLOATING
C454 m3_106770_65070# a_106400_64915# 0 $ **FLOATING
C455 m3_106400_65070# a_106400_64915# 0 $ **FLOATING
C456 m3_109150_65630# a_106400_64915# 0 $ **FLOATING
C457 m3_108590_65630# a_106400_64915# 0 $ **FLOATING
C458 m3_108030_65630# a_106400_64915# 0 $ **FLOATING
C459 m3_107470_65630# a_106400_64915# 0 $ **FLOATING
C460 m3_106910_65630# a_106400_64915# 0 $ **FLOATING
C461 m3_106400_65630# a_106400_64915# 0 $ **FLOATING
C462 m3_109290_66190# a_106400_64915# 0 $ **FLOATING
C463 m3_108730_66190# a_106400_64915# 0 $ **FLOATING
C464 m3_108170_66190# a_106400_64915# 0 $ **FLOATING
C465 m3_107610_66190# a_106400_64915# 0 $ **FLOATING
C466 m3_107050_66190# a_106400_64915# 0 $ **FLOATING
C467 m3_106490_66190# a_106400_64915# 0 $ **FLOATING
C468 m3_109430_66750# a_106400_64915# 0 $ **FLOATING
C469 m3_108870_66750# a_106400_64915# 0 $ **FLOATING
C470 m3_108310_66750# a_106400_64915# 0 $ **FLOATING
C471 m3_107750_66750# a_106400_64915# 0 $ **FLOATING
C472 m3_107190_66750# a_106400_64915# 0 $ **FLOATING
C473 m3_106630_66750# a_106400_64915# 0 $ **FLOATING
C474 m3_106400_66750# a_106400_64915# 0 $ **FLOATING
C475 m3_109570_67310# a_106400_64915# 0 $ **FLOATING
C476 m3_109010_67310# a_106400_64915# 0 $ **FLOATING
C477 m3_108450_67310# a_106400_64915# 0 $ **FLOATING
C478 m3_107890_67310# a_106400_64915# 0 $ **FLOATING
C479 m3_107330_67310# a_106400_64915# 0 $ **FLOATING
C480 m3_106770_67310# a_106400_64915# 0 $ **FLOATING
C481 m3_106400_67310# a_106400_64915# 0 $ **FLOATING
C482 m2_22440_20240# a_106400_64915# 0 $ **FLOATING
C483 m2_22460_20340# a_106400_64915# 0 $ **FLOATING
C484 m2_22480_20440# a_106400_64915# 0 $ **FLOATING
C485 m2_22440_20740# a_106400_64915# 0 $ **FLOATING
C486 m2_22460_20840# a_106400_64915# 0 $ **FLOATING
C487 m2_22480_20940# a_106400_64915# 0 $ **FLOATING
C488 m2_22440_21240# a_106400_64915# 0 $ **FLOATING
C489 m2_22460_21340# a_106400_64915# 0 $ **FLOATING
C490 m2_22480_21440# a_106400_64915# 0 $ **FLOATING
C491 m2_22440_21740# a_106400_64915# 0 $ **FLOATING
C492 m2_22460_21840# a_106400_64915# 0 $ **FLOATING
C493 m2_22480_21940# a_106400_64915# 0 $ **FLOATING
C494 m2_22440_22240# a_106400_64915# 0 $ **FLOATING
C495 m2_22460_22340# a_106400_64915# 0 $ **FLOATING
C496 m2_22480_22440# a_106400_64915# 0 $ **FLOATING
C497 m2_22346_20000# a_106400_64915# 5.6525900000000012e-16
C498 m2_21896_20000# a_106400_64915# 0 $ **FLOATING
C499 m2_21880_20060# a_106400_64915# 0 $ **FLOATING
C500 m2_21864_20216# a_106400_64915# 0 $ **FLOATING
C501 m2_21848_20372# a_106400_64915# 0 $ **FLOATING
C502 m2_22000_20540# a_106400_64915# 0 $ **FLOATING
C503 m2_22020_20640# a_106400_64915# 0 $ **FLOATING
C504 m2_21832_20528# a_106400_64915# 0 $ **FLOATING
C505 m2_21816_20684# a_106400_64915# 0 $ **FLOATING
C506 m2_21960_20840# a_106400_64915# 0 $ **FLOATING
C507 m2_21860_20840# a_106400_64915# 0 $ **FLOATING
C508 m2_21980_20940# a_106400_64915# 0 $ **FLOATING
C509 m2_21880_20940# a_106400_64915# 0 $ **FLOATING
C510 m2_21780_20940# a_106400_64915# 0 $ **FLOATING
C511 m2_22000_21040# a_106400_64915# 0 $ **FLOATING
C512 m2_21900_21040# a_106400_64915# 0 $ **FLOATING
C513 m2_21800_21040# a_106400_64915# 0 $ **FLOATING
C514 m2_21924_21152# a_106400_64915# 0 $ **FLOATING
C515 m2_21820_21140# a_106400_64915# 0 $ **FLOATING
C516 m2_22160_21340# a_106400_64915# 0 $ **FLOATING
C517 m2_21908_21308# a_106400_64915# 0 $ **FLOATING
C518 m2_22048_21464# a_106400_64915# 0 $ **FLOATING
C519 m2_21892_21464# a_106400_64915# 0 $ **FLOATING
C520 m2_21780_21440# a_106400_64915# 0 $ **FLOATING
C521 m2_22220_21640# a_106400_64915# 0 $ **FLOATING
C522 m2_22032_21620# a_106400_64915# 0 $ **FLOATING
C523 m2_21876_21620# a_106400_64915# 0 $ **FLOATING
C524 m2_22016_21776# a_106400_64915# 0 $ **FLOATING
C525 m2_21860_21776# a_106400_64915# 0 $ **FLOATING
C526 m2_22180_21940# a_106400_64915# 0 $ **FLOATING
C527 m2_22200_22040# a_106400_64915# 0 $ **FLOATING
C528 m2_22000_21932# a_106400_64915# 0 $ **FLOATING
C529 m2_21844_21932# a_106400_64915# 0 $ **FLOATING
C530 m2_22220_22140# a_106400_64915# 0 $ **FLOATING
C531 m2_21984_22088# a_106400_64915# 0 $ **FLOATING
C532 m2_21828_22088# a_106400_64915# 0 $ **FLOATING
C533 m2_22124_22244# a_106400_64915# 0 $ **FLOATING
C534 m2_21968_22244# a_106400_64915# 0 $ **FLOATING
C535 m2_21812_22244# a_106400_64915# 0 $ **FLOATING
C536 m2_22108_22400# a_106400_64915# 0 $ **FLOATING
C537 m2_21952_22400# a_106400_64915# 0 $ **FLOATING
C538 m2_21780_22440# a_106400_64915# 0 $ **FLOATING
C539 m2_21674_20000# a_106400_64915# 1.9860200000000002e-16
C540 m2_21482_20000# a_106400_64915# 3.5299200000000008e-16
C541 m2_21256_20060# a_106400_64915# 0 $ **FLOATING
C542 m2_20804_20000# a_106400_64915# 0 $ **FLOATING
C543 m2_20648_20000# a_106400_64915# 0 $ **FLOATING
C544 m2_20492_20000# a_106400_64915# 0 $ **FLOATING
C545 m2_20336_20000# a_106400_64915# 0 $ **FLOATING
C546 m2_20180_20000# a_106400_64915# 0 $ **FLOATING
C547 m2_20024_20000# a_106400_64915# 0 $ **FLOATING
C548 m2_20788_20060# a_106400_64915# 0 $ **FLOATING
C549 m2_20632_20060# a_106400_64915# 0 $ **FLOATING
C550 m2_20476_20060# a_106400_64915# 0 $ **FLOATING
C551 m2_20320_20060# a_106400_64915# 0 $ **FLOATING
C552 m2_20164_20060# a_106400_64915# 0 $ **FLOATING
C553 m2_20008_20060# a_106400_64915# 0 $ **FLOATING
C554 m2_21240_20216# a_106400_64915# 0 $ **FLOATING
C555 m2_20940_20240# a_106400_64915# 0 $ **FLOATING
C556 m2_20772_20216# a_106400_64915# 0 $ **FLOATING
C557 m2_20000_20216# a_106400_64915# 0 $ **FLOATING
C558 m2_21224_20372# a_106400_64915# 0 $ **FLOATING
C559 m2_21068_20372# a_106400_64915# 0 $ **FLOATING
C560 m2_20912_20372# a_106400_64915# 0 $ **FLOATING
C561 m2_20756_20372# a_106400_64915# 0 $ **FLOATING
C562 m2_20000_20372# a_106400_64915# 0 $ **FLOATING
C563 m2_21208_20528# a_106400_64915# 0 $ **FLOATING
C564 m2_21052_20528# a_106400_64915# 0 $ **FLOATING
C565 m2_20896_20528# a_106400_64915# 0 $ **FLOATING
C566 m2_20740_20528# a_106400_64915# 0 $ **FLOATING
C567 m2_20584_20528# a_106400_64915# 0 $ **FLOATING
C568 m2_20428_20528# a_106400_64915# 0 $ **FLOATING
C569 m2_20272_20528# a_106400_64915# 0 $ **FLOATING
C570 m2_20116_20528# a_106400_64915# 0 $ **FLOATING
C571 m2_20000_20528# a_106400_64915# 0 $ **FLOATING
C572 m2_21192_20684# a_106400_64915# 0 $ **FLOATING
C573 m2_21036_20684# a_106400_64915# 0 $ **FLOATING
C574 m2_20880_20684# a_106400_64915# 0 $ **FLOATING
C575 m2_20724_20684# a_106400_64915# 0 $ **FLOATING
C576 m2_20568_20684# a_106400_64915# 0 $ **FLOATING
C577 m2_20412_20684# a_106400_64915# 0 $ **FLOATING
C578 m2_20256_20684# a_106400_64915# 0 $ **FLOATING
C579 m2_20100_20684# a_106400_64915# 0 $ **FLOATING
C580 m2_20000_20684# a_106400_64915# 0 $ **FLOATING
C581 m2_21360_20840# a_106400_64915# 0 $ **FLOATING
C582 m2_21176_20840# a_106400_64915# 0 $ **FLOATING
C583 m2_21020_20840# a_106400_64915# 0 $ **FLOATING
C584 m2_20864_20840# a_106400_64915# 0 $ **FLOATING
C585 m2_20708_20840# a_106400_64915# 0 $ **FLOATING
C586 m2_20552_20840# a_106400_64915# 0 $ **FLOATING
C587 m2_20396_20840# a_106400_64915# 0 $ **FLOATING
C588 m2_20240_20840# a_106400_64915# 0 $ **FLOATING
C589 m2_20084_20840# a_106400_64915# 0 $ **FLOATING
C590 m2_20000_20840# a_106400_64915# 0 $ **FLOATING
C591 m2_21160_20996# a_106400_64915# 0 $ **FLOATING
C592 m2_21004_20996# a_106400_64915# 0 $ **FLOATING
C593 m2_20848_20996# a_106400_64915# 0 $ **FLOATING
C594 m2_20692_20996# a_106400_64915# 0 $ **FLOATING
C595 m2_20536_20996# a_106400_64915# 0 $ **FLOATING
C596 m2_20380_20996# a_106400_64915# 0 $ **FLOATING
C597 m2_20224_20996# a_106400_64915# 0 $ **FLOATING
C598 m2_20068_20996# a_106400_64915# 0 $ **FLOATING
C599 m2_20000_20996# a_106400_64915# 0 $ **FLOATING
C600 m2_21320_21140# a_106400_64915# 0 $ **FLOATING
C601 m2_21340_21240# a_106400_64915# 0 $ **FLOATING
C602 m2_21144_21152# a_106400_64915# 0 $ **FLOATING
C603 m2_20988_21152# a_106400_64915# 0 $ **FLOATING
C604 m2_20832_21152# a_106400_64915# 0 $ **FLOATING
C605 m2_20676_21152# a_106400_64915# 0 $ **FLOATING
C606 m2_20520_21152# a_106400_64915# 0 $ **FLOATING
C607 m2_20364_21152# a_106400_64915# 0 $ **FLOATING
C608 m2_20208_21152# a_106400_64915# 0 $ **FLOATING
C609 m2_20052_21152# a_106400_64915# 0 $ **FLOATING
C610 m2_21360_21340# a_106400_64915# 0 $ **FLOATING
C611 m2_21128_21308# a_106400_64915# 0 $ **FLOATING
C612 m2_20972_21308# a_106400_64915# 0 $ **FLOATING
C613 m2_20816_21308# a_106400_64915# 0 $ **FLOATING
C614 m2_20660_21308# a_106400_64915# 0 $ **FLOATING
C615 m2_20504_21308# a_106400_64915# 0 $ **FLOATING
C616 m2_20348_21308# a_106400_64915# 0 $ **FLOATING
C617 m2_20192_21308# a_106400_64915# 0 $ **FLOATING
C618 m2_20036_21308# a_106400_64915# 0 $ **FLOATING
C619 m2_21112_21464# a_106400_64915# 0 $ **FLOATING
C620 m2_20956_21464# a_106400_64915# 0 $ **FLOATING
C621 m2_20800_21464# a_106400_64915# 0 $ **FLOATING
C622 m2_20644_21464# a_106400_64915# 0 $ **FLOATING
C623 m2_20488_21464# a_106400_64915# 0 $ **FLOATING
C624 m2_20332_21464# a_106400_64915# 0 $ **FLOATING
C625 m2_20176_21464# a_106400_64915# 0 $ **FLOATING
C626 m2_20020_21464# a_106400_64915# 0 $ **FLOATING
C627 m2_21252_21620# a_106400_64915# 0 $ **FLOATING
C628 m2_21096_21620# a_106400_64915# 0 $ **FLOATING
C629 m2_20940_21620# a_106400_64915# 0 $ **FLOATING
C630 m2_20784_21620# a_106400_64915# 0 $ **FLOATING
C631 m2_20004_21620# a_106400_64915# 0 $ **FLOATING
C632 m2_21236_21776# a_106400_64915# 0 $ **FLOATING
C633 m2_21080_21776# a_106400_64915# 0 $ **FLOATING
C634 m2_20924_21776# a_106400_64915# 0 $ **FLOATING
C635 m2_20768_21776# a_106400_64915# 0 $ **FLOATING
C636 m2_20000_21776# a_106400_64915# 0 $ **FLOATING
C637 m2_21220_21932# a_106400_64915# 0 $ **FLOATING
C638 m2_21064_21932# a_106400_64915# 0 $ **FLOATING
C639 m2_20908_21932# a_106400_64915# 0 $ **FLOATING
C640 m2_20752_21932# a_106400_64915# 0 $ **FLOATING
C641 m2_20596_21932# a_106400_64915# 0 $ **FLOATING
C642 m2_20440_21932# a_106400_64915# 0 $ **FLOATING
C643 m2_20284_21932# a_106400_64915# 0 $ **FLOATING
C644 m2_20128_21932# a_106400_64915# 0 $ **FLOATING
C645 m2_20000_21932# a_106400_64915# 0 $ **FLOATING
C646 m2_21204_22088# a_106400_64915# 0 $ **FLOATING
C647 m2_21048_22088# a_106400_64915# 0 $ **FLOATING
C648 m2_20892_22088# a_106400_64915# 0 $ **FLOATING
C649 m2_20736_22088# a_106400_64915# 0 $ **FLOATING
C650 m2_20580_22088# a_106400_64915# 0 $ **FLOATING
C651 m2_20424_22088# a_106400_64915# 0 $ **FLOATING
C652 m2_20268_22088# a_106400_64915# 0 $ **FLOATING
C653 m2_20112_22088# a_106400_64915# 0 $ **FLOATING
C654 m2_20000_22088# a_106400_64915# 0 $ **FLOATING
C655 m2_21360_22340# a_106400_64915# 0 $ **FLOATING
C656 m2_21188_22244# a_106400_64915# 0 $ **FLOATING
C657 m2_21032_22244# a_106400_64915# 0 $ **FLOATING
C658 m2_20876_22244# a_106400_64915# 0 $ **FLOATING
C659 m2_20720_22244# a_106400_64915# 0 $ **FLOATING
C660 m2_20564_22244# a_106400_64915# 0 $ **FLOATING
C661 m2_20408_22244# a_106400_64915# 0 $ **FLOATING
C662 m2_20252_22244# a_106400_64915# 0 $ **FLOATING
C663 m2_20096_22244# a_106400_64915# 0 $ **FLOATING
C664 m2_20000_22244# a_106400_64915# 0 $ **FLOATING
C665 m2_21172_22400# a_106400_64915# 0 $ **FLOATING
C666 m2_21016_22400# a_106400_64915# 0 $ **FLOATING
C667 m2_20860_22400# a_106400_64915# 0 $ **FLOATING
C668 m2_20704_22400# a_106400_64915# 0 $ **FLOATING
C669 m2_20548_22400# a_106400_64915# 0 $ **FLOATING
C670 m2_20392_22400# a_106400_64915# 0 $ **FLOATING
C671 m2_20236_22400# a_106400_64915# 0 $ **FLOATING
C672 m2_20080_22400# a_106400_64915# 0 $ **FLOATING
C673 m2_20000_22400# a_106400_64915# 0 $ **FLOATING
C674 m2_107080_64440# a_106400_64915# 0 $ **FLOATING
C675 m2_109430_64510# a_106400_64915# 0 $ **FLOATING
C676 m2_109320_64640# a_106400_64915# 0 $ **FLOATING
C677 m2_108870_64510# a_106400_64915# 0 $ **FLOATING
C678 m2_108760_64840# a_106400_64915# 0 $ **FLOATING
C679 m2_108310_64510# a_106400_64915# 0 $ **FLOATING
C680 m2_108200_64540# a_106400_64915# 0 $ **FLOATING
C681 m2_107750_64510# a_106400_64915# 0 $ **FLOATING
C682 m2_107640_64740# a_106400_64915# 0 $ **FLOATING
C683 m2_107190_64510# a_106400_64915# 0 $ **FLOATING
C684 m2_106630_64510# a_106400_64915# 0 $ **FLOATING
C685 m2_106520_64640# a_106400_64915# 0 $ **FLOATING
C686 m2_106400_64510# a_106400_64915# 0 $ **FLOATING
C687 m2_107080_64940# a_106400_64915# 0 $ **FLOATING
C688 m2_109570_65070# a_106400_64915# 0 $ **FLOATING
C689 m2_109460_65340# a_106400_64915# 0 $ **FLOATING
C690 m2_109010_65070# a_106400_64915# 0 $ **FLOATING
C691 m2_108900_65040# a_106400_64915# 0 $ **FLOATING
C692 m2_108450_65070# a_106400_64915# 0 $ **FLOATING
C693 m2_108340_65240# a_106400_64915# 0 $ **FLOATING
C694 m2_107890_65070# a_106400_64915# 0 $ **FLOATING
C695 m2_107780_65440# a_106400_64915# 0 $ **FLOATING
C696 m2_107330_65070# a_106400_64915# 0 $ **FLOATING
C697 m2_107220_65140# a_106400_64915# 0 $ **FLOATING
C698 m2_106770_65070# a_106400_64915# 0 $ **FLOATING
C699 m2_106660_65340# a_106400_64915# 0 $ **FLOATING
C700 m2_106400_65070# a_106400_64915# 0 $ **FLOATING
C701 m2_109600_65540# a_106400_64915# 0 $ **FLOATING
C702 m2_106800_65540# a_106400_64915# 0 $ **FLOATING
C703 m2_109150_65630# a_106400_64915# 0 $ **FLOATING
C704 m2_109040_65740# a_106400_64915# 0 $ **FLOATING
C705 m2_108590_65630# a_106400_64915# 0 $ **FLOATING
C706 m2_108480_65940# a_106400_64915# 0 $ **FLOATING
C707 m2_108030_65630# a_106400_64915# 0 $ **FLOATING
C708 m2_107920_65640# a_106400_64915# 0 $ **FLOATING
C709 m2_107470_65630# a_106400_64915# 0 $ **FLOATING
C710 m2_107360_65840# a_106400_64915# 0 $ **FLOATING
C711 m2_106910_65630# a_106400_64915# 0 $ **FLOATING
C712 m2_106400_65630# a_106400_64915# 0 $ **FLOATING
C713 m2_109600_66040# a_106400_64915# 0 $ **FLOATING
C714 m2_106800_66040# a_106400_64915# 0 $ **FLOATING
C715 m2_109290_66190# a_106400_64915# 0 $ **FLOATING
C716 m2_109180_66440# a_106400_64915# 0 $ **FLOATING
C717 m2_108730_66190# a_106400_64915# 0 $ **FLOATING
C718 m2_108620_66140# a_106400_64915# 0 $ **FLOATING
C719 m2_108170_66190# a_106400_64915# 0 $ **FLOATING
C720 m2_108060_66340# a_106400_64915# 0 $ **FLOATING
C721 m2_107610_66190# a_106400_64915# 0 $ **FLOATING
C722 m2_107500_66540# a_106400_64915# 0 $ **FLOATING
C723 m2_107050_66190# a_106400_64915# 0 $ **FLOATING
C724 m2_106940_66240# a_106400_64915# 0 $ **FLOATING
C725 m2_106490_66190# a_106400_64915# 0 $ **FLOATING
C726 m2_106400_66440# a_106400_64915# 0 $ **FLOATING
C727 m2_109620_66640# a_106400_64915# 0 $ **FLOATING
C728 m2_109520_66640# a_106400_64915# 0 $ **FLOATING
C729 m2_109420_66640# a_106400_64915# 0 $ **FLOATING
C730 m2_109320_66640# a_106400_64915# 0 $ **FLOATING
C731 m2_109220_66640# a_106400_64915# 0 $ **FLOATING
C732 m2_109120_66640# a_106400_64915# 0 $ **FLOATING
C733 m2_109020_66640# a_106400_64915# 0 $ **FLOATING
C734 m2_108920_66640# a_106400_64915# 0 $ **FLOATING
C735 m2_108820_66640# a_106400_64915# 0 $ **FLOATING
C736 m2_108720_66640# a_106400_64915# 0 $ **FLOATING
C737 m2_108620_66640# a_106400_64915# 0 $ **FLOATING
C738 m2_108520_66640# a_106400_64915# 0 $ **FLOATING
C739 m2_108420_66640# a_106400_64915# 0 $ **FLOATING
C740 m2_108320_66640# a_106400_64915# 0 $ **FLOATING
C741 m2_108220_66640# a_106400_64915# 0 $ **FLOATING
C742 m2_108120_66640# a_106400_64915# 0 $ **FLOATING
C743 m2_108020_66640# a_106400_64915# 0 $ **FLOATING
C744 m2_107920_66640# a_106400_64915# 0 $ **FLOATING
C745 m2_107820_66640# a_106400_64915# 0 $ **FLOATING
C746 m2_107720_66640# a_106400_64915# 0 $ **FLOATING
C747 m2_107620_66640# a_106400_64915# 0 $ **FLOATING
C748 m2_107520_66640# a_106400_64915# 0 $ **FLOATING
C749 m2_107420_66640# a_106400_64915# 0 $ **FLOATING
C750 m2_107320_66640# a_106400_64915# 0 $ **FLOATING
C751 m2_107220_66640# a_106400_64915# 0 $ **FLOATING
C752 m2_107120_66640# a_106400_64915# 0 $ **FLOATING
C753 m2_107020_66640# a_106400_64915# 0 $ **FLOATING
C754 m2_106920_66640# a_106400_64915# 0 $ **FLOATING
C755 m2_106820_66640# a_106400_64915# 0 $ **FLOATING
C756 m2_106720_66640# a_106400_64915# 0 $ **FLOATING
C757 m2_106620_66640# a_106400_64915# 0 $ **FLOATING
C758 m2_106520_66640# a_106400_64915# 0 $ **FLOATING
C759 m2_106420_66640# a_106400_64915# 0 $ **FLOATING
C760 m2_109430_66750# a_106400_64915# 0 $ **FLOATING
C761 m2_109320_67140# a_106400_64915# 0 $ **FLOATING
C762 m2_108870_66750# a_106400_64915# 0 $ **FLOATING
C763 m2_108760_66840# a_106400_64915# 0 $ **FLOATING
C764 m2_108310_66750# a_106400_64915# 0 $ **FLOATING
C765 m2_108200_67040# a_106400_64915# 0 $ **FLOATING
C766 m2_107750_66750# a_106400_64915# 0 $ **FLOATING
C767 m2_107640_66740# a_106400_64915# 0 $ **FLOATING
C768 m2_107190_66750# a_106400_64915# 0 $ **FLOATING
C769 m2_107080_66940# a_106400_64915# 0 $ **FLOATING
C770 m2_106630_66750# a_106400_64915# 0 $ **FLOATING
C771 m2_106520_67140# a_106400_64915# 0 $ **FLOATING
C772 m2_106400_66750# a_106400_64915# 0 $ **FLOATING
C773 m2_108340_67240# a_106400_64915# 0 $ **FLOATING
C774 m2_109570_67310# a_106400_64915# 0 $ **FLOATING
C775 m2_109460_67340# a_106400_64915# 0 $ **FLOATING
C776 m2_109010_67310# a_106400_64915# 0 $ **FLOATING
C777 m2_108900_67540# a_106400_64915# 0 $ **FLOATING
C778 m2_108450_67310# a_106400_64915# 0 $ **FLOATING
C779 m2_107890_67310# a_106400_64915# 0 $ **FLOATING
C780 m2_107780_67440# a_106400_64915# 0 $ **FLOATING
C781 m2_107330_67310# a_106400_64915# 0 $ **FLOATING
C782 m2_106770_67310# a_106400_64915# 0 $ **FLOATING
C783 m2_106660_67340# a_106400_64915# 0 $ **FLOATING
C784 m2_106400_67310# a_106400_64915# 0 $ **FLOATING
C785 m1_20890_20030# a_106400_64915# 0 $ **FLOATING
C786 m1_20718_20000# a_106400_64915# 0 $ **FLOATING
C787 m1_20562_20000# a_106400_64915# 0 $ **FLOATING
C788 m1_20406_20000# a_106400_64915# 0 $ **FLOATING
C789 m1_20250_20000# a_106400_64915# 0 $ **FLOATING
C790 m1_20094_20000# a_106400_64915# 0 $ **FLOATING
C791 m1_20000_20000# a_106400_64915# 0 $ **FLOATING
C792 m1_21080_20136# a_106400_64915# 3.7989600000000005e-16
C793 m1_20000_20222# a_106400_64915# 3.5300800000000001e-16
C794 m1_20050_20330# a_106400_64915# 0 $ **FLOATING
C795 m1_20000_20330# a_106400_64915# 0 $ **FLOATING
C796 m1_20070_20430# a_106400_64915# 0 $ **FLOATING
C797 m1_20000_20458# a_106400_64915# 0 $ **FLOATING
C798 m1_22370_20614# a_106400_64915# 0 $ **FLOATING
C799 m1_22214_20614# a_106400_64915# 0 $ **FLOATING
C800 m1_22058_20614# a_106400_64915# 0 $ **FLOATING
C801 m1_21902_20614# a_106400_64915# 0 $ **FLOATING
C802 m1_21746_20614# a_106400_64915# 0 $ **FLOATING
C803 m1_21590_20614# a_106400_64915# 0 $ **FLOATING
C804 m1_21434_20614# a_106400_64915# 0 $ **FLOATING
C805 m1_21278_20614# a_106400_64915# 0 $ **FLOATING
C806 m1_21122_20614# a_106400_64915# 0 $ **FLOATING
C807 m1_20966_20614# a_106400_64915# 0 $ **FLOATING
C808 m1_20810_20614# a_106400_64915# 0 $ **FLOATING
C809 m1_20654_20614# a_106400_64915# 0 $ **FLOATING
C810 m1_20498_20614# a_106400_64915# 0 $ **FLOATING
C811 m1_20342_20614# a_106400_64915# 0 $ **FLOATING
C812 m1_20186_20614# a_106400_64915# 0 $ **FLOATING
C813 m1_20030_20614# a_106400_64915# 0 $ **FLOATING
C814 m1_22354_20770# a_106400_64915# 0 $ **FLOATING
C815 m1_22198_20770# a_106400_64915# 0 $ **FLOATING
C816 m1_22042_20770# a_106400_64915# 0 $ **FLOATING
C817 m1_21886_20770# a_106400_64915# 0 $ **FLOATING
C818 m1_21730_20770# a_106400_64915# 0 $ **FLOATING
C819 m1_21574_20770# a_106400_64915# 0 $ **FLOATING
C820 m1_21418_20770# a_106400_64915# 0 $ **FLOATING
C821 m1_21262_20770# a_106400_64915# 0 $ **FLOATING
C822 m1_21106_20770# a_106400_64915# 0 $ **FLOATING
C823 m1_20950_20770# a_106400_64915# 0 $ **FLOATING
C824 m1_20794_20770# a_106400_64915# 0 $ **FLOATING
C825 m1_20638_20770# a_106400_64915# 0 $ **FLOATING
C826 m1_20482_20770# a_106400_64915# 0 $ **FLOATING
C827 m1_20326_20770# a_106400_64915# 0 $ **FLOATING
C828 m1_20170_20770# a_106400_64915# 0 $ **FLOATING
C829 m1_20014_20770# a_106400_64915# 0 $ **FLOATING
C830 m1_22136_21172# a_106400_64915# 1.31212e-16
C831 m1_21838_21238# a_106400_64915# 0 $ **FLOATING
C832 m1_21682_21238# a_106400_64915# 0 $ **FLOATING
C833 m1_21526_21238# a_106400_64915# 0 $ **FLOATING
C834 m1_21370_21238# a_106400_64915# 0 $ **FLOATING
C835 m1_21214_21238# a_106400_64915# 0 $ **FLOATING
C836 m1_21058_21238# a_106400_64915# 0 $ **FLOATING
C837 m1_20902_21238# a_106400_64915# 0 $ **FLOATING
C838 m1_20746_21238# a_106400_64915# 0 $ **FLOATING
C839 m1_20590_21238# a_106400_64915# 0 $ **FLOATING
C840 m1_20434_21238# a_106400_64915# 0 $ **FLOATING
C841 m1_20278_21238# a_106400_64915# 0 $ **FLOATING
C842 m1_20122_21238# a_106400_64915# 0 $ **FLOATING
C843 m1_20000_21238# a_106400_64915# 0 $ **FLOATING
C844 m1_22446_21394# a_106400_64915# 0 $ **FLOATING
C845 m1_22290_21394# a_106400_64915# 0 $ **FLOATING
C846 m1_22134_21394# a_106400_64915# 0 $ **FLOATING
C847 m1_21978_21394# a_106400_64915# 0 $ **FLOATING
C848 m1_21822_21394# a_106400_64915# 0 $ **FLOATING
C849 m1_21666_21394# a_106400_64915# 0 $ **FLOATING
C850 m1_21510_21394# a_106400_64915# 0 $ **FLOATING
C851 m1_21354_21394# a_106400_64915# 0 $ **FLOATING
C852 m1_21198_21394# a_106400_64915# 0 $ **FLOATING
C853 m1_21042_21394# a_106400_64915# 0 $ **FLOATING
C854 m1_20886_21394# a_106400_64915# 0 $ **FLOATING
C855 m1_20730_21394# a_106400_64915# 0 $ **FLOATING
C856 m1_20574_21394# a_106400_64915# 0 $ **FLOATING
C857 m1_20418_21394# a_106400_64915# 0 $ **FLOATING
C858 m1_20262_21394# a_106400_64915# 0 $ **FLOATING
C859 m1_20106_21394# a_106400_64915# 0 $ **FLOATING
C860 m1_20000_21394# a_106400_64915# 0 $ **FLOATING
C861 m1_20000_21550# a_106400_64915# 0 $ **FLOATING
C862 m1_20000_21706# a_106400_64915# 0 $ **FLOATING
C863 m1_22450_21830# a_106400_64915# 0 $ **FLOATING
C864 m1_22350_21830# a_106400_64915# 0 $ **FLOATING
C865 m1_22250_21830# a_106400_64915# 0 $ **FLOATING
C866 m1_22150_21830# a_106400_64915# 0 $ **FLOATING
C867 m1_22050_21830# a_106400_64915# 0 $ **FLOATING
C868 m1_21950_21830# a_106400_64915# 0 $ **FLOATING
C869 m1_21850_21830# a_106400_64915# 0 $ **FLOATING
C870 m1_21750_21830# a_106400_64915# 0 $ **FLOATING
C871 m1_21650_21830# a_106400_64915# 0 $ **FLOATING
C872 m1_21550_21830# a_106400_64915# 0 $ **FLOATING
C873 m1_21450_21830# a_106400_64915# 0 $ **FLOATING
C874 m1_21350_21830# a_106400_64915# 0 $ **FLOATING
C875 m1_21250_21830# a_106400_64915# 0 $ **FLOATING
C876 m1_21150_21830# a_106400_64915# 0 $ **FLOATING
C877 m1_21050_21830# a_106400_64915# 0 $ **FLOATING
C878 m1_20950_21830# a_106400_64915# 0 $ **FLOATING
C879 m1_20850_21830# a_106400_64915# 0 $ **FLOATING
C880 m1_20750_21830# a_106400_64915# 0 $ **FLOATING
C881 m1_20650_21830# a_106400_64915# 0 $ **FLOATING
C882 m1_20550_21830# a_106400_64915# 0 $ **FLOATING
C883 m1_20450_21830# a_106400_64915# 0 $ **FLOATING
C884 m1_20350_21830# a_106400_64915# 0 $ **FLOATING
C885 m1_20250_21830# a_106400_64915# 0 $ **FLOATING
C886 m1_20150_21830# a_106400_64915# 0 $ **FLOATING
C887 m1_20000_21862# a_106400_64915# 0 $ **FLOATING
C888 m1_22382_22018# a_106400_64915# 0 $ **FLOATING
C889 m1_22226_22018# a_106400_64915# 0 $ **FLOATING
C890 m1_22070_22018# a_106400_64915# 0 $ **FLOATING
C891 m1_21914_22018# a_106400_64915# 0 $ **FLOATING
C892 m1_21758_22018# a_106400_64915# 0 $ **FLOATING
C893 m1_21602_22018# a_106400_64915# 0 $ **FLOATING
C894 m1_21446_22018# a_106400_64915# 0 $ **FLOATING
C895 m1_21290_22018# a_106400_64915# 0 $ **FLOATING
C896 m1_21134_22018# a_106400_64915# 0 $ **FLOATING
C897 m1_20978_22018# a_106400_64915# 0 $ **FLOATING
C898 m1_20822_22018# a_106400_64915# 0 $ **FLOATING
C899 m1_20666_22018# a_106400_64915# 0 $ **FLOATING
C900 m1_20510_22018# a_106400_64915# 0 $ **FLOATING
C901 m1_20354_22018# a_106400_64915# 0 $ **FLOATING
C902 m1_20198_22018# a_106400_64915# 0 $ **FLOATING
C903 m1_20042_22018# a_106400_64915# 0 $ **FLOATING
C904 m1_20000_22018# a_106400_64915# 0 $ **FLOATING
C905 m1_109570_64762# a_106400_64915# 0 $ **FLOATING
C906 m1_109414_64762# a_106400_64915# 0 $ **FLOATING
C907 m1_109258_64762# a_106400_64915# 0 $ **FLOATING
C908 m1_109102_64762# a_106400_64915# 0 $ **FLOATING
C909 m1_108946_64762# a_106400_64915# 0 $ **FLOATING
C910 m1_108790_64762# a_106400_64915# 0 $ **FLOATING
C911 m1_108634_64762# a_106400_64915# 0 $ **FLOATING
C912 m1_108478_64762# a_106400_64915# 0 $ **FLOATING
C913 m1_108322_64762# a_106400_64915# 0 $ **FLOATING
C914 m1_108166_64762# a_106400_64915# 0 $ **FLOATING
C915 m1_108010_64762# a_106400_64915# 0 $ **FLOATING
C916 m1_107854_64762# a_106400_64915# 0 $ **FLOATING
C917 m1_107698_64762# a_106400_64915# 0 $ **FLOATING
C918 m1_107542_64762# a_106400_64915# 0 $ **FLOATING
C919 m1_107386_64762# a_106400_64915# 0 $ **FLOATING
C920 m1_107230_64762# a_106400_64915# 0 $ **FLOATING
C921 m1_107074_64762# a_106400_64915# 0 $ **FLOATING
C922 m1_106918_64762# a_106400_64915# 0 $ **FLOATING
C923 m1_106762_64762# a_106400_64915# 0 $ **FLOATING
C924 m1_106606_64762# a_106400_64915# 0 $ **FLOATING
C925 m1_106450_64762# a_106400_64915# 0 $ **FLOATING
C926 m1_106400_64762# a_106400_64915# 0 $ **FLOATING
C927 m1_109678_65230# a_106400_64915# 0 $ **FLOATING
C928 m1_109522_65230# a_106400_64915# 0 $ **FLOATING
C929 m1_109366_65230# a_106400_64915# 0 $ **FLOATING
C930 m1_109210_65230# a_106400_64915# 0 $ **FLOATING
C931 m1_109054_65230# a_106400_64915# 0 $ **FLOATING
C932 m1_108898_65230# a_106400_64915# 0 $ **FLOATING
C933 m1_108742_65230# a_106400_64915# 0 $ **FLOATING
C934 m1_108586_65230# a_106400_64915# 0 $ **FLOATING
C935 m1_108430_65230# a_106400_64915# 0 $ **FLOATING
C936 m1_108274_65230# a_106400_64915# 0 $ **FLOATING
C937 m1_108118_65230# a_106400_64915# 0 $ **FLOATING
C938 m1_107962_65230# a_106400_64915# 0 $ **FLOATING
C939 m1_107806_65230# a_106400_64915# 0 $ **FLOATING
C940 m1_107650_65230# a_106400_64915# 0 $ **FLOATING
C941 m1_107494_65230# a_106400_64915# 0 $ **FLOATING
C942 m1_107338_65230# a_106400_64915# 0 $ **FLOATING
C943 m1_107182_65230# a_106400_64915# 0 $ **FLOATING
C944 m1_107026_65230# a_106400_64915# 0 $ **FLOATING
C945 m1_106870_65230# a_106400_64915# 0 $ **FLOATING
C946 m1_106714_65230# a_106400_64915# 0 $ **FLOATING
C947 m1_106558_65230# a_106400_64915# 0 $ **FLOATING
C948 m1_106402_65230# a_106400_64915# 0 $ **FLOATING
C949 m1_109670_65430# a_106400_64915# 0 $ **FLOATING
C950 m1_109570_65430# a_106400_64915# 0 $ **FLOATING
C951 m1_109470_65430# a_106400_64915# 0 $ **FLOATING
C952 m1_109370_65430# a_106400_64915# 0 $ **FLOATING
C953 m1_109270_65430# a_106400_64915# 0 $ **FLOATING
C954 m1_109170_65430# a_106400_64915# 0 $ **FLOATING
C955 m1_109070_65430# a_106400_64915# 0 $ **FLOATING
C956 m1_108970_65430# a_106400_64915# 0 $ **FLOATING
C957 m1_108870_65430# a_106400_64915# 0 $ **FLOATING
C958 m1_108770_65430# a_106400_64915# 0 $ **FLOATING
C959 m1_108670_65430# a_106400_64915# 0 $ **FLOATING
C960 m1_108570_65430# a_106400_64915# 0 $ **FLOATING
C961 m1_108470_65430# a_106400_64915# 0 $ **FLOATING
C962 m1_108370_65430# a_106400_64915# 0 $ **FLOATING
C963 m1_108270_65430# a_106400_64915# 0 $ **FLOATING
C964 m1_108170_65430# a_106400_64915# 0 $ **FLOATING
C965 m1_108070_65430# a_106400_64915# 0 $ **FLOATING
C966 m1_107970_65430# a_106400_64915# 0 $ **FLOATING
C967 m1_107870_65430# a_106400_64915# 0 $ **FLOATING
C968 m1_107770_65430# a_106400_64915# 0 $ **FLOATING
C969 m1_107670_65430# a_106400_64915# 0 $ **FLOATING
C970 m1_107570_65430# a_106400_64915# 0 $ **FLOATING
C971 m1_107470_65430# a_106400_64915# 0 $ **FLOATING
C972 m1_107370_65430# a_106400_64915# 0 $ **FLOATING
C973 m1_107270_65430# a_106400_64915# 0 $ **FLOATING
C974 m1_107170_65430# a_106400_64915# 0 $ **FLOATING
C975 m1_107070_65430# a_106400_64915# 0 $ **FLOATING
C976 m1_106970_65430# a_106400_64915# 0 $ **FLOATING
C977 m1_106870_65430# a_106400_64915# 0 $ **FLOATING
C978 m1_106770_65430# a_106400_64915# 0 $ **FLOATING
C979 m1_106670_65430# a_106400_64915# 0 $ **FLOATING
C980 m1_106570_65430# a_106400_64915# 0 $ **FLOATING
C981 m1_106470_65430# a_106400_64915# 0 $ **FLOATING
C982 m1_106400_65430# a_106400_64915# 0 $ **FLOATING
C983 m1_109630_65730# a_106400_64915# 0 $ **FLOATING
C984 m1_109530_65730# a_106400_64915# 0 $ **FLOATING
C985 m1_109430_65730# a_106400_64915# 0 $ **FLOATING
C986 m1_109330_65730# a_106400_64915# 0 $ **FLOATING
C987 m1_109230_65730# a_106400_64915# 0 $ **FLOATING
C988 m1_109130_65730# a_106400_64915# 0 $ **FLOATING
C989 m1_109030_65730# a_106400_64915# 0 $ **FLOATING
C990 m1_108930_65730# a_106400_64915# 0 $ **FLOATING
C991 m1_108830_65730# a_106400_64915# 0 $ **FLOATING
C992 m1_108730_65730# a_106400_64915# 0 $ **FLOATING
C993 m1_108630_65730# a_106400_64915# 0 $ **FLOATING
C994 m1_108530_65730# a_106400_64915# 0 $ **FLOATING
C995 m1_108430_65730# a_106400_64915# 0 $ **FLOATING
C996 m1_108330_65730# a_106400_64915# 0 $ **FLOATING
C997 m1_108230_65730# a_106400_64915# 0 $ **FLOATING
C998 m1_108130_65730# a_106400_64915# 0 $ **FLOATING
C999 m1_108030_65730# a_106400_64915# 0 $ **FLOATING
C1000 m1_107930_65730# a_106400_64915# 0 $ **FLOATING
C1001 m1_107830_65730# a_106400_64915# 0 $ **FLOATING
C1002 m1_107730_65730# a_106400_64915# 0 $ **FLOATING
C1003 m1_107630_65730# a_106400_64915# 0 $ **FLOATING
C1004 m1_107530_65730# a_106400_64915# 0 $ **FLOATING
C1005 m1_107430_65730# a_106400_64915# 0 $ **FLOATING
C1006 m1_107330_65730# a_106400_64915# 0 $ **FLOATING
C1007 m1_107230_65730# a_106400_64915# 0 $ **FLOATING
C1008 m1_107130_65730# a_106400_64915# 0 $ **FLOATING
C1009 m1_107030_65730# a_106400_64915# 0 $ **FLOATING
C1010 m1_106930_65730# a_106400_64915# 0 $ **FLOATING
C1011 m1_106830_65730# a_106400_64915# 0 $ **FLOATING
C1012 m1_106730_65730# a_106400_64915# 0 $ **FLOATING
C1013 m1_106630_65730# a_106400_64915# 0 $ **FLOATING
C1014 m1_106530_65730# a_106400_64915# 0 $ **FLOATING
C1015 m1_106430_65730# a_106400_64915# 0 $ **FLOATING
C1016 m1_109614_65854# a_106400_64915# 0 $ **FLOATING
C1017 m1_109458_65854# a_106400_64915# 0 $ **FLOATING
C1018 m1_109302_65854# a_106400_64915# 0 $ **FLOATING
C1019 m1_109146_65854# a_106400_64915# 0 $ **FLOATING
C1020 m1_108990_65854# a_106400_64915# 0 $ **FLOATING
C1021 m1_108834_65854# a_106400_64915# 0 $ **FLOATING
C1022 m1_108678_65854# a_106400_64915# 0 $ **FLOATING
C1023 m1_108522_65854# a_106400_64915# 0 $ **FLOATING
C1024 m1_108366_65854# a_106400_64915# 0 $ **FLOATING
C1025 m1_108210_65854# a_106400_64915# 0 $ **FLOATING
C1026 m1_108054_65854# a_106400_64915# 0 $ **FLOATING
C1027 m1_107898_65854# a_106400_64915# 0 $ **FLOATING
C1028 m1_107742_65854# a_106400_64915# 0 $ **FLOATING
C1029 m1_107586_65854# a_106400_64915# 0 $ **FLOATING
C1030 m1_107430_65854# a_106400_64915# 0 $ **FLOATING
C1031 m1_107274_65854# a_106400_64915# 0 $ **FLOATING
C1032 m1_107118_65854# a_106400_64915# 0 $ **FLOATING
C1033 m1_106962_65854# a_106400_64915# 0 $ **FLOATING
C1034 m1_106806_65854# a_106400_64915# 0 $ **FLOATING
C1035 m1_106650_65854# a_106400_64915# 0 $ **FLOATING
C1036 m1_106494_65854# a_106400_64915# 0 $ **FLOATING
C1037 m1_106400_65854# a_106400_64915# 0 $ **FLOATING
C1038 m1_109566_66322# a_106400_64915# 0 $ **FLOATING
C1039 m1_109410_66322# a_106400_64915# 0 $ **FLOATING
C1040 m1_109254_66322# a_106400_64915# 0 $ **FLOATING
C1041 m1_109098_66322# a_106400_64915# 0 $ **FLOATING
C1042 m1_108942_66322# a_106400_64915# 0 $ **FLOATING
C1043 m1_108786_66322# a_106400_64915# 0 $ **FLOATING
C1044 m1_108630_66322# a_106400_64915# 0 $ **FLOATING
C1045 m1_108474_66322# a_106400_64915# 0 $ **FLOATING
C1046 m1_108318_66322# a_106400_64915# 0 $ **FLOATING
C1047 m1_108162_66322# a_106400_64915# 0 $ **FLOATING
C1048 m1_108006_66322# a_106400_64915# 0 $ **FLOATING
C1049 m1_107850_66322# a_106400_64915# 0 $ **FLOATING
C1050 m1_107694_66322# a_106400_64915# 0 $ **FLOATING
C1051 m1_107538_66322# a_106400_64915# 0 $ **FLOATING
C1052 m1_107382_66322# a_106400_64915# 0 $ **FLOATING
C1053 m1_107226_66322# a_106400_64915# 0 $ **FLOATING
C1054 m1_107070_66322# a_106400_64915# 0 $ **FLOATING
C1055 m1_106914_66322# a_106400_64915# 0 $ **FLOATING
C1056 m1_106758_66322# a_106400_64915# 0 $ **FLOATING
C1057 m1_106602_66322# a_106400_64915# 0 $ **FLOATING
C1058 m1_106446_66322# a_106400_64915# 0 $ **FLOATING
C1059 m1_106400_66322# a_106400_64915# 0 $ **FLOATING
C1060 m1_109550_66478# a_106400_64915# 0 $ **FLOATING
C1061 m1_109394_66478# a_106400_64915# 0 $ **FLOATING
C1062 m1_109238_66478# a_106400_64915# 0 $ **FLOATING
C1063 m1_109082_66478# a_106400_64915# 0 $ **FLOATING
C1064 m1_108926_66478# a_106400_64915# 0 $ **FLOATING
C1065 m1_108770_66478# a_106400_64915# 0 $ **FLOATING
C1066 m1_108614_66478# a_106400_64915# 0 $ **FLOATING
C1067 m1_108458_66478# a_106400_64915# 0 $ **FLOATING
C1068 m1_108302_66478# a_106400_64915# 0 $ **FLOATING
C1069 m1_108146_66478# a_106400_64915# 0 $ **FLOATING
C1070 m1_107990_66478# a_106400_64915# 0 $ **FLOATING
C1071 m1_107834_66478# a_106400_64915# 0 $ **FLOATING
C1072 m1_107678_66478# a_106400_64915# 0 $ **FLOATING
C1073 m1_107522_66478# a_106400_64915# 0 $ **FLOATING
C1074 m1_107366_66478# a_106400_64915# 0 $ **FLOATING
C1075 m1_107210_66478# a_106400_64915# 0 $ **FLOATING
C1076 m1_107054_66478# a_106400_64915# 0 $ **FLOATING
C1077 m1_106898_66478# a_106400_64915# 0 $ **FLOATING
C1078 m1_106742_66478# a_106400_64915# 0 $ **FLOATING
C1079 m1_106586_66478# a_106400_64915# 0 $ **FLOATING
C1080 m1_106430_66478# a_106400_64915# 0 $ **FLOATING
C1081 m1_109690_66634# a_106400_64915# 0 $ **FLOATING
C1082 m1_109534_66634# a_106400_64915# 0 $ **FLOATING
C1083 m1_109378_66634# a_106400_64915# 0 $ **FLOATING
C1084 m1_109222_66634# a_106400_64915# 0 $ **FLOATING
C1085 m1_109066_66634# a_106400_64915# 0 $ **FLOATING
C1086 m1_108910_66634# a_106400_64915# 0 $ **FLOATING
C1087 m1_108754_66634# a_106400_64915# 0 $ **FLOATING
C1088 m1_108598_66634# a_106400_64915# 0 $ **FLOATING
C1089 m1_108442_66634# a_106400_64915# 0 $ **FLOATING
C1090 m1_108286_66634# a_106400_64915# 0 $ **FLOATING
C1091 m1_108130_66634# a_106400_64915# 0 $ **FLOATING
C1092 m1_107974_66634# a_106400_64915# 0 $ **FLOATING
C1093 m1_107818_66634# a_106400_64915# 0 $ **FLOATING
C1094 m1_107662_66634# a_106400_64915# 0 $ **FLOATING
C1095 m1_107506_66634# a_106400_64915# 0 $ **FLOATING
C1096 m1_107350_66634# a_106400_64915# 0 $ **FLOATING
C1097 m1_107194_66634# a_106400_64915# 0 $ **FLOATING
C1098 m1_107038_66634# a_106400_64915# 0 $ **FLOATING
C1099 m1_106882_66634# a_106400_64915# 0 $ **FLOATING
C1100 m1_106726_66634# a_106400_64915# 0 $ **FLOATING
C1101 m1_106570_66634# a_106400_64915# 0 $ **FLOATING
C1102 m1_106414_66634# a_106400_64915# 0 $ **FLOATING
C1103 m1_109540_66820# a_106400_64915# 0 $ **FLOATING
C1104 m1_109300_66820# a_106400_64915# 0 $ **FLOATING
C1105 m1_109060_66820# a_106400_64915# 0 $ **FLOATING
C1106 m1_108820_66820# a_106400_64915# 0 $ **FLOATING
C1107 m1_108580_66820# a_106400_64915# 0 $ **FLOATING
C1108 m1_108340_66820# a_106400_64915# 0 $ **FLOATING
C1109 m1_108100_66820# a_106400_64915# 0 $ **FLOATING
C1110 m1_107860_66820# a_106400_64915# 0 $ **FLOATING
C1111 m1_107620_66820# a_106400_64915# 0 $ **FLOATING
C1112 m1_107380_66820# a_106400_64915# 0 $ **FLOATING
C1113 m1_107140_66820# a_106400_64915# 0 $ **FLOATING
C1114 m1_106900_66820# a_106400_64915# 0 $ **FLOATING
C1115 m1_106660_66820# a_106400_64915# 0 $ **FLOATING
C1116 m1_106420_66820# a_106400_64915# 0 $ **FLOATING
C1117 m1_109680_67060# a_106400_64915# 0 $ **FLOATING
C1118 m1_109440_67060# a_106400_64915# 0 $ **FLOATING
C1119 m1_109200_67060# a_106400_64915# 0 $ **FLOATING
C1120 m1_108960_67060# a_106400_64915# 0 $ **FLOATING
C1121 m1_108720_67060# a_106400_64915# 0 $ **FLOATING
C1122 m1_108480_67060# a_106400_64915# 0 $ **FLOATING
C1123 m1_108240_67060# a_106400_64915# 0 $ **FLOATING
C1124 m1_108000_67060# a_106400_64915# 0 $ **FLOATING
C1125 m1_107760_67060# a_106400_64915# 0 $ **FLOATING
C1126 m1_107520_67060# a_106400_64915# 0 $ **FLOATING
C1127 m1_107280_67060# a_106400_64915# 0 $ **FLOATING
C1128 m1_107040_67060# a_106400_64915# 0 $ **FLOATING
C1129 m1_106800_67060# a_106400_64915# 0 $ **FLOATING
C1130 m1_106560_67060# a_106400_64915# 0 $ **FLOATING
C1131 m1_106400_67060# a_106400_64915# 0 $ **FLOATING
C1132 m1_109570_67310# a_106400_64915# 0 $ **FLOATING
C1133 m1_109450_67330# a_106400_64915# 0 $ **FLOATING
C1134 m1_109470_67430# a_106400_64915# 0 $ **FLOATING
C1135 m1_109010_67310# a_106400_64915# 0 $ **FLOATING
C1136 m1_108890_67530# a_106400_64915# 0 $ **FLOATING
C1137 m1_108450_67310# a_106400_64915# 0 $ **FLOATING
C1138 m1_108350_67330# a_106400_64915# 0 $ **FLOATING
C1139 m1_107890_67310# a_106400_64915# 0 $ **FLOATING
C1140 m1_107770_67430# a_106400_64915# 0 $ **FLOATING
C1141 m1_107790_67530# a_106400_64915# 0 $ **FLOATING
C1142 m1_107330_67310# a_106400_64915# 0 $ **FLOATING
C1143 m1_106770_67310# a_106400_64915# 0 $ **FLOATING
C1144 m1_106650_67330# a_106400_64915# 0 $ **FLOATING
C1145 m1_106670_67430# a_106400_64915# 0 $ **FLOATING
C1146 m1_106400_67310# a_106400_64915# 0 $ **FLOATING
C1147 li_22458_20000# a_106400_64915# 0 $ **FLOATING
C1148 li_22242_20000# a_106400_64915# 0 $ **FLOATING
C1149 li_22026_20000# a_106400_64915# 0 $ **FLOATING
C1150 li_21810_20000# a_106400_64915# 0 $ **FLOATING
C1151 li_21594_20000# a_106400_64915# 0 $ **FLOATING
C1152 li_20730_20000# a_106400_64915# 0 $ **FLOATING
C1153 li_20514_20000# a_106400_64915# 0 $ **FLOATING
C1154 li_20298_20000# a_106400_64915# 0 $ **FLOATING
C1155 li_20654_20194# a_106400_64915# 0 $ **FLOATING
C1156 li_20438_20194# a_106400_64915# 0 $ **FLOATING
C1157 li_20794_20410# a_106400_64915# 0 $ **FLOATING
C1158 li_20578_20410# a_106400_64915# 0 $ **FLOATING
C1159 li_20362_20410# a_106400_64915# 0 $ **FLOATING
C1160 li_22446_20626# a_106400_64915# 0 $ **FLOATING
C1161 li_22230_20626# a_106400_64915# 0 $ **FLOATING
C1162 li_22014_20626# a_106400_64915# 0 $ **FLOATING
C1163 li_21798_20626# a_106400_64915# 0 $ **FLOATING
C1164 li_21582_20626# a_106400_64915# 0 $ **FLOATING
C1165 li_20718_20626# a_106400_64915# 0 $ **FLOATING
C1166 li_20502_20626# a_106400_64915# 0 $ **FLOATING
C1167 li_20000_20060# a_106400_64915# 0 $ **FLOATING
C1168 li_20642_20842# a_106400_64915# 0 $ **FLOATING
C1169 li_20426_20842# a_106400_64915# 0 $ **FLOATING
C1170 li_22434_21274# a_106400_64915# 0 $ **FLOATING
C1171 li_22218_21274# a_106400_64915# 0 $ **FLOATING
C1172 li_22002_21274# a_106400_64915# 0 $ **FLOATING
C1173 li_21786_21274# a_106400_64915# 0 $ **FLOATING
C1174 li_21570_21274# a_106400_64915# 0 $ **FLOATING
C1175 li_20782_21058# a_106400_64915# 0 $ **FLOATING
C1176 li_20566_21058# a_106400_64915# 0 $ **FLOATING
C1177 li_20706_21274# a_106400_64915# 0 $ **FLOATING
C1178 li_20490_21274# a_106400_64915# 0 $ **FLOATING
C1179 li_20000_20840# a_106400_64915# 0 $ **FLOATING
C1180 li_20630_21490# a_106400_64915# 0 $ **FLOATING
C1181 li_20414_21490# a_106400_64915# 0 $ **FLOATING
C1182 li_20770_21706# a_106400_64915# 0 $ **FLOATING
C1183 li_20554_21706# a_106400_64915# 0 $ **FLOATING
C1184 li_20338_21706# a_106400_64915# 0 $ **FLOATING
C1185 li_22422_21922# a_106400_64915# 0 $ **FLOATING
C1186 li_22206_21922# a_106400_64915# 0 $ **FLOATING
C1187 li_21990_21922# a_106400_64915# 0 $ **FLOATING
C1188 li_21774_21922# a_106400_64915# 0 $ **FLOATING
C1189 li_21558_21922# a_106400_64915# 0 $ **FLOATING
C1190 li_20694_21922# a_106400_64915# 0 $ **FLOATING
C1191 li_20478_21922# a_106400_64915# 0 $ **FLOATING
C1192 li_20000_21650# a_106400_64915# 0 $ **FLOATING
C1193 li_22346_22138# a_106400_64915# 0 $ **FLOATING
C1194 li_22130_22138# a_106400_64915# 0 $ **FLOATING
C1195 li_21914_22138# a_106400_64915# 0 $ **FLOATING
C1196 li_21698_22138# a_106400_64915# 0 $ **FLOATING
C1197 li_21482_22138# a_106400_64915# 0 $ **FLOATING
C1198 li_20618_22138# a_106400_64915# 0 $ **FLOATING
C1199 li_20070_22050# a_106400_64915# 0 $ **FLOATING
C1200 li_20758_22354# a_106400_64915# 0 $ **FLOATING
C1201 li_20542_22354# a_106400_64915# 0 $ **FLOATING
C1202 li_109582_66418# a_106400_64915# 0 $ **FLOATING
C1203 li_109366_66418# a_106400_64915# 0 $ **FLOATING
C1204 li_109150_66418# a_106400_64915# 0 $ **FLOATING
C1205 li_108934_66418# a_106400_64915# 0 $ **FLOATING
C1206 li_108718_66418# a_106400_64915# 0 $ **FLOATING
C1207 li_108502_66418# a_106400_64915# 0 $ **FLOATING
C1208 li_108286_66418# a_106400_64915# 0 $ **FLOATING
C1209 li_108070_66418# a_106400_64915# 0 $ **FLOATING
C1210 li_107854_66418# a_106400_64915# 0 $ **FLOATING
C1211 li_107638_66418# a_106400_64915# 0 $ **FLOATING
C1212 li_107422_66418# a_106400_64915# 0 $ **FLOATING
C1213 li_107206_66418# a_106400_64915# 0 $ **FLOATING
C1214 li_106990_66418# a_106400_64915# 0 $ **FLOATING
C1215 li_106774_66418# a_106400_64915# 0 $ **FLOATING
C1216 li_106558_66418# a_106400_64915# 0 $ **FLOATING
C1217 li_106400_66418# a_106400_64915# 0 $ **FLOATING
C1218 li_109506_66634# a_106400_64915# 0 $ **FLOATING
C1219 li_109290_66634# a_106400_64915# 0 $ **FLOATING
C1220 li_109074_66634# a_106400_64915# 0 $ **FLOATING
C1221 li_108858_66634# a_106400_64915# 0 $ **FLOATING
C1222 li_108642_66634# a_106400_64915# 0 $ **FLOATING
C1223 li_108426_66634# a_106400_64915# 0 $ **FLOATING
C1224 li_108210_66634# a_106400_64915# 0 $ **FLOATING
C1225 li_107994_66634# a_106400_64915# 0 $ **FLOATING
C1226 li_107778_66634# a_106400_64915# 0 $ **FLOATING
C1227 li_107562_66634# a_106400_64915# 0 $ **FLOATING
C1228 li_107346_66634# a_106400_64915# 0 $ **FLOATING
C1229 li_107130_66634# a_106400_64915# 0 $ **FLOATING
C1230 li_106914_66634# a_106400_64915# 0 $ **FLOATING
C1231 li_106698_66634# a_106400_64915# 0 $ **FLOATING
C1232 li_106482_66634# a_106400_64915# 0 $ **FLOATING
C1233 li_109070_66860# a_106400_64915# 0 $ **FLOATING
C1234 li_108290_66860# a_106400_64915# 0 $ **FLOATING
C1235 li_107510_66860# a_106400_64915# 0 $ **FLOATING
C1236 li_106730_66860# a_106400_64915# 0 $ **FLOATING
C1237 li_106400_66860# a_106400_64915# 0 $ **FLOATING
C1238 a_20000_20000# a_106400_64915# 0 $ **FLOATING
C1239 a_21111_20175# a_106400_64915# 2.6014299999999998e-16 $ **FLOATING
C1240 a_20672_20180# a_106400_64915# 0 $ **FLOATING
C1241 a_20456_20180# a_106400_64915# 0 $ **FLOATING
C1242 a_20240_20180# a_106400_64915# 0 $ **FLOATING
C1243 a_20024_20180# a_106400_64915# 0 $ **FLOATING
C1244 a_20504_20396# a_106400_64915# 0 $ **FLOATING
C1245 a_20288_20396# a_106400_64915# 0 $ **FLOATING
C1246 a_20072_20396# a_106400_64915# 0 $ **FLOATING
C1247 a_20552_20612# a_106400_64915# 0 $ **FLOATING
C1248 a_20336_20612# a_106400_64915# 0 $ **FLOATING
C1249 a_20120_20612# a_106400_64915# 0 $ **FLOATING
C1250 a_20000_20612# a_106400_64915# 0 $ **FLOATING
C1251 a_20600_20828# a_106400_64915# 0 $ **FLOATING
C1252 a_20384_20828# a_106400_64915# 0 $ **FLOATING
C1253 a_20168_20828# a_106400_64915# 0 $ **FLOATING
C1254 a_20000_20828# a_106400_64915# 0 $ **FLOATING
C1255 a_20648_21044# a_106400_64915# 0 $ **FLOATING
C1256 a_20432_21044# a_106400_64915# 0 $ **FLOATING
C1257 a_20216_21044# a_106400_64915# 0 $ **FLOATING
C1258 a_20000_21044# a_106400_64915# 0 $ **FLOATING
C1259 a_20696_21260# a_106400_64915# 0 $ **FLOATING
C1260 a_20480_21260# a_106400_64915# 0 $ **FLOATING
C1261 a_20264_21260# a_106400_64915# 0 $ **FLOATING
C1262 a_20048_21260# a_106400_64915# 0 $ **FLOATING
C1263 a_20528_21476# a_106400_64915# 0 $ **FLOATING
C1264 a_20312_21476# a_106400_64915# 0 $ **FLOATING
C1265 a_21043_20776# a_106400_64915# 1.0766500000000002e-15 $ **FLOATING
C1266 a_20576_21692# a_106400_64915# 0 $ **FLOATING
C1267 a_20360_21692# a_106400_64915# 0 $ **FLOATING
C1268 a_20144_21692# a_106400_64915# 0 $ **FLOATING
C1269 a_20624_21908# a_106400_64915# 0 $ **FLOATING
C1270 a_20408_21908# a_106400_64915# 0 $ **FLOATING
C1271 a_20192_21908# a_106400_64915# 0 $ **FLOATING
C1272 a_20672_22124# a_106400_64915# 0 $ **FLOATING
C1273 a_20456_22124# a_106400_64915# 0 $ **FLOATING
C1274 a_20240_22124# a_106400_64915# 0 $ **FLOATING
C1275 a_21058_20215# a_106400_64915# 3.6434400000000007e-15 $ **FLOATING
C1276 a_20000_21496# a_106400_64915# 0 $ **FLOATING
C1277 a_21098_22430# a_106400_64915# 3.4029800000000001e-18 $ **FLOATING
C1278 a_21043_22108# a_106400_64915# 1.3333499999999999e-15 $ **FLOATING
C1279 a_20504_22340# a_106400_64915# 0 $ **FLOATING
C1280 a_20288_22340# a_106400_64915# 0 $ **FLOATING
C1281 a_20098_22396# a_106400_64915# 0 $ **FLOATING
C1282 a_20000_22396# a_106400_64915# 0 $ **FLOATING
C1283 a_109107_64400# a_106400_64915# 2.2618000000000006e-16 $ **FLOATING
C1284 a_108003_64400# a_106400_64915# 3.0544800000000003e-16 $ **FLOATING
C1285 a_107267_64400# a_106400_64915# 9.5162400000000014e-17 $ **FLOATING
C1286 a_106400_64400# a_106400_64915# 2.3011199999999999e-16 $ **FLOATING
C1287 a_109568_66404# a_106400_64915# 0 $ **FLOATING
C1288 a_109352_66404# a_106400_64915# 0 $ **FLOATING
C1289 a_109136_66404# a_106400_64915# 0 $ **FLOATING
C1290 a_108920_66404# a_106400_64915# 0 $ **FLOATING
C1291 a_108704_66404# a_106400_64915# 0 $ **FLOATING
C1292 a_108488_66404# a_106400_64915# 0 $ **FLOATING
C1293 a_108272_66404# a_106400_64915# 0 $ **FLOATING
C1294 a_108056_66404# a_106400_64915# 0 $ **FLOATING
C1295 a_107840_66404# a_106400_64915# 0 $ **FLOATING
C1296 a_107624_66404# a_106400_64915# 0 $ **FLOATING
C1297 a_107408_66404# a_106400_64915# 0 $ **FLOATING
C1298 a_107192_66404# a_106400_64915# 0 $ **FLOATING
C1299 a_106976_66404# a_106400_64915# 0 $ **FLOATING
C1300 a_106760_66404# a_106400_64915# 0 $ **FLOATING
C1301 a_106544_66404# a_106400_64915# 0 $ **FLOATING
C1302 a_106400_66404# a_106400_64915# 0 $ **FLOATING
C1303 a_109616_66620# a_106400_64915# 0 $ **FLOATING
C1304 a_109400_66620# a_106400_64915# 0 $ **FLOATING
C1305 a_109184_66620# a_106400_64915# 0 $ **FLOATING
C1306 a_108968_66620# a_106400_64915# 0 $ **FLOATING
C1307 a_108752_66620# a_106400_64915# 0 $ **FLOATING
C1308 a_108536_66620# a_106400_64915# 0 $ **FLOATING
C1309 a_108320_66620# a_106400_64915# 0 $ **FLOATING
C1310 a_108104_66620# a_106400_64915# 0 $ **FLOATING
C1311 a_107888_66620# a_106400_64915# 0 $ **FLOATING
C1312 a_107672_66620# a_106400_64915# 0 $ **FLOATING
C1313 a_107456_66620# a_106400_64915# 0 $ **FLOATING
C1314 a_107240_66620# a_106400_64915# 0 $ **FLOATING
C1315 a_107024_66620# a_106400_64915# 0 $ **FLOATING
C1316 a_106808_66620# a_106400_64915# 0 $ **FLOATING
C1317 a_106592_66620# a_106400_64915# 0 $ **FLOATING
C1318 a_106400_66620# a_106400_64915# 0 $ **FLOATING
C1319 a_109648_66936# a_106400_64915# 0 $ **FLOATING
C1320 a_109402_67036# a_106400_64915# 0 $ **FLOATING
C1321 a_109450_67216# a_106400_64915# 0 $ **FLOATING
C1322 a_109452_67404# a_106400_64915# 0 $ **FLOATING
C1323 a_108512_66936# a_106400_64915# 0 $ **FLOATING
C1324 a_108274_66856# a_106400_64915# 0 $ **FLOATING
C1325 a_108322_67036# a_106400_64915# 0 $ **FLOATING
C1326 a_108296_67484# a_106400_64915# 0 $ **FLOATING
C1327 a_107376_66936# a_106400_64915# 0 $ **FLOATING
C1328 a_107194_66856# a_106400_64915# 0 $ **FLOATING
C1329 a_107120_67052# a_106400_64915# 0 $ **FLOATING
C1330 a_107168_67268# a_106400_64915# 0 $ **FLOATING
C1331 a_107206_67576# a_106400_64915# 0 $ **FLOATING
C1332 a_106400_66936# a_106400_64915# 0 $ **FLOATING
C1333 w_20978_20000# a_106400_64915# 2.3743199999999998e-16
C1334 w_20978_20716# a_106400_64915# 3.0500900000000002e-15 $ **FLOATING
C1335 w_20978_22048# a_106400_64915# 2.0932100000000003e-15 $ **FLOATING
C1336 w_106364_64364# a_106400_64915# 1.3847000000000001e-14 $ **FLOATING
C1337 w_106364_65359# a_106400_64915# 2.1808900000000003e-14 $ **FLOATING
C1338 a_106400_64915# a_106400_64915# 0 $ **FLOATING
.ends
