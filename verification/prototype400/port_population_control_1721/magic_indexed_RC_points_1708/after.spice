* NGSPICE file created from PortStress.ext - technology: sky130A

.subckt PortStress P0 P1 ISOLATED_0 ISOLATED_1 ISOLATED_2 ISOLATED_3 ISOLATED_4 ISOLATED_5
+ ISOLATED_6 ISOLATED_7 ISOLATED_8 ISOLATED_9 ISOLATED_10 ISOLATED_11 ISOLATED_12
+ ISOLATED_13 ISOLATED_14 ISOLATED_15 ISOLATED_16 ISOLATED_17 ISOLATED_18 ISOLATED_19
+ ISOLATED_20 ISOLATED_21 ISOLATED_22 ISOLATED_23 ISOLATED_24 ISOLATED_25 ISOLATED_26
+ ISOLATED_27 ISOLATED_28 ISOLATED_29 ISOLATED_30 ISOLATED_31 ISOLATED_32 ISOLATED_33
+ ISOLATED_34 ISOLATED_35 ISOLATED_36 ISOLATED_37 ISOLATED_38 ISOLATED_39 ISOLATED_40
+ ISOLATED_41 ISOLATED_42 ISOLATED_43 ISOLATED_44 ISOLATED_45 ISOLATED_46 ISOLATED_47
+ ISOLATED_48 ISOLATED_49 ISOLATED_50 ISOLATED_51 ISOLATED_52 ISOLATED_53 ISOLATED_54
+ ISOLATED_55 ISOLATED_56 ISOLATED_57 ISOLATED_58 ISOLATED_59 ISOLATED_60 ISOLATED_61
+ ISOLATED_62
R0 LOAD_0 P0 0.000000
C0 ISOLATED_14 ISOLATED_15 7.0400000000000011e-18
C1 ISOLATED_15 ISOLATED_16 7.0400000000000011e-18
C2 ISOLATED_42 ISOLATED_41 7.0400000000000011e-18
C3 ISOLATED_17 ISOLATED_16 7.0400000000000011e-18
C4 ISOLATED_17 ISOLATED_18 7.0400000000000011e-18
C5 ISOLATED_38 ISOLATED_37 7.0400000000000011e-18
C6 ISOLATED_52 ISOLATED_51 7.0400000000000011e-18
C7 ISOLATED_19 ISOLATED_18 7.0400000000000011e-18
C8 ISOLATED_47 ISOLATED_46 7.0400000000000011e-18
C9 ISOLATED_58 ISOLATED_57 7.0400000000000011e-18
C10 ISOLATED_32 ISOLATED_31 7.0400000000000011e-18
C11 ISOLATED_43 ISOLATED_44 7.0400000000000011e-18
C12 ISOLATED_32 ISOLATED_33 7.0400000000000011e-18
C13 ISOLATED_35 ISOLATED_36 7.0400000000000011e-18
C14 ISOLATED_19 ISOLATED_20 7.0400000000000011e-18
C15 ISOLATED_23 ISOLATED_24 7.0400000000000011e-18
C16 ISOLATED_49 ISOLATED_48 7.0400000000000011e-18
C17 ISOLATED_35 ISOLATED_34 7.0400000000000011e-18
C18 P1 ISOLATED_0 2.7076900000000001e-18
C19 ISOLATED_40 ISOLATED_41 7.0400000000000011e-18
C20 ISOLATED_49 ISOLATED_50 7.0400000000000011e-18
C21 ISOLATED_20 ISOLATED_21 7.0400000000000011e-18
C22 ISOLATED_55 ISOLATED_54 7.0400000000000011e-18
C23 ISOLATED_21 ISOLATED_22 7.0400000000000011e-18
C24 ISOLATED_62 ISOLATED_61 7.0400000000000011e-18
C25 ISOLATED_26 ISOLATED_27 7.0400000000000011e-18
C26 ISOLATED_46 ISOLATED_45 7.0400000000000011e-18
C27 ISOLATED_51 ISOLATED_50 7.0400000000000011e-18
C28 ISOLATED_24 ISOLATED_25 7.0400000000000011e-18
C29 ISOLATED_42 ISOLATED_43 7.0400000000000011e-18
C30 ISOLATED_0 ISOLATED_1 7.0400000000000011e-18
C31 ISOLATED_2 ISOLATED_1 7.0400000000000011e-18
C32 ISOLATED_3 ISOLATED_2 7.0400000000000011e-18
C33 ISOLATED_3 ISOLATED_4 7.0400000000000011e-18
C34 ISOLATED_31 ISOLATED_30 7.0400000000000011e-18
C35 ISOLATED_44 ISOLATED_45 7.0400000000000011e-18
C36 ISOLATED_5 ISOLATED_4 7.0400000000000011e-18
C37 ISOLATED_37 ISOLATED_36 7.0400000000000011e-18
C38 ISOLATED_6 ISOLATED_5 7.0400000000000011e-18
C39 ISOLATED_57 ISOLATED_56 7.0400000000000011e-18
C40 ISOLATED_53 ISOLATED_52 7.0400000000000011e-18
C41 ISOLATED_6 ISOLATED_7 7.0400000000000011e-18
C42 ISOLATED_39 ISOLATED_38 7.0400000000000011e-18
C43 ISOLATED_28 ISOLATED_27 7.0400000000000011e-18
C44 ISOLATED_7 ISOLATED_8 7.0400000000000011e-18
C45 ISOLATED_55 ISOLATED_56 7.0400000000000011e-18
C46 ISOLATED_33 ISOLATED_34 7.0400000000000011e-18
C47 ISOLATED_28 ISOLATED_29 7.0400000000000011e-18
C48 ISOLATED_9 ISOLATED_8 7.0400000000000011e-18
C49 ISOLATED_60 ISOLATED_61 7.0400000000000011e-18
C50 ISOLATED_59 ISOLATED_58 7.0400000000000011e-18
C51 ISOLATED_30 ISOLATED_29 7.0400000000000011e-18
C52 ISOLATED_10 ISOLATED_9 7.0400000000000011e-18
C53 ISOLATED_10 ISOLATED_11 7.0400000000000011e-18
C54 ISOLATED_53 ISOLATED_54 7.0400000000000011e-18
C55 ISOLATED_39 ISOLATED_40 7.0400000000000011e-18
C56 ISOLATED_11 ISOLATED_12 7.0400000000000011e-18
C57 ISOLATED_47 ISOLATED_48 7.0400000000000011e-18
C58 ISOLATED_23 ISOLATED_22 7.0400000000000011e-18
C59 ISOLATED_13 ISOLATED_12 7.0400000000000011e-18
C60 ISOLATED_59 ISOLATED_60 7.0400000000000011e-18
C61 ISOLATED_14 ISOLATED_13 7.0400000000000011e-18
C62 ISOLATED_26 ISOLATED_25 7.0400000000000011e-18
R1 P0 P1.n1 1.5
R2 P1.n1 P1.n0 1.875
R3 P1.n0 P1 1.6000000000000001
C63 LOAD_0 SUB 0 $ **FLOATING
C64 P0 SUB 6.5324698779296792e-16
C65 ISOLATED_0 SUB 9.3904300000000022e-17
C66 ISOLATED_1 SUB 9.1213900000000007e-17
C67 ISOLATED_2 SUB 9.1213900000000007e-17
C68 ISOLATED_3 SUB 9.1213900000000007e-17
C69 ISOLATED_4 SUB 9.1213900000000007e-17
C70 ISOLATED_5 SUB 9.1213900000000007e-17
C71 ISOLATED_6 SUB 9.1213900000000007e-17
C72 ISOLATED_7 SUB 9.1213900000000007e-17
C73 ISOLATED_8 SUB 9.1213900000000007e-17
C74 ISOLATED_9 SUB 9.1213900000000007e-17
C75 ISOLATED_10 SUB 9.1213900000000007e-17
C76 ISOLATED_11 SUB 9.1213900000000007e-17
C77 ISOLATED_12 SUB 9.1213900000000007e-17
C78 ISOLATED_13 SUB 9.1213900000000007e-17
C79 ISOLATED_14 SUB 9.1213900000000007e-17
C80 ISOLATED_15 SUB 9.1213900000000007e-17
C81 ISOLATED_16 SUB 9.1213900000000007e-17
C82 ISOLATED_17 SUB 9.1213900000000007e-17
C83 ISOLATED_18 SUB 9.1213900000000007e-17
C84 ISOLATED_19 SUB 9.1213900000000007e-17
C85 ISOLATED_20 SUB 9.1213900000000007e-17
C86 ISOLATED_21 SUB 9.1213900000000007e-17
C87 ISOLATED_22 SUB 9.1213900000000007e-17
C88 ISOLATED_23 SUB 9.1213900000000007e-17
C89 ISOLATED_24 SUB 9.1213900000000007e-17
C90 ISOLATED_25 SUB 9.1213900000000007e-17
C91 ISOLATED_26 SUB 9.1213900000000007e-17
C92 ISOLATED_27 SUB 9.1213900000000007e-17
C93 ISOLATED_28 SUB 9.1213900000000007e-17
C94 ISOLATED_29 SUB 9.1213900000000007e-17
C95 ISOLATED_30 SUB 9.1213900000000007e-17
C96 ISOLATED_31 SUB 9.1213900000000007e-17
C97 ISOLATED_32 SUB 9.1213900000000007e-17
C98 ISOLATED_33 SUB 9.1213900000000007e-17
C99 ISOLATED_34 SUB 9.1213900000000007e-17
C100 ISOLATED_35 SUB 9.1213900000000007e-17
C101 ISOLATED_36 SUB 9.1213900000000007e-17
C102 ISOLATED_37 SUB 9.1213900000000007e-17
C103 ISOLATED_38 SUB 9.1213900000000007e-17
C104 ISOLATED_39 SUB 9.1213900000000007e-17
C105 ISOLATED_40 SUB 9.1213900000000007e-17
C106 ISOLATED_41 SUB 9.1213900000000007e-17
C107 ISOLATED_42 SUB 9.1213900000000007e-17
C108 ISOLATED_43 SUB 9.1213900000000007e-17
C109 ISOLATED_44 SUB 9.1213900000000007e-17
C110 ISOLATED_45 SUB 9.1213900000000007e-17
C111 ISOLATED_46 SUB 9.1213900000000007e-17
C112 ISOLATED_47 SUB 9.1213900000000007e-17
C113 ISOLATED_48 SUB 9.1213900000000007e-17
C114 ISOLATED_49 SUB 9.1213900000000007e-17
C115 ISOLATED_50 SUB 9.1213900000000007e-17
C116 ISOLATED_51 SUB 9.1213900000000007e-17
C117 ISOLATED_52 SUB 9.1213900000000007e-17
C118 ISOLATED_53 SUB 9.1213900000000007e-17
C119 ISOLATED_54 SUB 9.1213900000000007e-17
C120 ISOLATED_55 SUB 9.1213900000000007e-17
C121 ISOLATED_56 SUB 9.1213900000000007e-17
C122 ISOLATED_57 SUB 9.1213900000000007e-17
C123 ISOLATED_58 SUB 9.1213900000000007e-17
C124 ISOLATED_59 SUB 9.1213900000000007e-17
C125 ISOLATED_60 SUB 9.1213900000000007e-17
C126 ISOLATED_61 SUB 9.1213900000000007e-17
C127 ISOLATED_62 SUB 9.6869000000000004e-17
C128 dummy SUB 0 $ **FLOATING
C129 SUB SUB 0
C130 P1 SUB 7.1857169877929676e-16
C131 P1.n0 SUB 1.513355560375977e-15 $ **FLOATING
C132 P1.n1 SUB 1.469805753051758e-15 $ **FLOATING
.ends
