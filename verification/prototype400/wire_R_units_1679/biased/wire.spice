* NGSPICE file created from WireUnits.ext - technology: sky130A

* Top level circuit WireUnits

R0 g h 1000
R1 e f 4.9755
R2 c d 0.000501
R3 a b 0.0005
.end
