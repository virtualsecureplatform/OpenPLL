* NGSPICE file created from OpenPLL_Coupling_R_Probe.ext - technology: sky130A

.subckt OpenPLL_Coupling_R_Probe A B AFAR
R0 MID A 0.000000
C0 AFAR B 3.9111100000000006e-15
R1 A AFAR.n1 1.5
R2 AFAR.n1 AFAR.n0 1.875
R3 AFAR.n0 AFAR 1.6000000000000001
C1 MID SUB 0 $ **FLOATING
C2 A SUB 4.2619501373291038e-16
C3 B SUB 2.8413000000000006e-15
C4 dummy SUB 0 $ **FLOATING
C5 SUB SUB 0
C6 AFAR SUB 4.6881449069213867e-16
C7 AFAR.n0 SUB 9.8735176045227056e-16 $ **FLOATING
C8 AFAR.n1 SUB 9.5893873512268068e-16 $ **FLOATING
.ends
