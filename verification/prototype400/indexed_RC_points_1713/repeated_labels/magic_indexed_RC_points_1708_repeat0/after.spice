* NGSPICE file created from OpenPLL_Coupling_R_Probe.ext - technology: sky130A

.subckt OpenPLL_Coupling_R_Probe A B AFAR
C0 AFAR B 3.9111100000000006e-15
R0 A AFAR 4.9749999999999996
C1 AFAR SUB 1.4277532106323235e-15
C2 A SUB 1.4135467893676772e-15
C3 B SUB 2.8413000000000006e-15
C4 dummy SUB 0 $ **FLOATING
C5 SUB SUB 0
.ends
