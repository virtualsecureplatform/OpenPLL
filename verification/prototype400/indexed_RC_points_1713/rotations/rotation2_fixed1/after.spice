* NGSPICE file created from RotatedCrop.ext - technology: sky130A

.subckt RotatedCrop
* OPENPLL_ORIGIN X0 sky130_fd_pr__pfet_01v8 108402 66624 108403 66625
X0 a_108345_66276.t1 a_108332_65715.t8 a_108345_66276.t0 w_107200_66216.t1 sky130_fd_pr__pfet_01v8 ad=0.285 pd=2.57 as=0 ps=0 w=1 l=1
* OPENPLL_ORIGIN X1 sky130_fd_pr__nfet_01v8 20000 21487 20001 21488
X1 a_20000_21737.t19 w_19964_21727.t23 a_20000_21737.t18 a_20000_21737.t18 sky130_fd_pr__nfet_01v8 ad=0.143 pd=1.62 as=0 ps=0 w=0.55 l=2.69
* OPENPLL_ORIGIN X2 sky130_fd_pr__pfet_01v8_hvt 20751 21763 20752 21764
X2 w_19964_21727.t15 a_20000_21737.t42 w_19964_21727.t2 w_19964_21727.t2 sky130_fd_pr__pfet_01v8_hvt ad=0.2262 pd=2.26 as=0 ps=0 w=0.87 l=4.73
* OPENPLL_ORIGIN X3 sky130_fd_pr__pfet_01v8_hvt 22039 23119 22040 23120
X3 w_19964_23083.t7 a_22039_23093# w_19964_23083.t5 w_19964_23083.t5 sky130_fd_pr__pfet_01v8_hvt ad=0.1053 pd=1.33 as=0 ps=0 w=0.405 l=1.97
* OPENPLL_ORIGIN X4 sky130_fd_pr__nfet_01v8 22039 22371 22040 22372
X4 a_20000_21737.t24 w_19964_21727.t21 a_20000_21737.t22 a_20000_21737.t22 sky130_fd_pr__nfet_01v8 ad=0.143 pd=1.62 as=0 ps=0 w=0.55 l=1.97
* OPENPLL_ORIGIN X5 sky130_fd_pr__pfet_01v8_hvt 22039 22031 22040 22032
X5 w_19964_21727.t7 a_20000_21737.t39 w_19964_21727.t5 w_19964_21727.t5 sky130_fd_pr__pfet_01v8_hvt ad=0.2262 pd=2.26 as=0 ps=0 w=0.87 l=1.97
* OPENPLL_ORIGIN X6 sky130_fd_pr__nfet_01v8 21947 21487 21948 21488
X6 a_20000_21737.t14 w_19964_21727.t25 a_20000_21737.t12 a_20000_21737.t12 sky130_fd_pr__nfet_01v8 ad=0.143 pd=1.62 as=0 ps=0 w=0.55 l=0.59
* OPENPLL_ORIGIN X7 sky130_fd_pr__pfet_01v8_hvt 20000 21763 20001 21764
X7 w_19964_21727.t8 a_20000_21737.t41 w_19964_21727.t0 w_19964_21727.t0 sky130_fd_pr__pfet_01v8_hvt ad=0.2262 pd=2.26 as=0 ps=0 w=0.87 l=2.53
* OPENPLL_ORIGIN X8 sky130_fd_pr__nfet_01v8 21119 22575 21120 22576
X8 a_20000_21737.t5 w_19964_23083.t20 a_20000_21737.t3 a_20000_21737.t3 sky130_fd_pr__nfet_01v8 ad=0.143 pd=1.62 as=0 ps=0 w=0.55 l=4.73
* OPENPLL_ORIGIN X9 sky130_fd_pr__nfet_01v8_lvt 108389 67047 108390 67048
X9 a_108332_65715.t5 a_108345_66276.t4 a_108332_65715.t4 a_20000_21737.t32 sky130_fd_pr__nfet_01v8_lvt ad=0.1197 pd=1.41 as=0 ps=0 w=0.42 l=1
* OPENPLL_ORIGIN X10 sky130_fd_pr__pfet_01v8 108402 66276 108403 66277
X10 a_108345_66276.t3 a_108332_65715.t9 a_108345_66276.t2 w_107200_66216.t0 sky130_fd_pr__pfet_01v8 ad=0.285 pd=2.57 as=0 ps=0 w=1 l=1
* OPENPLL_ORIGIN X11 sky130_fd_pr__pfet_01v8_hvt 21947 21763 21948 21764
X11 w_19964_21727.t18 a_20000_21737.t43 w_19964_21727.t16 w_19964_21727.t16 sky130_fd_pr__pfet_01v8_hvt ad=0.2262 pd=2.26 as=0 ps=0 w=0.87 l=0.59
* OPENPLL_ORIGIN X12 sky130_fd_pr__pfet_01v8 108402 65292 108403 65293
X12 a_108345_65100.t1 a_108332_65715.t10 a_108345_65100.t0 w_107200_65100.t0 sky130_fd_pr__pfet_01v8 ad=0.285 pd=2.57 as=0 ps=0 w=1 l=1
* OPENPLL_ORIGIN X13 sky130_fd_pr__pfet_01v8_hvt 20751 23119 20752 23120
X13 w_19964_23083.t13 a_20751_23093# w_19964_23083.t11 w_19964_23083.t11 sky130_fd_pr__pfet_01v8_hvt ad=0.1053 pd=1.33 as=0 ps=0 w=0.405 l=4.73
* OPENPLL_ORIGIN X14 sky130_fd_pr__nfet_01v8 20751 22371 20752 22372
X14 a_20000_21737.t27 w_19964_21727.t20 a_20000_21737.t25 a_20000_21737.t25 sky130_fd_pr__nfet_01v8 ad=0.143 pd=1.62 as=0 ps=0 w=0.55 l=4.73
* OPENPLL_ORIGIN X15 sky130_fd_pr__nfet_01v8 22223 21487 22224 21488
X15 a_20000_21737.t11 w_19964_21727.t26 a_20000_21737.t9 a_20000_21737.t9 sky130_fd_pr__nfet_01v8 ad=0.143 pd=1.62 as=0 ps=0 w=0.55 l=4.73
* OPENPLL_ORIGIN X16 sky130_fd_pr__nfet_01v8_lvt 108389 65715 108390 65716
X16 a_108332_65715.t7 a_108345_65100.t4 a_108332_65715.t6 a_20000_21737.t33 sky130_fd_pr__nfet_01v8_lvt ad=0.1197 pd=1.41 as=0 ps=0 w=0.42 l=1
* OPENPLL_ORIGIN X17 sky130_fd_pr__pfet_01v8_hvt 21119 22851 21120 22852
X17 w_19964_23083.t18 a_20000_21737.t35 w_19964_23083.t16 w_19964_23083.t16 sky130_fd_pr__pfet_01v8_hvt ad=0.2262 pd=2.26 as=0 ps=0 w=0.87 l=4.73
* OPENPLL_ORIGIN X18 sky130_fd_pr__pfet_01v8_hvt 20751 22031 20752 22032
X18 w_19964_21727.t4 a_20000_21737.t38 w_19964_21727.t2 w_19964_21727.t2 sky130_fd_pr__pfet_01v8_hvt ad=0.2262 pd=2.26 as=0 ps=0 w=0.87 l=4.73
* OPENPLL_ORIGIN X19 sky130_fd_pr__nfet_01v8_lvt 108389 67301 108390 67302
X19 a_108332_65715.t1 a_108389_67263# a_108332_65715.t0 a_20000_21737.t30 sky130_fd_pr__nfet_01v8_lvt ad=0.1197 pd=1.41 as=0 ps=0 w=0.42 l=1
* OPENPLL_ORIGIN X20 sky130_fd_pr__pfet_01v8_hvt 20000 23119 20001 23120
X20 w_19964_23083.t4 a_20000_23093# w_19964_23083.t3 w_19964_23083.t3 sky130_fd_pr__pfet_01v8_hvt ad=0.1053 pd=1.33 as=0 ps=0 w=0.405 l=1.28
* OPENPLL_ORIGIN X21 sky130_fd_pr__pfet_01v8_hvt 22591 23119 22592 23120
X21 w_19964_23083.t15 a_22591_23093# w_19964_23083.t14 w_19964_23083.t14 sky130_fd_pr__pfet_01v8_hvt ad=0.1053 pd=1.33 as=0 ps=0 w=0.405 l=1.57
* OPENPLL_ORIGIN X22 sky130_fd_pr__nfet_01v8 20015 22575 20016 22576
X22 a_20000_21737.t8 w_19964_23083.t19 a_20000_21737.t6 a_20000_21737.t6 sky130_fd_pr__nfet_01v8 ad=0.04125 pd=1.25 as=0 ps=0 w=0.55 l=4.73
* OPENPLL_ORIGIN X23 sky130_fd_pr__nfet_01v8 20000 22371 20001 22372
X23 a_20000_21737.t29 w_19964_21727.t19 a_20000_21737.t28 a_20000_21737.t28 sky130_fd_pr__nfet_01v8 ad=0.143 pd=1.62 as=0 ps=0 w=0.55 l=2.69
* OPENPLL_ORIGIN X24 sky130_fd_pr__nfet_01v8 22591 22371 22592 22372
X24 a_20000_21737.t21 w_19964_21727.t22 a_20000_21737.t20 a_20000_21737.t20 sky130_fd_pr__nfet_01v8 ad=0.143 pd=1.62 as=0 ps=0 w=0.55 l=3.27
* OPENPLL_ORIGIN X25 sky130_fd_pr__pfet_01v8_hvt 20000 22031 20001 22032
X25 w_19964_21727.t1 a_20000_21737.t37 w_19964_21727.t0 w_19964_21727.t0 sky130_fd_pr__pfet_01v8_hvt ad=0.2262 pd=2.26 as=0 ps=0 w=0.87 l=2.53
* OPENPLL_ORIGIN X26 sky130_fd_pr__pfet_01v8_hvt 22591 22031 22592 22032
X26 w_19964_21727.t10 a_20000_21737.t40 w_19964_21727.t9 w_19964_21727.t9 sky130_fd_pr__pfet_01v8_hvt ad=0.2262 pd=2.26 as=0 ps=0 w=0.87 l=3.11
* OPENPLL_ORIGIN X27 sky130_fd_pr__pfet_01v8_hvt 22223 21763 22224 21764
X27 w_19964_21727.t13 a_20000_21737.t44 w_19964_21727.t11 w_19964_21727.t11 sky130_fd_pr__pfet_01v8_hvt ad=0.2262 pd=2.26 as=0 ps=0 w=0.87 l=4.73
* OPENPLL_ORIGIN X28 sky130_fd_pr__nfet_01v8_lvt 108389 65969 108390 65970
X28 a_108332_65715.t3 a_108345_66276.t5 a_108332_65715.t2 a_20000_21737.t31 sky130_fd_pr__nfet_01v8_lvt ad=0.1197 pd=1.41 as=0 ps=0 w=0.42 l=1
* OPENPLL_ORIGIN X29 sky130_fd_pr__nfet_01v8 22223 22575 22224 22576
X29 a_20000_21737.t2 w_19964_23083.t21 a_20000_21737.t0 a_20000_21737.t0 sky130_fd_pr__nfet_01v8 ad=0.143 pd=1.62 as=0 ps=0 w=0.55 l=4.73
* OPENPLL_ORIGIN X30 sky130_fd_pr__pfet_01v8 108402 65100 108403 65101
X30 a_108345_65100.t3 a_108402_65100# a_108345_65100.t2 w_107200_65100.t1 sky130_fd_pr__pfet_01v8 ad=0.0627 pd=1.01 as=0 ps=0 w=0.22 l=1
* OPENPLL_ORIGIN X31 sky130_fd_pr__pfet_01v8_hvt 20015 22851 20016 22852
X31 w_19964_23083.t10 a_20000_21737.t34 w_19964_23083.t8 w_19964_23083.t8 sky130_fd_pr__pfet_01v8_hvt ad=0.06525 pd=1.89 as=0 ps=0 w=0.87 l=4.73
* OPENPLL_ORIGIN X32 sky130_fd_pr__pfet_01v8_hvt 22223 22851 22224 22852
X32 w_19964_23083.t2 a_20000_21737.t36 w_19964_23083.t0 w_19964_23083.t0 sky130_fd_pr__pfet_01v8_hvt ad=0.2262 pd=2.26 as=0 ps=0 w=0.87 l=4.73
* OPENPLL_ORIGIN X33 sky130_fd_pr__nfet_01v8 20751 21487 20752 21488
X33 a_20000_21737.t17 w_19964_21727.t24 a_20000_21737.t15 a_20000_21737.t15 sky130_fd_pr__nfet_01v8 ad=0.143 pd=1.62 as=0 ps=0 w=0.55 l=4.73
C0 m4_107598_65100# m2_107998_65100# 1.0179600000000001e-17
C1 m2_107326_65100# m4_107598_65100# 1.0591400000000002e-17
C2 m4_107214_65100# m5_107200_66336# 1.3577300000000001e-16
C3 m1_107200_66388# a_108345_65100# 6.1075300000000006e-20
C4 w_19964_21727# a_22591_23093# 3.5767900000000004e-18
C5 w_19964_21727# a_22039_23093# 4.3139900000000006e-18
C6 w_19964_21727# a_20751_23093# 4.3139900000000006e-18
C7 a_22591_23093# w_19964_23083# 3.3554199999999996e-16
C8 a_22039_23093# w_19964_23083# 2.1416300000000004e-16
C9 w_19964_23083# a_20751_23093# 4.4880300000000007e-16
C10 a_108332_65715# a_108402_65100# 3.35961e-17
C11 w_19964_21727# a_20000_23093# 4.0955600000000003e-19
C12 w_19964_23083# a_20000_23093# 2.63403e-16
C13 w_107200_65100# a_108402_65100# 5.2726700000000005e-17
C14 a_108345_66276# a_108345_65100# 4.1432899999999998e-17
C15 m2_108190_65100# m5_107200_66336# 1.3326700000000002e-17
C16 m4_107598_65100# a_108402_65100# 1.0612000000000001e-20
C17 m1_107200_67350# m5_107200_66336# 2.3707300000000004e-18
C18 a_108332_65715# a_108345_65100# 6.3762400000000006e-16
C19 w_107200_65100# a_108345_65100# 5.3274900000000011e-16
C20 a_108345_66276# m1_107200_66388# 2.0253100000000003e-16
C21 a_108389_67263# m1_107200_66388# 1.6522900000000002e-19
C22 m4_107598_65100# a_108345_65100# 9.049500000000001e-18
C23 a_108332_65715# m1_107200_66388# 1.08716e-16
C24 w_107200_65100# m1_107200_66388# 3.8351200000000004e-19
C25 m1_107200_66388# w_107200_66216# 8.1488200000000022e-17
C26 w_107200_67548# m1_107200_66388# 3.2119600000000002e-18
C27 m1_107200_67424# m4_107214_65100# 1.3892400000000002e-18
C28 m2_107998_65100# m3_107200_66002# 1.63333e-18
C29 a_108345_66276# a_108389_67263# 3.4042600000000001e-17
C30 a_108345_66276# a_108332_65715# 1.2381600000000002e-15
C31 m2_107326_65100# m3_107200_66002# 5.1122700000000006e-17
C32 m4_107598_65100# m1_107200_66388# 1.4423900000000002e-17
C33 a_108345_66276# w_107200_66216# 7.2327600000000002e-16
C34 a_108389_67263# a_108332_65715# 2.1590700000000004e-16
C35 a_108389_67263# w_107200_67548# 2.2428400000000003e-17
C36 a_108332_65715# w_107200_66216# 4.0230400000000002e-16
C37 a_108332_65715# w_107200_65100# 2.0189100000000001e-16
C38 a_108332_65715# w_107200_67548# 6.0162100000000004e-17
C39 w_19964_21727# w_19964_23083# 8.8069700000000004e-16
C40 a_108345_66276# m4_107598_65100# 8.8562999999999996e-18
C41 m1_107200_67424# m2_108190_65100# 4.8298300000000001e-17
C42 m4_107982_65100# m2_107998_65100# 2.66712e-17
C43 m1_107200_67350# m1_107200_67424# 6.5872900000000004e-16
C44 m2_107326_65100# m4_107982_65100# 8.7285199999999993e-19
C45 a_108389_67263# m4_107598_65100# 1.2061800000000001e-19
C46 a_108332_65715# m4_107598_65100# 1.6941400000000004e-17
C47 w_107200_65100# m4_107598_65100# 6.5861000000000007e-18
C48 m4_107598_65100# w_107200_66216# 9.0080500000000004e-18
C49 w_107200_67548# m4_107598_65100# 1.08472e-18
C50 m3_107200_66002# a_108345_65100# 1.61041e-18
C51 m4_107982_65100# a_108402_65100# 2.8074700000000005e-19
C52 m1_107200_66388# m3_107200_66002# 1.9391000000000001e-17
C53 m4_107982_65100# a_108345_65100# 1.6507000000000003e-17
C54 a_108345_66276# m3_107200_66002# 1.24753e-17
C55 a_108389_67263# m3_107200_66002# 9.1782600000000015e-20
C56 a_108332_65715# m3_107200_66002# 2.8119599999999999e-17
C57 m4_107982_65100# m1_107200_66388# 4.7e-19
C58 w_107200_65100# m3_107200_66002# 4.9466100000000001e-18
C59 m3_107200_66002# w_107200_66216# 1.6701200000000002e-17
C60 w_107200_67548# m3_107200_66002# 8.4649000000000005e-19
C61 m4_107214_65100# m2_107326_65100# 2.5023100000000001e-17
C62 a_108345_66276# m4_107982_65100# 1.6397200000000001e-17
C63 m4_107598_65100# m3_107200_66002# 6.140160000000001e-16
C64 a_108389_67263# m4_107982_65100# 1.9722600000000002e-18
C65 a_108332_65715# m4_107982_65100# 2.27618e-16
C66 m2_108190_65100# m2_107998_65100# 5.5803600000000002e-16
C67 w_107200_65100# m4_107982_65100# 8.1896100000000012e-18
C68 w_107200_67548# m4_107982_65100# 2.5581000000000003e-18
C69 m4_107982_65100# w_107200_66216# 1.1378399999999999e-17
C70 m1_107200_67350# m2_107998_65100# 2.3884200000000004e-17
C71 m1_107200_67350# m2_107326_65100# 2.1664900000000002e-17
C72 m4_107214_65100# a_108402_65100# 9.3524300000000013e-22
C73 m1_107200_67424# m5_107200_66336# 1.4143500000000001e-18
C74 m4_107982_65100# m4_107598_65100# 5.3652999999999996e-16
C75 m4_107214_65100# a_108345_65100# 4.5276800000000007e-18
C76 m2_108190_65100# a_108402_65100# 2.0855700000000003e-18
C77 m4_107214_65100# m1_107200_66388# 2.3672700000000001e-18
C78 m2_108190_65100# a_108345_65100# 1.01416e-16
C79 a_108345_66276# m4_107214_65100# 5.7916999999999998e-18
C80 m2_108190_65100# m1_107200_66388# 4.0203900000000004e-20
C81 a_108389_67263# m4_107214_65100# 1.0530900000000002e-19
C82 m4_107214_65100# a_108332_65715# 1.4939600000000003e-17
C83 m1_107200_67350# m1_107200_66388# 2.3896500000000002e-17
C84 m4_107214_65100# w_107200_65100# 4.0374999999999995e-18
C85 m4_107214_65100# w_107200_67548# 5.92231e-19
C86 m4_107214_65100# w_107200_66216# 4.9793700000000006e-18
C87 m4_107982_65100# m3_107200_66002# 2.0485600000000002e-19
C88 a_108345_66276# m2_108190_65100# 1.1764e-16
C89 a_108345_66276# m1_107200_67350# 1.1850400000000001e-17
C90 m4_107214_65100# m4_107598_65100# 1.9293600000000002e-16
C91 a_108389_67263# m2_108190_65100# 1.1578200000000001e-17
C92 a_108332_65715# m2_108190_65100# 2.31152e-16
C93 w_107200_65100# m2_108190_65100# 1.8931300000000003e-17
C94 m2_108190_65100# w_107200_67548# 3.3428399999999998e-18
C95 m2_108190_65100# w_107200_66216# 3.0487600000000004e-17
C96 m1_107200_67350# a_108389_67263# 1.7539699999999999e-17
C97 m1_107200_67350# a_108332_65715# 8.5240000000000001e-16
C98 m1_107200_67350# w_107200_67548# 1.4063000000000002e-18
C99 m2_107998_65100# m5_107200_66336# 8.1286e-18
C100 m2_107326_65100# m5_107200_66336# 8.1952200000000019e-18
C101 m1_107200_67350# m4_107598_65100# 2.5642200000000004e-18
C102 m4_107214_65100# m3_107200_66002# 6.5634300000000008e-16
C103 m5_107200_66336# a_108345_65100# 5.1755800000000002e-18
C104 m1_107200_67424# m2_107998_65100# 2.49988e-17
C105 m1_107200_67424# m2_107326_65100# 2.2759100000000004e-17
C106 m2_108190_65100# m3_107200_66002# 8.4636000000000015e-20
C107 m1_107200_66388# m5_107200_66336# 1.1621500000000001e-17
C108 m1_107200_67350# m3_107200_66002# 1.5272800000000001e-18
C109 a_108345_66276# m5_107200_66336# 2.8862400000000001e-17
C110 m2_108190_65100# m4_107982_65100# 1.4945500000000001e-17
C111 a_108389_67263# m5_107200_66336# 3.5281500000000001e-19
C112 a_108332_65715# m5_107200_66336# 7.4302000000000009e-16
C113 m1_107200_67350# m4_107982_65100# 3.8046000000000005e-18
C114 w_107200_65100# m5_107200_66336# 4.8700000000000003e-18
C115 w_107200_67548# m5_107200_66336# 1.5137900000000001e-18
C116 m5_107200_66336# w_107200_66216# 2.0536599999999999e-17
C117 m4_107598_65100# m5_107200_66336# 1.98648e-16
C118 m1_107200_67424# m1_107200_66388# 2.4991099999999999e-17
C119 a_108345_66276# m1_107200_67424# 4.434400000000001e-19
C120 m1_107200_67424# a_108389_67263# 4.1616900000000002e-17
C121 m1_107200_67424# a_108332_65715# 7.302050000000001e-17
C122 m1_107200_67424# w_107200_66216# 8.5384699999999998e-20
C123 m1_107200_67424# w_107200_67548# 1.4178000000000003e-17
C124 m2_107326_65100# m2_107998_65100# 9.1264200000000011e-17
C125 m1_107200_67350# m4_107214_65100# 9.9906400000000019e-19
C126 m1_107200_67424# m4_107598_65100# 1.6285e-18
C127 m3_107200_66002# m5_107200_66336# 1.7783400000000002e-16
C128 m2_107998_65100# a_108402_65100# 3.1880400000000006e-20
C129 m1_107200_67350# m2_108190_65100# 2.4562000000000002e-17
C130 m2_107326_65100# a_108402_65100# 7.8486300000000013e-21
C131 m4_107982_65100# m5_107200_66336# 2.4036099999999999e-16
C132 a_22039_23093# a_22591_23093# 2.6329100000000002e-18
C133 a_22039_23093# a_20751_23093# 1.2163700000000001e-18
C134 m2_107998_65100# a_108345_65100# 7.6047300000000016e-17
C135 a_20751_23093# a_20000_23093# 2.6329100000000002e-18
C136 m2_107326_65100# a_108345_65100# 7.3327300000000006e-17
C137 m2_107998_65100# m1_107200_66388# 1.1905800000000002e-16
C138 m2_107326_65100# m1_107200_66388# 3.00859e-16
C139 m1_107200_67424# m3_107200_66002# 1.6020600000000002e-18
C140 a_108345_65100# a_108402_65100# 5.9348399999999998e-17
C141 a_108345_66276# m2_107998_65100# 7.9094400000000003e-17
C142 a_108345_66276# m2_107326_65100# 6.8070499999999998e-17
C143 a_108389_67263# m2_107998_65100# 5.5591599999999995e-19
C144 a_108332_65715# m2_107998_65100# 1.5544400000000001e-16
C145 a_108389_67263# m2_107326_65100# 1.10534e-19
C146 a_108332_65715# m2_107326_65100# 1.4475200000000002e-16
C147 w_107200_65100# m2_107998_65100# 3.3636200000000009e-17
C148 w_107200_67548# m2_107998_65100# 2.9277600000000006e-18
C149 m2_107998_65100# w_107200_66216# 4.7392200000000009e-17
C150 m2_107326_65100# w_107200_66216# 3.2141400000000004e-17
C151 w_107200_65100# m2_107326_65100# 3.1349100000000002e-17
C152 w_107200_67548# m2_107326_65100# 1.8978e-18
C153 m1_107200_67424# m4_107982_65100# 2.9948400000000002e-18
R0 a_108345_65100# a_108345_65100.n0 129.84100000000001
R1 a_108345_65100.n0 a_108345_65100.t3 125.364
R2 a_108345_65100.n0 a_108345_65100.n2 596.45299999999997
R3 a_108345_65100.n2 a_108345_65100.n1 19.430800781249999
R4 a_108345_65100.n2 a_108345_65100.n3 10.630000000000001
R5 a_108345_65100.n3 a_108345_65100.t0 252.012
R6 a_108345_65100.n3 a_108345_65100.t2 739.10000000000002
R7 a_108345_65100.n1 a_108345_65100.t1 219.089
R8 a_108345_65100.n1 a_108345_65100.t4 278.63200000000001
R9 a_108345_66276.n0 a_108345_66276.t4 278.63200000000001
R10 a_108345_66276.n0 a_108345_66276.t1 219.089
R11 a_108345_66276.n2 a_108345_66276.n1 191.50899999999999
R12 a_108345_66276.n1 a_108345_66276.n3 19.430499999999999
R13 a_108345_66276.n3 a_108345_66276.n0 19.430499999999999
R14 a_108345_66276.n3 a_108345_66276.n4 10.630000000000001
R15 a_108345_66276.n4 a_108345_66276.t0 252.012
R16 a_108345_66276.n4 a_108345_66276.t2 252.01300000000001
R17 a_108345_66276.n1 a_108345_66276.t5 278.63200000000001
R18 a_108345_66276# a_108345_66276.n2 28.565000000000001
R19 a_108345_66276.n2 a_108345_66276.t3 27.579999999999998
R20 a_108332_65715.n0 a_108332_65715.t5 249.82400000000001
R21 a_108332_65715.n1 a_108332_65715.n0 5.8117202148437501
R22 a_108332_65715.n5 a_108332_65715.n6 4.5
R23 a_108332_65715.n7 a_108332_65715.n8 4.5
R24 a_108332_65715.n9 a_108332_65715.n10 4.5
R25 a_108332_65715.n11 a_108332_65715.n12 4.5
R26 a_108332_65715.n11 a_108332_65715.n1 0.91030798339843755
R27 a_108332_65715.n9 a_108332_65715.n11 0.083333297729492189
R28 a_108332_65715.n7 a_108332_65715.n9 0.083333297729492189
R29 a_108332_65715.n5 a_108332_65715.n7 0.083333297729492189
R30 a_108332_65715.n4 a_108332_65715.n5 2.3277700195312501
R31 a_108332_65715.n14 a_108332_65715.n13 3.4100000000000001
R32 a_108332_65715.n16 a_108332_65715.n15 3.4100000000000001
R33 a_108332_65715.n18 a_108332_65715.n17 3.4100000000000001
R34 a_108332_65715.n12 a_108332_65715.n10 0.10810800170898438
R35 a_108332_65715.n13 a_108332_65715.n10 0.027027000427246095
R36 a_108332_65715.n13 a_108332_65715.n8 0.081081100463867184
R37 a_108332_65715.n8 a_108332_65715.n15 0.054054100036621096
R38 a_108332_65715.n15 a_108332_65715.n6 0.054054100036621096
R39 a_108332_65715.n17 a_108332_65715.n6 0.081081100463867184
R40 a_108332_65715.n17 a_108332_65715.n4 0.080455200195312507
R41 a_108332_65715.n21 a_108332_65715.n20 1.6913800048828125
R42 a_108332_65715.n21 a_108332_65715.n19 1.6913800048828125
R43 a_108332_65715.n19 a_108332_65715.n14 0.028748899459838866
R44 a_108332_65715.n16 a_108332_65715.n21 3.4100000000000001
R45 a_108332_65715.n20 a_108332_65715.n18 0.028748899459838866
R46 a_108332_65715.n19 a_108332_65715.n12 3.4387500000000002
R47 a_108332_65715.n14 a_108332_65715.n16 0.056969699859619138
R48 a_108332_65715.n18 a_108332_65715.n16 0.056969699859619138
R49 a_108332_65715.n20 a_108332_65715.n4 3.493159912109375
R50 a_108332_65715.n23 a_108332_65715.n22 3.4100000000000001
R51 a_108332_65715.n25 a_108332_65715.n24 0.028748899459838866
R52 a_108332_65715.n25 a_108332_65715.n22 1.6913800048828125
R53 a_108332_65715.n27 a_108332_65715.n22 1.6913800048828125
R54 a_108332_65715.n22 a_108332_65715.n21 0.15650999450683595
R55 a_108332_65715.n29 a_108332_65715.n23 3.4100000000000001
R56 a_108332_65715.n30 a_108332_65715.n24 3.4100000000000001
R57 a_108332_65715.n31 a_108332_65715.n26 3.4100000000000001
R58 a_108332_65715.n46 a_108332_65715.n28 3.4100000000000001
R59 a_108332_65715.n24 a_108332_65715.n23 0.056969699859619138
R60 a_108332_65715.n26 a_108332_65715.n25 0.028748899459838866
R61 a_108332_65715.n28 a_108332_65715.n26 0.056969699859619138
R62 a_108332_65715.n28 a_108332_65715.n27 0.028748899459838866
R63 a_108332_65715.n33 a_108332_65715.n34 4.5
R64 a_108332_65715.n35 a_108332_65715.n36 4.5
R65 a_108332_65715.n37 a_108332_65715.n38 4.5
R66 a_108332_65715.n45 a_108332_65715.n29 4.5
R67 a_108332_65715.n38 a_108332_65715.n29 0.10810800170898438
R68 a_108332_65715.n30 a_108332_65715.n38 0.027027000427246095
R69 a_108332_65715.n36 a_108332_65715.n30 0.081081100463867184
R70 a_108332_65715.n31 a_108332_65715.n36 0.054054100036621096
R71 a_108332_65715.n34 a_108332_65715.n31 0.054054100036621096
R72 a_108332_65715.n46 a_108332_65715.n34 0.081081100463867184
R73 a_108332_65715.n32 a_108332_65715.n46 0.080455200195312507
R74 a_108332_65715.n32 a_108332_65715.n27 3.493159912109375
R75 a_108332_65715.n45 a_108332_65715.n37 0.083333297729492189
R76 a_108332_65715.n37 a_108332_65715.n35 0.083333297729492189
R77 a_108332_65715.n35 a_108332_65715.n33 0.083333297729492189
R78 a_108332_65715.n33 a_108332_65715.n32 2.3277700195312501
R79 a_108332_65715.n39 a_108332_65715.n40 3.9453701171875002
R80 a_108332_65715.n39 a_108332_65715.n45 0.91030798339843755
R81 a_108332_65715.n44 a_108332_65715.n43 209.82400000000001
R82 a_108332_65715# a_108332_65715.n44 41.428601562499999
R83 a_108332_65715.n44 a_108332_65715.t7 40
R84 a_108332_65715.n43 a_108332_65715.t3 249.82400000000001
R85 a_108332_65715.n43 a_108332_65715.n39 5.8117202148437501
R86 a_108332_65715.n40 a_108332_65715.n42 14.371900390624999
R87 a_108332_65715.n40 a_108332_65715.n41 14.371900390624999
R88 a_108332_65715.n42 a_108332_65715.t10 271.81400000000002
R89 a_108332_65715.n42 a_108332_65715.t6 225
R90 a_108332_65715.n41 a_108332_65715.t2 225
R91 a_108332_65715.n41 a_108332_65715.t9 271.81400000000002
R92 a_108332_65715.n1 a_108332_65715.n2 3.9453701171875002
R93 a_108332_65715.n2 a_108332_65715.n3 14.371900390624999
R94 a_108332_65715.n2 a_108332_65715.t0 239.37200000000001
R95 a_108332_65715.n3 a_108332_65715.t8 271.81400000000002
R96 a_108332_65715.n3 a_108332_65715.t4 225
R97 a_108332_65715.n0 a_108332_65715.t1 249.82400000000001
R98 w_19964_21727.n0 w_19964_21727.t1 804.73099999999999
R99 w_19964_21727.t1 w_19964_21727.n0 751.69200000000001
R100 w_19964_21727.n0 w_19964_21727.t8 388.65499999999997
R101 w_19964_21727.n1 w_19964_21727.n2 9.3000000000000007
R102 w_19964_21727.n3 w_19964_21727.n51 4.1059599609374997
R103 w_19964_21727.n3 w_19964_21727.n0 5.5688198242187497
R104 w_19964_21727.n0 w_19964_21727.n1 0.1634040069580078
R105 w_19964_21727.n51 w_19964_21727.t19 279.48099999999999
R106 w_19964_21727.n51 w_19964_21727.t23 279.48099999999999
R107 w_19964_21727.n1 w_19964_21727.n4 13.9662998046875
R108 w_19964_21727.n7 w_19964_21727.n4 1.4404599609375
R109 w_19964_21727.n9 w_19964_21727.n7 0.40968701171874999
R110 w_19964_21727.n4 w_19964_21727.n6 3.17343994140625
R111 w_19964_21727.n4 w_19964_21727.n5 3.17343994140625
R112 w_19964_21727.n8 w_19964_21727.n9 9.3000000000000007
R113 w_19964_21727.n10 w_19964_21727.n11 9.3000000000000007
R114 w_19964_21727.n12 w_19964_21727.n13 9.3000000000000007
R115 w_19964_21727.n14 w_19964_21727.n15 9.3000000000000007
R116 w_19964_21727.n16 w_19964_21727.n17 9.3000000000000007
R117 w_19964_21727.n18 w_19964_21727.n19 9.3000000000000007
R118 w_19964_21727.n22 w_19964_21727.n20 9.3000000000000007
R119 w_19964_21727.n25 w_19964_21727.n24 3.0481101074218748
R120 w_19964_21727.n25 w_19964_21727.n27 0.41622500610351565
R121 w_19964_21727.n27 w_19964_21727.n26 2.2526201171875
R122 w_19964_21727.n27 w_19964_21727.n28 1.68225
R123 w_19964_21727.n2 w_19964_21727.n3 0.71329498291015625
R124 w_19964_21727.n7 w_19964_21727.n2 0.40790399169921876
R125 w_19964_21727.n11 w_19964_21727.n9 0.11979199981689453
R126 w_19964_21727.n13 w_19964_21727.n11 0.11979199981689453
R127 w_19964_21727.n15 w_19964_21727.n13 0.11979199981689453
R128 w_19964_21727.n17 w_19964_21727.n15 0.11979199981689453
R129 w_19964_21727.n19 w_19964_21727.n17 0.11979199981689453
R130 w_19964_21727.n20 w_19964_21727.n19 0.11979199981689453
R131 w_19964_21727.n20 w_19964_21727.n25 0.23888099670410157
R132 w_19964_21727.n28 w_19964_21727.t12 395.90899999999999
R133 w_19964_21727.n30 w_19964_21727.n50 3.1075100097656252
R134 w_19964_21727.n28 w_19964_21727.n30 2.68825
R135 w_19964_21727.n28 w_19964_21727.n29 3.17343994140625
R136 w_19964_21727.n50 w_19964_21727.n49 9.2307695312500009
R137 w_19964_21727.n50 w_19964_21727.n31 156.80000000000001
R138 w_19964_21727.n32 w_19964_21727.n49 164.80000000000001
R139 w_19964_21727.n49 w_19964_21727.n48 46.079999999999998
R140 w_19964_21727.n48 w_19964_21727.n30 19.017099609374998
R141 w_19964_21727.n48 w_19964_21727.n35 0.65345300292968755
R142 w_19964_21727.n36 w_19964_21727.n48 3.2672700195312498
R143 w_19964_21727.n26 w_19964_21727.n36 2.9213200683593752
R144 w_19964_21727.n26 w_19964_21727.n33 2.9213200683593752
R145 w_19964_21727.n33 w_19964_21727.n38 1.2684699707031251
R146 w_19964_21727.n38 w_19964_21727.n34 2.65225
R147 w_19964_21727.n34 w_19964_21727.n47 13.8682001953125
R148 w_19964_21727.n24 w_19964_21727.n39 5.2583798828125001
R149 w_19964_21727.n39 w_19964_21727.n38 2.283239990234375
R150 w_19964_21727.n38 w_19964_21727.n40 4.7740498046875004
R151 w_19964_21727.n40 w_19964_21727.n47 7.5416201171874997
R152 w_19964_21727.n43 w_19964_21727.n41 3.8399999999999999
R153 w_19964_21727.n42 w_19964_21727.n43 4.2666699218749997
R154 w_19964_21727.n24 w_19964_21727.n42 6.2108798828124998
R155 w_19964_21727.n46 w_19964_21727.n41 63.061300781249997
R156 w_19964_21727.n44 w_19964_21727.n46 16.417400390625001
R157 w_19964_21727.n43 w_19964_21727.n44 6.2608701171875003
R158 w_19964_21727.n43 w_19964_21727.n45 6.9565200195312498
R159 w_19964_21727.n24 w_19964_21727.n45 10.573900390625001
R160 w_19964_21727.n46 w_19964_21727.t25 236.22999999999999
R161 w_19964_21727.n44 w_19964_21727.t18 725.173
R162 w_19964_21727.t18 w_19964_21727.n45 804.73099999999999
R163 w_19964_21727.n41 w_19964_21727.t17 725.173
R164 w_19964_21727.t17 w_19964_21727.n42 804.73099999999999
R165 w_19964_21727.n39 w_19964_21727.t7 804.73099999999999
R166 w_19964_21727.n40 w_19964_21727.t7 751.69200000000001
R167 w_19964_21727.n47 w_19964_21727.t21 128.52000000000001
R168 w_19964_21727.n35 w_19964_21727.n37 125.068
R169 w_19964_21727.n37 w_19964_21727.n32 32.461199218749996
R170 w_19964_21727.n32 w_19964_21727.n31 62.955101562499998
R171 w_19964_21727.n37 w_19964_21727.t26 107.79300000000001
R172 w_19964_21727.n31 w_19964_21727.t26 571.74400000000003
R173 w_19964_21727.n35 w_19964_21727.t13 751.69200000000001
R174 w_19964_21727.t13 w_19964_21727.n36 804.73099999999999
R175 w_19964_21727.n33 w_19964_21727.t6 804.73099999999999
R176 w_19964_21727.n34 w_19964_21727.t6 751.69200000000001
R177 w_19964_21727.n29 w_19964_21727.t10 388.02699999999999
R178 w_19964_21727.n29 w_19964_21727.t22 105.64400000000001
R179 w_19964_21727.n22 w_19964_21727.n24 12.800000000000001
R180 w_19964_21727.n23 w_19964_21727.n22 106.56
R181 w_19964_21727.t0 w_19964_21727.t2 1557.5999999999999
R182 w_19964_21727.t2 w_19964_21727.n23 1003.71
R183 w_19964_21727.n23 w_19964_21727.t16 308.834
R184 w_19964_21727.t16 w_19964_21727.t5 386.04199999999997
R185 w_19964_21727.t5 w_19964_21727.t11 772.08500000000004
R186 w_19964_21727.t11 w_19964_21727.t9 417.93299999999999
R187 w_19964_21727# w_19964_21727.t0 3742.6500000000001
R188 w_19964_21727.n21 w_19964_21727.t3 388.65499999999997
R189 w_19964_21727.n21 w_19964_21727.t14 388.65499999999997
R190 w_19964_21727.n4 w_19964_21727.n8 1.661280029296875
R191 w_19964_21727.n8 w_19964_21727.n10 2.505530029296875
R192 w_19964_21727.n10 w_19964_21727.n12 2.505530029296875
R193 w_19964_21727.n12 w_19964_21727.n14 2.505530029296875
R194 w_19964_21727.n16 w_19964_21727.n14 2.505530029296875
R195 w_19964_21727.n21 w_19964_21727.n16 2.3421298828124999
R196 w_19964_21727.n18 w_19964_21727.n21 0.1634040069580078
R197 w_19964_21727.n22 w_19964_21727.n18 13.5897998046875
R198 w_19964_21727.n6 w_19964_21727.t24 147.851
R199 w_19964_21727.n6 w_19964_21727.t15 388.02699999999999
R200 w_19964_21727.n5 w_19964_21727.t4 388.02699999999999
R201 w_19964_21727.n5 w_19964_21727.t20 147.851
R202 w_19964_23083.t4 w_19964_23083.n0 656.01199999999994
R203 w_19964_23083.n1 w_19964_23083.n0 4.6207402343749999
R204 w_19964_23083.n0 w_19964_23083.n2 3.7978000488281252
R205 w_19964_23083.n4 w_19964_23083.t9 388.65499999999997
R206 w_19964_23083.n6 w_19964_23083.n5 9.3000000000000007
R207 w_19964_23083.n8 w_19964_23083.n7 9.3000000000000007
R208 w_19964_23083.n10 w_19964_23083.n9 9.3000000000000007
R209 w_19964_23083.n12 w_19964_23083.n11 9.3000000000000007
R210 w_19964_23083.n2 w_19964_23083.n5 6.6332402343750001
R211 w_19964_23083.n5 w_19964_23083.n3 0.21157000732421874
R212 w_19964_23083.n3 w_19964_23083.n7 3.032510009765625
R213 w_19964_23083.n7 w_19964_23083.n9 3.2440800781250001
R214 w_19964_23083.n9 w_19964_23083.n4 3.032510009765625
R215 w_19964_23083.n11 w_19964_23083.n4 0.21157000732421874
R216 w_19964_23083.n13 w_19964_23083.t18 388.65499999999997
R217 w_19964_23083.n15 w_19964_23083.n14 152
R218 w_19964_23083.n17 w_19964_23083.n16 152
R219 w_19964_23083.n19 w_19964_23083.n18 152
R220 w_19964_23083.n23 w_19964_23083.n22 9.3000000000000007
R221 w_19964_23083.n24 w_19964_23083.n25 9.3000000000000007
R222 w_19964_23083.n26 w_19964_23083.n27 9.3000000000000007
R223 w_19964_23083.n28 w_19964_23083.n29 9.3000000000000007
R224 w_19964_23083.n30 w_19964_23083.n31 9.3000000000000007
R225 w_19964_23083.n32 w_19964_23083.n33 9.3000000000000007
R226 w_19964_23083.n11 w_19964_23083.n22 4.8797001953125001
R227 w_19964_23083.n22 w_19964_23083.n13 0.16445399475097655
R228 w_19964_23083.n13 w_19964_23083.n21 1.7541800537109375
R229 w_19964_23083.n24 w_19964_23083.n21 0.60299798583984376
R230 w_19964_23083.n26 w_19964_23083.n24 2.5216298828124999
R231 w_19964_23083.n19 w_19964_23083.n26 0.38372601318359373
R232 w_19964_23083.n28 w_19964_23083.n19 2.1378999023437499
R233 w_19964_23083.n17 w_19964_23083.n28 1.3704499511718751
R234 w_19964_23083.n30 w_19964_23083.n17 1.1511800537109376
R235 w_19964_23083.n15 w_19964_23083.n30 2.3571699218750002
R236 w_19964_23083.n32 w_19964_23083.n15 0.16445399475097655
R237 w_19964_23083.n69 w_19964_23083.n32 0.84967901611328123
R238 w_19964_23083.n34 w_19964_23083.n35 4.6207402343749999
R239 w_19964_23083.n69 w_19964_23083.n34 3.7978000488281252
R240 w_19964_23083.n36 w_19964_23083.n37 9.3000000000000007
R241 w_19964_23083.n38 w_19964_23083.n39 9.3000000000000007
R242 w_19964_23083.n36 w_19964_23083.n69 7.0681298828125003
R243 w_19964_23083.n36 w_19964_23083.n38 4.6730200195312497
R244 w_19964_23083.n42 w_19964_23083.n41 4.6207402343749999
R245 w_19964_23083.n40 w_19964_23083.n41 7.93372021484375
R246 w_19964_23083.n41 w_19964_23083.n68 4.6933300781250002
R247 w_19964_23083.n67 w_19964_23083.n68 3.0896599121093749
R248 w_19964_23083.n46 w_19964_23083.n45 2.2526201171875
R249 w_19964_23083.n46 w_19964_23083.n49 0.35758700561523438
R250 w_19964_23083.n47 w_19964_23083.n44 0.3193500061035156
R251 w_19964_23083.n43 w_19964_23083.n47 3.2672700195312498
R252 w_19964_23083.n45 w_19964_23083.n43 2.9213200683593752
R253 w_19964_23083.n45 w_19964_23083.n67 2.1141101074218751
R254 w_19964_23083.n44 w_19964_23083.t21 149.13399999999999
R255 w_19964_23083.n49 w_19964_23083.n48 4.6207402343749999
R256 w_19964_23083.n47 w_19964_23083.n66 9.0702001953125002
R257 w_19964_23083.n66 w_19964_23083.n48 4.57747998046875
R258 w_19964_23083.n50 w_19964_23083.n66 5.88997998046875
R259 w_19964_23083.n50 w_19964_23083.t1 392.06700000000001
R260 w_19964_23083.n49 w_19964_23083.n50 0.60595202636718748
R261 w_19964_23083.n51 w_19964_23083.n52 9.3000000000000007
R262 w_19964_23083.n54 w_19964_23083.n53 9.3000000000000007
R263 w_19964_23083.n55 w_19964_23083.n56 9.3000000000000007
R264 w_19964_23083.n56 w_19964_23083.n65 4.2445000000000004
R265 w_19964_23083.n54 w_19964_23083.n56 0.11979199981689453
R266 w_19964_23083.n52 w_19964_23083.n54 0.11979199981689453
R267 w_19964_23083.n1 w_19964_23083.n52 0.17980400085449219
R268 w_19964_23083.n6 w_19964_23083.n1 0.17980400085449219
R269 w_19964_23083.n8 w_19964_23083.n6 0.11979199981689453
R270 w_19964_23083.n10 w_19964_23083.n8 0.11979199981689453
R271 w_19964_23083.n12 w_19964_23083.n10 0.11979199981689453
R272 w_19964_23083.n23 w_19964_23083.n12 0.11979199981689453
R273 w_19964_23083.n25 w_19964_23083.n23 0.11979199981689453
R274 w_19964_23083.n27 w_19964_23083.n25 0.11979199981689453
R275 w_19964_23083.n29 w_19964_23083.n27 0.11979199981689453
R276 w_19964_23083.n31 w_19964_23083.n29 0.11979199981689453
R277 w_19964_23083.n33 w_19964_23083.n31 0.11979199981689453
R278 w_19964_23083.n35 w_19964_23083.n33 0.17980400085449219
R279 w_19964_23083.n37 w_19964_23083.n35 0.17980400085449219
R280 w_19964_23083.n37 w_19964_23083.n39 0.11979199981689453
R281 w_19964_23083.n39 w_19964_23083.n42 0.17980400085449219
R282 w_19964_23083.n42 w_19964_23083.n46 0.35680398559570314
R283 w_19964_23083.n58 w_19964_23083.n57 152
R284 w_19964_23083.n60 w_19964_23083.n59 152
R285 w_19964_23083.n62 w_19964_23083.n61 152
R286 w_19964_23083.n64 w_19964_23083.t10 625.404
R287 w_19964_23083.n65 w_19964_23083.n64 1.7217499999999999
R288 w_19964_23083.n65 w_19964_23083.n62 1.4882500000000001
R289 w_19964_23083.n62 w_19964_23083.n55 2.1378999023437499
R290 w_19964_23083.n55 w_19964_23083.n60 1.3704499511718751
R291 w_19964_23083.n60 w_19964_23083.n53 1.1511800537109376
R292 w_19964_23083.n53 w_19964_23083.n58 2.3571699218750002
R293 w_19964_23083.n51 w_19964_23083.n58 0.16445399475097655
R294 w_19964_23083.n2 w_19964_23083.n51 0.84967901611328123
R295 w_19964_23083.n64 w_19964_23083.n61 214.95500000000001
R296 w_19964_23083.n61 w_19964_23083.n63 30.493900390625001
R297 w_19964_23083.n63 w_19964_23083.n59 32.461199218749996
R298 w_19964_23083.n59 w_19964_23083.n57 62.955101562499998
R299 w_19964_23083.n63 w_19964_23083.t19 107.79300000000001
R300 w_19964_23083.n57 w_19964_23083.t19 571.74400000000003
R301 w_19964_23083.n48 w_19964_23083.t15 657.10900000000004
R302 w_19964_23083.n44 w_19964_23083.t2 752.02599999999995
R303 w_19964_23083.t2 w_19964_23083.n43 804.73099999999999
R304 w_19964_23083.n67 w_19964_23083.t6 651.47400000000005
R305 w_19964_23083.n38 w_19964_23083.n40 4.5635498046874998
R306 w_19964_23083.n40 w_19964_23083.t17 389.51999999999998
R307 w_19964_23083.n68 w_19964_23083.t7 652.45899999999995
R308 w_19964_23083.t16 w_19964_23083.n36 1079.21
R309 w_19964_23083.t8 w_19964_23083.t11 820.35799999999995
R310 w_19964_23083.t11 w_19964_23083.t16 429.30599999999998
R311 w_19964_23083.t16 w_19964_23083.t5 429.30599999999998
R312 w_19964_23083.t5 w_19964_23083.t0 233.78100000000001
R313 w_19964_23083.t0 w_19964_23083.t14 176.398
R314 w_19964_23083.t3 w_19964_23083.t8 55.257300781250002
R315 w_19964_23083# w_19964_23083.t3 2634.6399999999999
R316 w_19964_23083.n34 w_19964_23083.t12 656.01199999999994
R317 w_19964_23083.n21 w_19964_23083.n18 214.95500000000001
R318 w_19964_23083.n18 w_19964_23083.n20 30.493900390625001
R319 w_19964_23083.n16 w_19964_23083.n20 32.461199218749996
R320 w_19964_23083.n16 w_19964_23083.n14 62.955101562499998
R321 w_19964_23083.n20 w_19964_23083.t20 107.79300000000001
R322 w_19964_23083.n14 w_19964_23083.t20 571.74400000000003
R323 w_19964_23083.n3 w_19964_23083.t13 650.66700000000003
R324 w_107200_65100# w_107200_65100.t1 13.731900390625
R325 w_107200_65100.t1 w_107200_65100.t0 168.52799999999999
R326 w_107200_66216# w_107200_66216.t0 99.868601562500004
R327 w_107200_66216.t0 w_107200_66216.t1 217.214
R328 a_20000_21737.t29 a_20000_21737.n189 214.45500000000001
R329 a_20000_21737.n1 a_20000_21737.n0 4.6207402343749999
R330 a_20000_21737.n2 a_20000_21737.n189 3.718919921875
R331 a_20000_21737.n0 a_20000_21737.n2 4.4972998046874997
R332 a_20000_21737.n0 a_20000_21737.n3 11.1567998046875
R333 a_20000_21737.n3 a_20000_21737.t34 120.17100000000001
R334 a_20000_21737.n6 a_20000_21737.n5 2.2524299316406249
R335 a_20000_21737.n5 a_20000_21737.n188 2.9597600097656249
R336 a_20000_21737.n5 a_20000_21737.n4 3.6516499023437499
R337 a_20000_21737.n4 a_20000_21737.n3 1.3069100341796875
R338 a_20000_21737.n8 a_20000_21737.n9 9.3000000000000007
R339 a_20000_21737.n11 a_20000_21737.n10 9.3000000000000007
R340 a_20000_21737.n188 a_20000_21737.n8 3.430929931640625
R341 a_20000_21737.n8 a_20000_21737.n7 0.22456100463867187
R342 a_20000_21737.n7 a_20000_21737.n10 3.2187099609374998
R343 a_20000_21737.n13 a_20000_21737.n12 152
R344 a_20000_21737.n15 a_20000_21737.n14 152
R345 a_20000_21737.n17 a_20000_21737.n16 152
R346 a_20000_21737.n19 a_20000_21737.n18 9.3000000000000007
R347 a_20000_21737.n21 a_20000_21737.n20 9.3000000000000007
R348 a_20000_21737.n23 a_20000_21737.n22 9.3000000000000007
R349 a_20000_21737.n25 a_20000_21737.n24 9.3000000000000007
R350 a_20000_21737.n10 a_20000_21737.n18 3.2076398925781251
R351 a_20000_21737.n18 a_20000_21737.n17 0.28699600219726562
R352 a_20000_21737.n17 a_20000_21737.n20 2.3533601074218748
R353 a_20000_21737.n20 a_20000_21737.n15 1.3201800537109376
R354 a_20000_21737.n22 a_20000_21737.n15 1.3201800537109376
R355 a_20000_21737.n22 a_20000_21737.n13 2.3533601074218748
R356 a_20000_21737.n24 a_20000_21737.n13 0.28699600219726562
R357 a_20000_21737.n24 a_20000_21737.n187 1.865469970703125
R358 a_20000_21737.n29 a_20000_21737.n28 4.6207402343749999
R359 a_20000_21737.n187 a_20000_21737.n26 3.718919921875
R360 a_20000_21737.n28 a_20000_21737.n187 4.4972998046874997
R361 a_20000_21737.n28 a_20000_21737.n30 11.1567998046875
R362 a_20000_21737.n31 a_20000_21737.n87 4.6207402343749999
R363 a_20000_21737.n31 a_20000_21737.n30 7.57431005859375
R364 a_20000_21737.n186 a_20000_21737.n31 1195.49
R365 a_20000_21737.t6 a_20000_21737.t28 1618.3900000000001
R366 a_20000_21737.t25 a_20000_21737.t6 6203.8299999999999
R367 a_20000_21737.t3 a_20000_21737.t25 3101.9200000000001
R368 a_20000_21737.n186 a_20000_21737.t3 1938.7
R369 a_20000_21737.t22 a_20000_21737.n186 3489.6599999999999
R370 a_20000_21737.t0 a_20000_21737.t22 3877.3899999999999
R371 a_20000_21737.t20 a_20000_21737.t0 2098.8499999999999
R372 a_20000_21737.n184 a_20000_21737.t20 19370.099999999999
R373 a_20000_21737.n184 a_20000_21737.n185 7752.1300000000001
R374 a_20000_21737.n185 a_20000_21737.t33 367.14800000000002
R375 a_20000_21737.n185 a_20000_21737.t31 367.14800000000002
R376 a_20000_21737.n185 a_20000_21737.t32 367.14800000000002
R377 a_20000_21737.n185 a_20000_21737.t30 367.14800000000002
R378 a_20000_21737.t15 a_20000_21737.t18 2400.4699999999998
R379 a_20000_21737.n88 a_20000_21737.t15 1546.8499999999999
R380 a_20000_21737.n88 a_20000_21737.t12 475.95499999999998
R381 a_20000_21737.t12 a_20000_21737.t9 1784.8299999999999
R382 a_20000_21737.t9 a_20000_21737.n184 19529
R383 a_20000_21737.n183 a_20000_21737.n89 9.3000000000000007
R384 a_20000_21737.n89 a_20000_21737.n88 1198.25
R385 a_20000_21737.n91 a_20000_21737.n90 9.3000000000000007
R386 a_20000_21737.n93 a_20000_21737.n92 9.3000000000000007
R387 a_20000_21737.n95 a_20000_21737.n94 9.3000000000000007
R388 a_20000_21737.n97 a_20000_21737.n96 9.3000000000000007
R389 a_20000_21737.n99 a_20000_21737.n98 9.3000000000000007
R390 a_20000_21737.n101 a_20000_21737.n100 9.3000000000000007
R391 a_20000_21737.n103 a_20000_21737.n102 9.3000000000000007
R392 a_20000_21737.n105 a_20000_21737.n104 9.3000000000000007
R393 a_20000_21737.n107 a_20000_21737.n106 9.3000000000000007
R394 a_20000_21737.n109 a_20000_21737.n108 9.3000000000000007
R395 a_20000_21737.n111 a_20000_21737.n110 9.3000000000000007
R396 a_20000_21737.n113 a_20000_21737.n112 9.3000000000000007
R397 a_20000_21737.n115 a_20000_21737.n114 9.3000000000000007
R398 a_20000_21737.n117 a_20000_21737.n116 9.3000000000000007
R399 a_20000_21737.n119 a_20000_21737.n118 9.3000000000000007
R400 a_20000_21737.n121 a_20000_21737.n120 9.3000000000000007
R401 a_20000_21737.n123 a_20000_21737.n122 9.3000000000000007
R402 a_20000_21737.n125 a_20000_21737.n124 9.3000000000000007
R403 a_20000_21737.n127 a_20000_21737.n126 9.3000000000000007
R404 a_20000_21737.n129 a_20000_21737.n128 9.3000000000000007
R405 a_20000_21737.n131 a_20000_21737.n130 9.3000000000000007
R406 a_20000_21737.n133 a_20000_21737.n132 9.3000000000000007
R407 a_20000_21737.n135 a_20000_21737.n134 9.3000000000000007
R408 a_20000_21737.n137 a_20000_21737.n136 9.3000000000000007
R409 a_20000_21737.n139 a_20000_21737.n138 9.3000000000000007
R410 a_20000_21737.n141 a_20000_21737.n140 9.3000000000000007
R411 a_20000_21737.n155 a_20000_21737.n156 9.3000000000000007
R412 a_20000_21737.n157 a_20000_21737.n158 9.3000000000000007
R413 a_20000_21737.n159 a_20000_21737.n160 9.3000000000000007
R414 a_20000_21737.n161 a_20000_21737.n162 9.3000000000000007
R415 a_20000_21737.n163 a_20000_21737.n162 3.2858898925781248
R416 a_20000_21737.n162 a_20000_21737.n160 0.11979199981689453
R417 a_20000_21737.n160 a_20000_21737.n158 0.11979199981689453
R418 a_20000_21737.n158 a_20000_21737.n156 0.11979199981689453
R419 a_20000_21737.n156 a_20000_21737.n91 0.11979199981689453
R420 a_20000_21737.n91 a_20000_21737.n93 0.11979199981689453
R421 a_20000_21737.n93 a_20000_21737.n95 0.11979199981689453
R422 a_20000_21737.n95 a_20000_21737.n97 0.11979199981689453
R423 a_20000_21737.n97 a_20000_21737.n99 0.11979199981689453
R424 a_20000_21737.n99 a_20000_21737.n101 0.11979199981689453
R425 a_20000_21737.n101 a_20000_21737.n103 0.11979199981689453
R426 a_20000_21737.n103 a_20000_21737.n105 0.11979199981689453
R427 a_20000_21737.n105 a_20000_21737.n107 0.11979199981689453
R428 a_20000_21737.n107 a_20000_21737.n109 0.11979199981689453
R429 a_20000_21737.n109 a_20000_21737.n111 0.11979199981689453
R430 a_20000_21737.n111 a_20000_21737.n113 0.11979199981689453
R431 a_20000_21737.n113 a_20000_21737.n183 0.11979199981689453
R432 a_20000_21737.n183 a_20000_21737.n115 0.11979199981689453
R433 a_20000_21737.n115 a_20000_21737.n117 0.11979199981689453
R434 a_20000_21737.n117 a_20000_21737.n119 0.11979199981689453
R435 a_20000_21737.n119 a_20000_21737.n121 0.11979199981689453
R436 a_20000_21737.n121 a_20000_21737.n123 0.11979199981689453
R437 a_20000_21737.n123 a_20000_21737.n125 0.11979199981689453
R438 a_20000_21737.n125 a_20000_21737.n127 0.11979199981689453
R439 a_20000_21737.n127 a_20000_21737.n129 0.11979199981689453
R440 a_20000_21737.n129 a_20000_21737.n131 0.11979199981689453
R441 a_20000_21737.n131 a_20000_21737.n133 0.11979199981689453
R442 a_20000_21737.n133 a_20000_21737.n135 0.11979199981689453
R443 a_20000_21737.n135 a_20000_21737.n137 0.11979199981689453
R444 a_20000_21737.n137 a_20000_21737.n139 0.11979199981689453
R445 a_20000_21737.n139 a_20000_21737.n141 0.11979199981689453
R446 a_20000_21737.n165 a_20000_21737.n166 152
R447 a_20000_21737.n167 a_20000_21737.n168 152
R448 a_20000_21737.n171 a_20000_21737.n163 153.22399999999999
R449 a_20000_21737.n168 a_20000_21737.n163 3.7269799804687498
R450 a_20000_21737.n168 a_20000_21737.n161 2.0164399414062499
R451 a_20000_21737.n161 a_20000_21737.n166 3.5945200195312501
R452 a_20000_21737.n166 a_20000_21737.n159 0.43835598754882815
R453 a_20000_21737.n159 a_20000_21737.n157 4.0328798828124999
R454 a_20000_21737.n157 a_20000_21737.n164 1.13972998046875
R455 a_20000_21737.n164 a_20000_21737.n172 2.630139892578125
R456 a_20000_21737.n172 a_20000_21737.n155 0.26301400756835935
R457 a_20000_21737.n155 a_20000_21737.n90 16.354099609375002
R458 a_20000_21737.n90 a_20000_21737.n173 0.40851098632812499
R459 a_20000_21737.n173 a_20000_21737.n92 5.8553198242187499
R460 a_20000_21737.n92 a_20000_21737.n94 6.2638300781250003
R461 a_20000_21737.n94 a_20000_21737.n96 6.2638300781250003
R462 a_20000_21737.n96 a_20000_21737.n98 6.2638300781250003
R463 a_20000_21737.n98 a_20000_21737.n100 6.2638300781250003
R464 a_20000_21737.n176 a_20000_21737.n175 152
R465 a_20000_21737.n178 a_20000_21737.n177 152
R466 a_20000_21737.n181 a_20000_21737.n180 152
R467 a_20000_21737.n100 a_20000_21737.n102 5.6090898437499996
R468 a_20000_21737.n102 a_20000_21737.n181 0.43835598754882815
R469 a_20000_21737.n181 a_20000_21737.n104 3.5945200195312501
R470 a_20000_21737.n104 a_20000_21737.n178 2.0164399414062499
R471 a_20000_21737.n178 a_20000_21737.n106 2.0164399414062499
R472 a_20000_21737.n106 a_20000_21737.n176 3.5945200195312501
R473 a_20000_21737.n108 a_20000_21737.n176 0.43835598754882815
R474 a_20000_21737.n108 a_20000_21737.n110 4.0328798828124999
R475 a_20000_21737.n110 a_20000_21737.n174 1.13972998046875
R476 a_20000_21737.n174 a_20000_21737.n182 2.630139892578125
R477 a_20000_21737.n112 a_20000_21737.n182 0.26301400756835935
R478 a_20000_21737.n112 a_20000_21737.n89 14.0712001953125
R479 a_20000_21737.n182 a_20000_21737.t16 214.45500000000001
R480 a_20000_21737.n180 a_20000_21737.n177 62.955101562499998
R481 a_20000_21737.n177 a_20000_21737.n179 31.477599609375002
R482 a_20000_21737.n175 a_20000_21737.n179 31.477599609375002
R483 a_20000_21737.n175 a_20000_21737.n174 214.95500000000001
R484 a_20000_21737.n179 a_20000_21737.t42 68.698898437500006
R485 a_20000_21737.t42 a_20000_21737.n180 538.31200000000001
R486 a_20000_21737.n173 a_20000_21737.t17 214.45500000000001
R487 a_20000_21737.n172 a_20000_21737.t19 214.45500000000001
R488 a_20000_21737.n171 a_20000_21737.n167 62.955101562499998
R489 a_20000_21737.n170 a_20000_21737.n167 31.477599609375002
R490 a_20000_21737.n170 a_20000_21737.n165 31.477599609375002
R491 a_20000_21737.n165 a_20000_21737.n164 214.95500000000001
R492 a_20000_21737.n169 a_20000_21737.t41 62.3276015625
R493 a_20000_21737.t41 a_20000_21737.n170 19.944800781249999
R494 a_20000_21737# a_20000_21737.n169 131.62299999999999
R495 a_20000_21737.n169 a_20000_21737.n171 149.708
R496 a_20000_21737.n144 a_20000_21737.n143 152
R497 a_20000_21737.n146 a_20000_21737.n145 152
R498 a_20000_21737.n149 a_20000_21737.n148 152
R499 a_20000_21737.n132 a_20000_21737.n149 0.43835598754882815
R500 a_20000_21737.n149 a_20000_21737.n134 3.5945200195312501
R501 a_20000_21737.n134 a_20000_21737.n146 2.0164399414062499
R502 a_20000_21737.n146 a_20000_21737.n136 2.0164399414062499
R503 a_20000_21737.n136 a_20000_21737.n144 3.5945200195312501
R504 a_20000_21737.n138 a_20000_21737.n144 0.43835598754882815
R505 a_20000_21737.n138 a_20000_21737.n140 4.0328798828124999
R506 a_20000_21737.n140 a_20000_21737.n142 1.13972998046875
R507 a_20000_21737.n150 a_20000_21737.n142 2.630139892578125
R508 a_20000_21737.n141 a_20000_21737.n150 7.5957900390624999
R509 a_20000_21737.n120 a_20000_21737.n151 0.40851098632812499
R510 a_20000_21737.n151 a_20000_21737.n122 5.8553198242187499
R511 a_20000_21737.n122 a_20000_21737.n124 6.2638300781250003
R512 a_20000_21737.n124 a_20000_21737.n126 6.2638300781250003
R513 a_20000_21737.n126 a_20000_21737.n128 6.2638300781250003
R514 a_20000_21737.n128 a_20000_21737.n130 6.2638300781250003
R515 a_20000_21737.n130 a_20000_21737.n132 5.6090898437499996
R516 a_20000_21737.n114 a_20000_21737.n152 0.41739099121093748
R517 a_20000_21737.n152 a_20000_21737.n116 5.9826098632812501
R518 a_20000_21737.n116 a_20000_21737.n154 4.7999999999999998
R519 a_20000_21737.n153 a_20000_21737.n154 1.1826099853515626
R520 a_20000_21737.n118 a_20000_21737.n153 0.41739099121093748
R521 a_20000_21737.n118 a_20000_21737.n120 17.100199218749999
R522 a_20000_21737.n154 a_20000_21737.t43 259.08100000000002
R523 a_20000_21737.n89 a_20000_21737.n114 14.817400390625
R524 a_20000_21737.n153 a_20000_21737.t13 214.45500000000001
R525 a_20000_21737.n152 a_20000_21737.t14 214.45500000000001
R526 a_20000_21737.n151 a_20000_21737.t11 214.45500000000001
R527 a_20000_21737.n150 a_20000_21737.t10 214.45500000000001
R528 a_20000_21737.n148 a_20000_21737.n145 62.955101562499998
R529 a_20000_21737.n145 a_20000_21737.n147 31.477599609375002
R530 a_20000_21737.n143 a_20000_21737.n147 31.477599609375002
R531 a_20000_21737.n143 a_20000_21737.n142 214.95500000000001
R532 a_20000_21737.n147 a_20000_21737.t44 68.698898437500006
R533 a_20000_21737.t44 a_20000_21737.n148 538.31200000000001
R534 a_20000_21737.n33 a_20000_21737.n32 4.6207402343749999
R535 a_20000_21737.n35 a_20000_21737.n34 9.3000000000000007
R536 a_20000_21737.n37 a_20000_21737.n36 9.3000000000000007
R537 a_20000_21737.n39 a_20000_21737.n38 9.3000000000000007
R538 a_20000_21737.n41 a_20000_21737.n40 9.3000000000000007
R539 a_20000_21737.n43 a_20000_21737.n42 9.3000000000000007
R540 a_20000_21737.n45 a_20000_21737.n44 9.3000000000000007
R541 a_20000_21737.n47 a_20000_21737.n46 9.3000000000000007
R542 a_20000_21737.n49 a_20000_21737.n48 9.3000000000000007
R543 a_20000_21737.n51 a_20000_21737.n50 9.3000000000000007
R544 a_20000_21737.n53 a_20000_21737.n52 9.3000000000000007
R545 a_20000_21737.n55 a_20000_21737.n54 9.3000000000000007
R546 a_20000_21737.n74 a_20000_21737.n73 9.3000000000000007
R547 a_20000_21737.n76 a_20000_21737.n75 9.3000000000000007
R548 a_20000_21737.n77 a_20000_21737.n78 9.3000000000000007
R549 a_20000_21737.n78 a_20000_21737.n79 4.1154702148437501
R550 a_20000_21737.n76 a_20000_21737.n78 0.11979199981689453
R551 a_20000_21737.n74 a_20000_21737.n76 0.11979199981689453
R552 a_20000_21737.n1 a_20000_21737.n74 0.17980400085449219
R553 a_20000_21737.n6 a_20000_21737.n1 0.35719198608398439
R554 a_20000_21737.n9 a_20000_21737.n6 0.29717999267578127
R555 a_20000_21737.n11 a_20000_21737.n9 0.11979199981689453
R556 a_20000_21737.n19 a_20000_21737.n11 0.11979199981689453
R557 a_20000_21737.n21 a_20000_21737.n19 0.11979199981689453
R558 a_20000_21737.n23 a_20000_21737.n21 0.11979199981689453
R559 a_20000_21737.n25 a_20000_21737.n23 0.11979199981689453
R560 a_20000_21737.n29 a_20000_21737.n25 0.17980400085449219
R561 a_20000_21737.n87 a_20000_21737.n29 0.23981700134277345
R562 a_20000_21737.n87 a_20000_21737.n33 0.23981700134277345
R563 a_20000_21737.n33 a_20000_21737.n35 0.17980400085449219
R564 a_20000_21737.n35 a_20000_21737.n37 0.11979199981689453
R565 a_20000_21737.n37 a_20000_21737.n39 0.11979199981689453
R566 a_20000_21737.n39 a_20000_21737.n41 0.11979199981689453
R567 a_20000_21737.n41 a_20000_21737.n43 0.11979199981689453
R568 a_20000_21737.n43 a_20000_21737.n45 0.11979199981689453
R569 a_20000_21737.n45 a_20000_21737.n47 0.11979199981689453
R570 a_20000_21737.n47 a_20000_21737.n49 0.11979199981689453
R571 a_20000_21737.n49 a_20000_21737.n51 0.11979199981689453
R572 a_20000_21737.n51 a_20000_21737.n53 0.11979199981689453
R573 a_20000_21737.n53 a_20000_21737.n55 0.11979199981689453
R574 a_20000_21737.n81 a_20000_21737.n80 152
R575 a_20000_21737.n83 a_20000_21737.n82 152
R576 a_20000_21737.n86 a_20000_21737.n85 152
R577 a_20000_21737.n79 a_20000_21737.n86 1.6479399414062501
R578 a_20000_21737.n86 a_20000_21737.n77 2.3533601074218748
R579 a_20000_21737.n77 a_20000_21737.n83 1.3201800537109376
R580 a_20000_21737.n83 a_20000_21737.n75 1.3201800537109376
R581 a_20000_21737.n75 a_20000_21737.n81 2.3533601074218748
R582 a_20000_21737.n73 a_20000_21737.n81 0.28699600219726562
R583 a_20000_21737.n73 a_20000_21737.n2 1.865469970703125
R584 a_20000_21737.n85 a_20000_21737.n82 62.955101562499998
R585 a_20000_21737.n82 a_20000_21737.n84 31.477599609375002
R586 a_20000_21737.n80 a_20000_21737.n84 31.477599609375002
R587 a_20000_21737.n80 a_20000_21737.n189 229.05199999999999
R588 a_20000_21737.n84 a_20000_21737.t37 19.944800781249999
R589 a_20000_21737.t37 a_20000_21737.n85 212.035
R590 a_20000_21737.n79 a_20000_21737.t8 203.255
R591 a_20000_21737.n55 a_20000_21737.n72 6.6347500000000004
R592 a_20000_21737.n59 a_20000_21737.n58 152
R593 a_20000_21737.n61 a_20000_21737.n60 152
R594 a_20000_21737.n64 a_20000_21737.n63 152
R595 a_20000_21737.n46 a_20000_21737.n64 0.28699600219726562
R596 a_20000_21737.n64 a_20000_21737.n48 2.3533601074218748
R597 a_20000_21737.n48 a_20000_21737.n61 1.3201800537109376
R598 a_20000_21737.n61 a_20000_21737.n50 1.3201800537109376
R599 a_20000_21737.n50 a_20000_21737.n59 2.3533601074218748
R600 a_20000_21737.n52 a_20000_21737.n59 0.28699600219726562
R601 a_20000_21737.n52 a_20000_21737.n54 2.6403601074218752
R602 a_20000_21737.n54 a_20000_21737.n57 0.74618798828124999
R603 a_20000_21737.n71 a_20000_21737.n57 0.60269097900390622
R604 a_20000_21737.n65 a_20000_21737.n71 1.119280029296875
R605 a_20000_21737.n72 a_20000_21737.n65 0.40150799560546874
R606 a_20000_21737.n56 a_20000_21737.n72 32.153099609374998
R607 a_20000_21737.n56 a_20000_21737.t40 148.661
R608 a_20000_21737.n71 a_20000_21737.n56 4.4077402343749998
R609 a_20000_21737.n42 a_20000_21737.n66 0.22456100463867187
R610 a_20000_21737.n66 a_20000_21737.n44 3.2187099609374998
R611 a_20000_21737.n44 a_20000_21737.n46 3.2076398925781251
R612 a_20000_21737.n34 a_20000_21737.n67 0.22456100463867187
R613 a_20000_21737.n67 a_20000_21737.n36 3.2187099609374998
R614 a_20000_21737.n36 a_20000_21737.n38 3.44327001953125
R615 a_20000_21737.n38 a_20000_21737.n68 3.2187099609374998
R616 a_20000_21737.n40 a_20000_21737.n68 0.22456100463867187
R617 a_20000_21737.n40 a_20000_21737.n42 4.5163100585937501
R618 a_20000_21737.n70 a_20000_21737.n34 3.430929931640625
R619 a_20000_21737.n32 a_20000_21737.n70 6.570669921875
R620 a_20000_21737.n32 a_20000_21737.n69 8.1066699218749996
R621 a_20000_21737.n30 a_20000_21737.n69 2.901330078125
R622 a_20000_21737.n70 a_20000_21737.t24 215.99100000000001
R623 a_20000_21737.n69 a_20000_21737.t4 214.45500000000001
R624 a_20000_21737.n30 a_20000_21737.t35 118.375
R625 a_20000_21737.n68 a_20000_21737.t23 214.45500000000001
R626 a_20000_21737.n67 a_20000_21737.t2 214.45500000000001
R627 a_20000_21737.n66 a_20000_21737.t21 214.45500000000001
R628 a_20000_21737.n65 a_20000_21737.t1 214.45500000000001
R629 a_20000_21737.n63 a_20000_21737.n60 62.955101562499998
R630 a_20000_21737.n60 a_20000_21737.n62 31.477599609375002
R631 a_20000_21737.n58 a_20000_21737.n62 31.477599609375002
R632 a_20000_21737.n58 a_20000_21737.n57 214.95500000000001
R633 a_20000_21737.n62 a_20000_21737.t36 68.698898437500006
R634 a_20000_21737.t36 a_20000_21737.n63 538.31200000000001
R635 a_20000_21737.n38 a_20000_21737.t39 116.733
R636 a_20000_21737.n16 a_20000_21737.n14 62.955101562499998
R637 a_20000_21737.n14 a_20000_21737.n27 31.477599609375002
R638 a_20000_21737.n12 a_20000_21737.n27 31.477599609375002
R639 a_20000_21737.n12 a_20000_21737.n26 229.05199999999999
R640 a_20000_21737.n27 a_20000_21737.t38 68.698898437500006
R641 a_20000_21737.t38 a_20000_21737.n16 538.31200000000001
R642 a_20000_21737.n26 a_20000_21737.t26 214.45500000000001
R643 a_20000_21737.n7 a_20000_21737.t5 214.45500000000001
R644 a_20000_21737.n188 a_20000_21737.t27 215.14599999999999
R645 a_20000_21737.n4 a_20000_21737.t7 214.45500000000001
C154 m5_22600_20000# a_20000_21737# 0 $ **FLOATING
C155 m5_20600_20000# a_20000_21737# 0 $ **FLOATING
C156 m5_20000_20000# a_20000_21737# 0 $ **FLOATING
C157 m5_22600_21100# a_20000_21737# 0 $ **FLOATING
C158 m5_20600_21100# a_20000_21737# 0 $ **FLOATING
C159 m5_20000_21100# a_20000_21737# 0 $ **FLOATING
C160 m5_22600_23100# a_20000_21737# 0 $ **FLOATING
C161 m5_20600_23100# a_20000_21737# 0 $ **FLOATING
C162 m5_20000_23100# a_20000_21737# 0 $ **FLOATING
C163 m5_108600_65100# a_20000_21737# 0 $ **FLOATING
C164 m5_107200_65100# a_20000_21737# 0 $ **FLOATING
C165 m5_107200_66336# a_20000_21737# 8.8871e-16
C166 m5_108600_67100# a_20000_21737# 0 $ **FLOATING
C167 m5_107200_67100# a_20000_21737# 0 $ **FLOATING
C168 m4_23090_20000# a_20000_21737# 0 $ **FLOATING
C169 m4_22530_20000# a_20000_21737# 0 $ **FLOATING
C170 m4_21970_20000# a_20000_21737# 0 $ **FLOATING
C171 m4_21410_20000# a_20000_21737# 0 $ **FLOATING
C172 m4_20850_20000# a_20000_21737# 0 $ **FLOATING
C173 m4_20290_20000# a_20000_21737# 0 $ **FLOATING
C174 m4_20000_20000# a_20000_21737# 0 $ **FLOATING
C175 m4_23230_20450# a_20000_21737# 0 $ **FLOATING
C176 m4_22670_20450# a_20000_21737# 0 $ **FLOATING
C177 m4_22110_20450# a_20000_21737# 0 $ **FLOATING
C178 m4_21550_20450# a_20000_21737# 0 $ **FLOATING
C179 m4_20990_20450# a_20000_21737# 0 $ **FLOATING
C180 m4_20430_20450# a_20000_21737# 0 $ **FLOATING
C181 m4_20000_20450# a_20000_21737# 0 $ **FLOATING
C182 m4_22810_21010# a_20000_21737# 0 $ **FLOATING
C183 m4_22250_21010# a_20000_21737# 0 $ **FLOATING
C184 m4_21690_21010# a_20000_21737# 0 $ **FLOATING
C185 m4_21130_21010# a_20000_21737# 0 $ **FLOATING
C186 m4_20570_21010# a_20000_21737# 0 $ **FLOATING
C187 m4_20010_21010# a_20000_21737# 0 $ **FLOATING
C188 m4_22950_21570# a_20000_21737# 0 $ **FLOATING
C189 m4_22390_21570# a_20000_21737# 0 $ **FLOATING
C190 m4_21830_21570# a_20000_21737# 0 $ **FLOATING
C191 m4_21270_21570# a_20000_21737# 0 $ **FLOATING
C192 m4_20710_21570# a_20000_21737# 0 $ **FLOATING
C193 m4_20150_21570# a_20000_21737# 0 $ **FLOATING
C194 m4_23090_22130# a_20000_21737# 0 $ **FLOATING
C195 m4_22530_22130# a_20000_21737# 0 $ **FLOATING
C196 m4_21970_22130# a_20000_21737# 0 $ **FLOATING
C197 m4_21410_22130# a_20000_21737# 0 $ **FLOATING
C198 m4_20850_22130# a_20000_21737# 0 $ **FLOATING
C199 m4_20290_22130# a_20000_21737# 0 $ **FLOATING
C200 m4_20000_22130# a_20000_21737# 0 $ **FLOATING
C201 m4_23230_22690# a_20000_21737# 0 $ **FLOATING
C202 m4_22670_22690# a_20000_21737# 0 $ **FLOATING
C203 m4_22110_22690# a_20000_21737# 0 $ **FLOATING
C204 m4_21550_22690# a_20000_21737# 0 $ **FLOATING
C205 m4_20990_22690# a_20000_21737# 0 $ **FLOATING
C206 m4_20430_22690# a_20000_21737# 0 $ **FLOATING
C207 m4_20000_22690# a_20000_21737# 0 $ **FLOATING
C208 m4_109660_65100# a_20000_21737# 0 $ **FLOATING
C209 m4_109690_65250# a_20000_21737# 0 $ **FLOATING
C210 m4_109668_65428# a_20000_21737# 0 $ **FLOATING
C211 m4_109632_65604# a_20000_21737# 0 $ **FLOATING
C212 m4_109596_65780# a_20000_21737# 0 $ **FLOATING
C213 m4_108860_65100# a_20000_21737# 0 $ **FLOATING
C214 m4_108684_65100# a_20000_21737# 0 $ **FLOATING
C215 m4_108508_65100# a_20000_21737# 0 $ **FLOATING
C216 m4_108332_65100# a_20000_21737# 0 $ **FLOATING
C217 m4_108156_65100# a_20000_21737# 0 $ **FLOATING
C218 m4_108824_65252# a_20000_21737# 0 $ **FLOATING
C219 m4_108648_65252# a_20000_21737# 0 $ **FLOATING
C220 m4_108472_65252# a_20000_21737# 0 $ **FLOATING
C221 m4_108296_65252# a_20000_21737# 0 $ **FLOATING
C222 m4_108788_65428# a_20000_21737# 0 $ **FLOATING
C223 m4_108612_65428# a_20000_21737# 0 $ **FLOATING
C224 m4_108436_65428# a_20000_21737# 0 $ **FLOATING
C225 m4_108260_65428# a_20000_21737# 0 $ **FLOATING
C226 m4_108752_65604# a_20000_21737# 0 $ **FLOATING
C227 m4_108576_65604# a_20000_21737# 0 $ **FLOATING
C228 m4_108400_65604# a_20000_21737# 0 $ **FLOATING
C229 m4_108224_65604# a_20000_21737# 0 $ **FLOATING
C230 m4_108716_65780# a_20000_21737# 0 $ **FLOATING
C231 m4_108540_65780# a_20000_21737# 0 $ **FLOATING
C232 m4_108364_65780# a_20000_21737# 0 $ **FLOATING
C233 m4_108188_65780# a_20000_21737# 0 $ **FLOATING
C234 m4_109680_66050# a_20000_21737# 0 $ **FLOATING
C235 m4_109664_66308# a_20000_21737# 0 $ **FLOATING
C236 m4_109628_66484# a_20000_21737# 0 $ **FLOATING
C237 m4_109592_66660# a_20000_21737# 0 $ **FLOATING
C238 m4_109670_66850# a_20000_21737# 0 $ **FLOATING
C239 m4_108856_65956# a_20000_21737# 0 $ **FLOATING
C240 m4_108680_65956# a_20000_21737# 0 $ **FLOATING
C241 m4_108504_65956# a_20000_21737# 0 $ **FLOATING
C242 m4_108328_65956# a_20000_21737# 0 $ **FLOATING
C243 m4_108152_65956# a_20000_21737# 0 $ **FLOATING
C244 m4_108820_66132# a_20000_21737# 0 $ **FLOATING
C245 m4_108644_66132# a_20000_21737# 0 $ **FLOATING
C246 m4_108468_66132# a_20000_21737# 0 $ **FLOATING
C247 m4_108292_66132# a_20000_21737# 0 $ **FLOATING
C248 m4_108784_66308# a_20000_21737# 0 $ **FLOATING
C249 m4_108608_66308# a_20000_21737# 0 $ **FLOATING
C250 m4_108432_66308# a_20000_21737# 0 $ **FLOATING
C251 m4_108256_66308# a_20000_21737# 0 $ **FLOATING
C252 m4_108748_66484# a_20000_21737# 0 $ **FLOATING
C253 m4_108572_66484# a_20000_21737# 0 $ **FLOATING
C254 m4_108396_66484# a_20000_21737# 0 $ **FLOATING
C255 m4_108220_66484# a_20000_21737# 0 $ **FLOATING
C256 m4_108712_66660# a_20000_21737# 0 $ **FLOATING
C257 m4_108536_66660# a_20000_21737# 0 $ **FLOATING
C258 m4_108360_66660# a_20000_21737# 0 $ **FLOATING
C259 m4_108184_66660# a_20000_21737# 0 $ **FLOATING
C260 m4_108852_66836# a_20000_21737# 0 $ **FLOATING
C261 m4_108676_66836# a_20000_21737# 0 $ **FLOATING
C262 m4_108500_66836# a_20000_21737# 0 $ **FLOATING
C263 m4_108324_66836# a_20000_21737# 0 $ **FLOATING
C264 m4_108148_66836# a_20000_21737# 0 $ **FLOATING
C265 m4_108816_67012# a_20000_21737# 0 $ **FLOATING
C266 m4_108640_67012# a_20000_21737# 0 $ **FLOATING
C267 m4_108464_67012# a_20000_21737# 0 $ **FLOATING
C268 m4_108288_67012# a_20000_21737# 0 $ **FLOATING
C269 m4_108780_67188# a_20000_21737# 0 $ **FLOATING
C270 m4_108604_67188# a_20000_21737# 0 $ **FLOATING
C271 m4_108428_67188# a_20000_21737# 0 $ **FLOATING
C272 m4_108252_67188# a_20000_21737# 0 $ **FLOATING
C273 m4_108744_67364# a_20000_21737# 0 $ **FLOATING
C274 m4_108568_67364# a_20000_21737# 0 $ **FLOATING
C275 m4_108392_67364# a_20000_21737# 0 $ **FLOATING
C276 m4_108216_67364# a_20000_21737# 0 $ **FLOATING
C277 m4_108708_67540# a_20000_21737# 0 $ **FLOATING
C278 m4_108532_67540# a_20000_21737# 0 $ **FLOATING
C279 m4_108356_67540# a_20000_21737# 0 $ **FLOATING
C280 m4_108180_67540# a_20000_21737# 0 $ **FLOATING
C281 m4_107982_65100# a_20000_21737# 2.46726e-16
C282 m4_107740_65100# a_20000_21737# 0 $ **FLOATING
C283 m4_107770_65250# a_20000_21737# 0 $ **FLOATING
C284 m4_107800_65410# a_20000_21737# 0 $ **FLOATING
C285 m4_107764_66132# a_20000_21737# 0 $ **FLOATING
C286 m4_107750_66850# a_20000_21737# 0 $ **FLOATING
C287 m4_107760_67012# a_20000_21737# 0 $ **FLOATING
C288 m4_107598_65100# a_20000_21737# 1.1617500000000001e-16
C289 m4_107380_65428# a_20000_21737# 0 $ **FLOATING
C290 m4_107380_65730# a_20000_21737# 0 $ **FLOATING
C291 m4_107214_65100# a_20000_21737# 5.1146899999999999e-16
C292 m3_23090_20000# a_20000_21737# 0 $ **FLOATING
C293 m3_22530_20000# a_20000_21737# 0 $ **FLOATING
C294 m3_21970_20000# a_20000_21737# 0 $ **FLOATING
C295 m3_21410_20000# a_20000_21737# 0 $ **FLOATING
C296 m3_20850_20000# a_20000_21737# 0 $ **FLOATING
C297 m3_20290_20000# a_20000_21737# 0 $ **FLOATING
C298 m3_20000_20000# a_20000_21737# 0 $ **FLOATING
C299 m3_23230_20450# a_20000_21737# 0 $ **FLOATING
C300 m3_22670_20450# a_20000_21737# 0 $ **FLOATING
C301 m3_22110_20450# a_20000_21737# 0 $ **FLOATING
C302 m3_21550_20450# a_20000_21737# 0 $ **FLOATING
C303 m3_20990_20450# a_20000_21737# 0 $ **FLOATING
C304 m3_20430_20450# a_20000_21737# 0 $ **FLOATING
C305 m3_20000_20450# a_20000_21737# 0 $ **FLOATING
C306 m3_22810_21010# a_20000_21737# 0 $ **FLOATING
C307 m3_22250_21010# a_20000_21737# 0 $ **FLOATING
C308 m3_21690_21010# a_20000_21737# 0 $ **FLOATING
C309 m3_21130_21010# a_20000_21737# 0 $ **FLOATING
C310 m3_20570_21010# a_20000_21737# 0 $ **FLOATING
C311 m3_20010_21010# a_20000_21737# 0 $ **FLOATING
C312 m3_22950_21570# a_20000_21737# 0 $ **FLOATING
C313 m3_22390_21570# a_20000_21737# 0 $ **FLOATING
C314 m3_21830_21570# a_20000_21737# 0 $ **FLOATING
C315 m3_21270_21570# a_20000_21737# 0 $ **FLOATING
C316 m3_20710_21570# a_20000_21737# 0 $ **FLOATING
C317 m3_20150_21570# a_20000_21737# 0 $ **FLOATING
C318 m3_23090_22130# a_20000_21737# 0 $ **FLOATING
C319 m3_22530_22130# a_20000_21737# 0 $ **FLOATING
C320 m3_21970_22130# a_20000_21737# 0 $ **FLOATING
C321 m3_21410_22130# a_20000_21737# 0 $ **FLOATING
C322 m3_20850_22130# a_20000_21737# 0 $ **FLOATING
C323 m3_20290_22130# a_20000_21737# 0 $ **FLOATING
C324 m3_20000_22130# a_20000_21737# 0 $ **FLOATING
C325 m3_23230_22690# a_20000_21737# 0 $ **FLOATING
C326 m3_22670_22690# a_20000_21737# 0 $ **FLOATING
C327 m3_22110_22690# a_20000_21737# 0 $ **FLOATING
C328 m3_21550_22690# a_20000_21737# 0 $ **FLOATING
C329 m3_20990_22690# a_20000_21737# 0 $ **FLOATING
C330 m3_20430_22690# a_20000_21737# 0 $ **FLOATING
C331 m3_20000_22690# a_20000_21737# 0 $ **FLOATING
C332 m3_109634_65146# a_20000_21737# 0 $ **FLOATING
C333 m3_109458_65146# a_20000_21737# 0 $ **FLOATING
C334 m3_109282_65146# a_20000_21737# 0 $ **FLOATING
C335 m3_109106_65146# a_20000_21737# 0 $ **FLOATING
C336 m3_108930_65146# a_20000_21737# 0 $ **FLOATING
C337 m3_108754_65146# a_20000_21737# 0 $ **FLOATING
C338 m3_108578_65146# a_20000_21737# 0 $ **FLOATING
C339 m3_108400_65110# a_20000_21737# 0 $ **FLOATING
C340 m3_108240_65110# a_20000_21737# 0 $ **FLOATING
C341 m3_107346_65146# a_20000_21737# 0 $ **FLOATING
C342 m3_107200_65146# a_20000_21737# 0 $ **FLOATING
C343 m3_109598_65322# a_20000_21737# 0 $ **FLOATING
C344 m3_109422_65322# a_20000_21737# 0 $ **FLOATING
C345 m3_109246_65322# a_20000_21737# 0 $ **FLOATING
C346 m3_109070_65322# a_20000_21737# 0 $ **FLOATING
C347 m3_108894_65322# a_20000_21737# 0 $ **FLOATING
C348 m3_108718_65322# a_20000_21737# 0 $ **FLOATING
C349 m3_108542_65322# a_20000_21737# 0 $ **FLOATING
C350 m3_109562_65498# a_20000_21737# 0 $ **FLOATING
C351 m3_109386_65498# a_20000_21737# 0 $ **FLOATING
C352 m3_109210_65498# a_20000_21737# 0 $ **FLOATING
C353 m3_109034_65498# a_20000_21737# 0 $ **FLOATING
C354 m3_108858_65498# a_20000_21737# 0 $ **FLOATING
C355 m3_108682_65498# a_20000_21737# 0 $ **FLOATING
C356 m3_108506_65498# a_20000_21737# 0 $ **FLOATING
C357 m3_108240_65310# a_20000_21737# 0 $ **FLOATING
C358 m3_108014_65322# a_20000_21737# 0 $ **FLOATING
C359 m3_107838_65322# a_20000_21737# 0 $ **FLOATING
C360 m3_107662_65322# a_20000_21737# 0 $ **FLOATING
C361 m3_107486_65322# a_20000_21737# 0 $ **FLOATING
C362 m3_107310_65322# a_20000_21737# 0 $ **FLOATING
C363 m3_107200_65322# a_20000_21737# 0 $ **FLOATING
C364 m3_108822_65674# a_20000_21737# 0 $ **FLOATING
C365 m3_108646_65674# a_20000_21737# 0 $ **FLOATING
C366 m3_108120_65570# a_20000_21737# 0 $ **FLOATING
C367 m3_107802_65498# a_20000_21737# 0 $ **FLOATING
C368 m3_107626_65498# a_20000_21737# 0 $ **FLOATING
C369 m3_107450_65498# a_20000_21737# 0 $ **FLOATING
C370 m3_107274_65498# a_20000_21737# 0 $ **FLOATING
C371 m3_107200_65498# a_20000_21737# 0 $ **FLOATING
C372 m3_107942_65674# a_20000_21737# 0 $ **FLOATING
C373 m3_107766_65674# a_20000_21737# 0 $ **FLOATING
C374 m3_107590_65674# a_20000_21737# 0 $ **FLOATING
C375 m3_107414_65674# a_20000_21737# 0 $ **FLOATING
C376 m3_107238_65674# a_20000_21737# 0 $ **FLOATING
C377 m3_109666_65850# a_20000_21737# 0 $ **FLOATING
C378 m3_108786_65850# a_20000_21737# 0 $ **FLOATING
C379 m3_108610_65850# a_20000_21737# 0 $ **FLOATING
C380 m3_109630_66026# a_20000_21737# 0 $ **FLOATING
C381 m3_109454_66026# a_20000_21737# 0 $ **FLOATING
C382 m3_109278_66026# a_20000_21737# 0 $ **FLOATING
C383 m3_109102_66026# a_20000_21737# 0 $ **FLOATING
C384 m3_108926_66026# a_20000_21737# 0 $ **FLOATING
C385 m3_108750_66026# a_20000_21737# 0 $ **FLOATING
C386 m3_108574_66026# a_20000_21737# 0 $ **FLOATING
C387 m3_108260_65830# a_20000_21737# 0 $ **FLOATING
C388 m3_108082_65850# a_20000_21737# 0 $ **FLOATING
C389 m3_107906_65850# a_20000_21737# 0 $ **FLOATING
C390 m3_107730_65850# a_20000_21737# 0 $ **FLOATING
C391 m3_109594_66202# a_20000_21737# 0 $ **FLOATING
C392 m3_109418_66202# a_20000_21737# 0 $ **FLOATING
C393 m3_109242_66202# a_20000_21737# 0 $ **FLOATING
C394 m3_109066_66202# a_20000_21737# 0 $ **FLOATING
C395 m3_108890_66202# a_20000_21737# 0 $ **FLOATING
C396 m3_108714_66202# a_20000_21737# 0 $ **FLOATING
C397 m3_108140_66090# a_20000_21737# 0 $ **FLOATING
C398 m3_107870_66026# a_20000_21737# 0 $ **FLOATING
C399 m3_107694_66026# a_20000_21737# 0 $ **FLOATING
C400 m3_107200_66002# a_20000_21737# 1.5996000000000004e-16
C401 m3_107834_66202# a_20000_21737# 0 $ **FLOATING
C402 m3_107658_66202# a_20000_21737# 0 $ **FLOATING
C403 m3_107482_66202# a_20000_21737# 0 $ **FLOATING
C404 m3_107306_66202# a_20000_21737# 0 $ **FLOATING
C405 m3_107200_66202# a_20000_21737# 0 $ **FLOATING
C406 m3_109558_66378# a_20000_21737# 0 $ **FLOATING
C407 m3_109382_66378# a_20000_21737# 0 $ **FLOATING
C408 m3_109206_66378# a_20000_21737# 0 $ **FLOATING
C409 m3_109030_66378# a_20000_21737# 0 $ **FLOATING
C410 m3_108854_66378# a_20000_21737# 0 $ **FLOATING
C411 m3_108678_66378# a_20000_21737# 0 $ **FLOATING
C412 m3_108280_66350# a_20000_21737# 0 $ **FLOATING
C413 m3_107974_66378# a_20000_21737# 0 $ **FLOATING
C414 m3_107798_66378# a_20000_21737# 0 $ **FLOATING
C415 m3_107622_66378# a_20000_21737# 0 $ **FLOATING
C416 m3_107446_66378# a_20000_21737# 0 $ **FLOATING
C417 m3_107270_66378# a_20000_21737# 0 $ **FLOATING
C418 m3_107200_66378# a_20000_21737# 0 $ **FLOATING
C419 m3_109522_66554# a_20000_21737# 0 $ **FLOATING
C420 m3_109346_66554# a_20000_21737# 0 $ **FLOATING
C421 m3_109170_66554# a_20000_21737# 0 $ **FLOATING
C422 m3_108994_66554# a_20000_21737# 0 $ **FLOATING
C423 m3_108818_66554# a_20000_21737# 0 $ **FLOATING
C424 m3_108642_66554# a_20000_21737# 0 $ **FLOATING
C425 m3_109662_66730# a_20000_21737# 0 $ **FLOATING
C426 m3_109486_66730# a_20000_21737# 0 $ **FLOATING
C427 m3_109310_66730# a_20000_21737# 0 $ **FLOATING
C428 m3_109134_66730# a_20000_21737# 0 $ **FLOATING
C429 m3_108958_66730# a_20000_21737# 0 $ **FLOATING
C430 m3_108782_66730# a_20000_21737# 0 $ **FLOATING
C431 m3_108606_66730# a_20000_21737# 0 $ **FLOATING
C432 m3_108430_66730# a_20000_21737# 0 $ **FLOATING
C433 m3_108160_66610# a_20000_21737# 0 $ **FLOATING
C434 m3_107938_66554# a_20000_21737# 0 $ **FLOATING
C435 m3_107762_66554# a_20000_21737# 0 $ **FLOATING
C436 m3_107586_66554# a_20000_21737# 0 $ **FLOATING
C437 m3_107410_66554# a_20000_21737# 0 $ **FLOATING
C438 m3_107234_66554# a_20000_21737# 0 $ **FLOATING
C439 m3_107902_66730# a_20000_21737# 0 $ **FLOATING
C440 m3_107726_66730# a_20000_21737# 0 $ **FLOATING
C441 m3_107550_66730# a_20000_21737# 0 $ **FLOATING
C442 m3_107374_66730# a_20000_21737# 0 $ **FLOATING
C443 m3_107200_66730# a_20000_21737# 0 $ **FLOATING
C444 m3_109626_66906# a_20000_21737# 0 $ **FLOATING
C445 m3_109450_66906# a_20000_21737# 0 $ **FLOATING
C446 m3_109274_66906# a_20000_21737# 0 $ **FLOATING
C447 m3_109098_66906# a_20000_21737# 0 $ **FLOATING
C448 m3_108922_66906# a_20000_21737# 0 $ **FLOATING
C449 m3_108746_66906# a_20000_21737# 0 $ **FLOATING
C450 m3_108570_66906# a_20000_21737# 0 $ **FLOATING
C451 m3_108394_66906# a_20000_21737# 0 $ **FLOATING
C452 m3_108218_66906# a_20000_21737# 0 $ **FLOATING
C453 m3_108710_67082# a_20000_21737# 0 $ **FLOATING
C454 m3_108534_67082# a_20000_21737# 0 $ **FLOATING
C455 m3_108850_67258# a_20000_21737# 0 $ **FLOATING
C456 m3_108674_67258# a_20000_21737# 0 $ **FLOATING
C457 m3_108498_67258# a_20000_21737# 0 $ **FLOATING
C458 m3_108180_67130# a_20000_21737# 0 $ **FLOATING
C459 m3_107650_66930# a_20000_21737# 0 $ **FLOATING
C460 m3_107338_66906# a_20000_21737# 0 $ **FLOATING
C461 m3_107200_66906# a_20000_21737# 0 $ **FLOATING
C462 m3_107302_67082# a_20000_21737# 0 $ **FLOATING
C463 m3_107200_67082# a_20000_21737# 0 $ **FLOATING
C464 m3_107442_67258# a_20000_21737# 0 $ **FLOATING
C465 m3_107266_67258# a_20000_21737# 0 $ **FLOATING
C466 m3_107200_67258# a_20000_21737# 0 $ **FLOATING
C467 m3_109694_67434# a_20000_21737# 0 $ **FLOATING
C468 m3_109518_67434# a_20000_21737# 0 $ **FLOATING
C469 m3_109342_67434# a_20000_21737# 0 $ **FLOATING
C470 m3_109166_67434# a_20000_21737# 0 $ **FLOATING
C471 m3_108990_67434# a_20000_21737# 0 $ **FLOATING
C472 m3_108814_67434# a_20000_21737# 0 $ **FLOATING
C473 m3_108638_67434# a_20000_21737# 0 $ **FLOATING
C474 m3_108462_67434# a_20000_21737# 0 $ **FLOATING
C475 m3_108286_67434# a_20000_21737# 0 $ **FLOATING
C476 m3_108110_67434# a_20000_21737# 0 $ **FLOATING
C477 m3_107934_67434# a_20000_21737# 0 $ **FLOATING
C478 m3_107758_67434# a_20000_21737# 0 $ **FLOATING
C479 m3_107582_67434# a_20000_21737# 0 $ **FLOATING
C480 m3_107406_67434# a_20000_21737# 0 $ **FLOATING
C481 m3_107230_67434# a_20000_21737# 0 $ **FLOATING
C482 m2_23090_20000# a_20000_21737# 0 $ **FLOATING
C483 m2_22980_20200# a_20000_21737# 0 $ **FLOATING
C484 m2_22530_20000# a_20000_21737# 0 $ **FLOATING
C485 m2_21970_20000# a_20000_21737# 0 $ **FLOATING
C486 m2_21860_20100# a_20000_21737# 0 $ **FLOATING
C487 m2_21410_20000# a_20000_21737# 0 $ **FLOATING
C488 m2_20850_20000# a_20000_21737# 0 $ **FLOATING
C489 m2_20740_20000# a_20000_21737# 0 $ **FLOATING
C490 m2_20290_20000# a_20000_21737# 0 $ **FLOATING
C491 m2_20180_20200# a_20000_21737# 0 $ **FLOATING
C492 m2_20000_20000# a_20000_21737# 0 $ **FLOATING
C493 m2_21300_20300# a_20000_21737# 0 $ **FLOATING
C494 m2_23230_20450# a_20000_21737# 0 $ **FLOATING
C495 m2_23120_20400# a_20000_21737# 0 $ **FLOATING
C496 m2_22670_20450# a_20000_21737# 0 $ **FLOATING
C497 m2_22560_20600# a_20000_21737# 0 $ **FLOATING
C498 m2_22110_20450# a_20000_21737# 0 $ **FLOATING
C499 m2_22000_20800# a_20000_21737# 0 $ **FLOATING
C500 m2_21550_20450# a_20000_21737# 0 $ **FLOATING
C501 m2_21440_20500# a_20000_21737# 0 $ **FLOATING
C502 m2_20990_20450# a_20000_21737# 0 $ **FLOATING
C503 m2_20880_20700# a_20000_21737# 0 $ **FLOATING
C504 m2_20430_20450# a_20000_21737# 0 $ **FLOATING
C505 m2_20320_20400# a_20000_21737# 0 $ **FLOATING
C506 m2_20000_20450# a_20000_21737# 0 $ **FLOATING
C507 m2_23220_20900# a_20000_21737# 0 $ **FLOATING
C508 m2_23120_20900# a_20000_21737# 0 $ **FLOATING
C509 m2_23020_20900# a_20000_21737# 0 $ **FLOATING
C510 m2_22920_20900# a_20000_21737# 0 $ **FLOATING
C511 m2_22820_20900# a_20000_21737# 0 $ **FLOATING
C512 m2_22720_20900# a_20000_21737# 0 $ **FLOATING
C513 m2_22620_20900# a_20000_21737# 0 $ **FLOATING
C514 m2_22520_20900# a_20000_21737# 0 $ **FLOATING
C515 m2_22420_20900# a_20000_21737# 0 $ **FLOATING
C516 m2_22320_20900# a_20000_21737# 0 $ **FLOATING
C517 m2_22220_20900# a_20000_21737# 0 $ **FLOATING
C518 m2_22120_20900# a_20000_21737# 0 $ **FLOATING
C519 m2_22020_20900# a_20000_21737# 0 $ **FLOATING
C520 m2_21920_20900# a_20000_21737# 0 $ **FLOATING
C521 m2_21820_20900# a_20000_21737# 0 $ **FLOATING
C522 m2_21720_20900# a_20000_21737# 0 $ **FLOATING
C523 m2_21620_20900# a_20000_21737# 0 $ **FLOATING
C524 m2_21520_20900# a_20000_21737# 0 $ **FLOATING
C525 m2_21420_20900# a_20000_21737# 0 $ **FLOATING
C526 m2_21320_20900# a_20000_21737# 0 $ **FLOATING
C527 m2_21220_20900# a_20000_21737# 0 $ **FLOATING
C528 m2_21120_20900# a_20000_21737# 0 $ **FLOATING
C529 m2_21020_20900# a_20000_21737# 0 $ **FLOATING
C530 m2_20920_20900# a_20000_21737# 0 $ **FLOATING
C531 m2_20820_20900# a_20000_21737# 0 $ **FLOATING
C532 m2_20720_20900# a_20000_21737# 0 $ **FLOATING
C533 m2_20620_20900# a_20000_21737# 0 $ **FLOATING
C534 m2_20520_20900# a_20000_21737# 0 $ **FLOATING
C535 m2_20420_20900# a_20000_21737# 0 $ **FLOATING
C536 m2_20320_20900# a_20000_21737# 0 $ **FLOATING
C537 m2_20220_20900# a_20000_21737# 0 $ **FLOATING
C538 m2_20120_20900# a_20000_21737# 0 $ **FLOATING
C539 m2_20020_20900# a_20000_21737# 0 $ **FLOATING
C540 m2_23260_21100# a_20000_21737# 0 $ **FLOATING
C541 m2_22810_21010# a_20000_21737# 0 $ **FLOATING
C542 m2_22700_21300# a_20000_21737# 0 $ **FLOATING
C543 m2_22250_21010# a_20000_21737# 0 $ **FLOATING
C544 m2_22140_21000# a_20000_21737# 0 $ **FLOATING
C545 m2_21690_21010# a_20000_21737# 0 $ **FLOATING
C546 m2_21580_21200# a_20000_21737# 0 $ **FLOATING
C547 m2_21130_21010# a_20000_21737# 0 $ **FLOATING
C548 m2_21020_21400# a_20000_21737# 0 $ **FLOATING
C549 m2_20570_21010# a_20000_21737# 0 $ **FLOATING
C550 m2_20460_21100# a_20000_21737# 0 $ **FLOATING
C551 m2_20010_21010# a_20000_21737# 0 $ **FLOATING
C552 m2_22840_21500# a_20000_21737# 0 $ **FLOATING
C553 m2_20040_21500# a_20000_21737# 0 $ **FLOATING
C554 m2_22950_21570# a_20000_21737# 0 $ **FLOATING
C555 m2_22390_21570# a_20000_21737# 0 $ **FLOATING
C556 m2_22280_21700# a_20000_21737# 0 $ **FLOATING
C557 m2_21830_21570# a_20000_21737# 0 $ **FLOATING
C558 m2_21720_21900# a_20000_21737# 0 $ **FLOATING
C559 m2_21270_21570# a_20000_21737# 0 $ **FLOATING
C560 m2_21160_21600# a_20000_21737# 0 $ **FLOATING
C561 m2_20710_21570# a_20000_21737# 0 $ **FLOATING
C562 m2_20600_21800# a_20000_21737# 0 $ **FLOATING
C563 m2_20150_21570# a_20000_21737# 0 $ **FLOATING
C564 m2_22840_22000# a_20000_21737# 0 $ **FLOATING
C565 m2_20040_22000# a_20000_21737# 0 $ **FLOATING
C566 m2_23090_22130# a_20000_21737# 0 $ **FLOATING
C567 m2_22980_22200# a_20000_21737# 0 $ **FLOATING
C568 m2_22530_22130# a_20000_21737# 0 $ **FLOATING
C569 m2_22420_22400# a_20000_21737# 0 $ **FLOATING
C570 m2_21970_22130# a_20000_21737# 0 $ **FLOATING
C571 m2_21860_22100# a_20000_21737# 0 $ **FLOATING
C572 m2_21410_22130# a_20000_21737# 0 $ **FLOATING
C573 m2_21300_22300# a_20000_21737# 0 $ **FLOATING
C574 m2_20850_22130# a_20000_21737# 0 $ **FLOATING
C575 m2_20740_22500# a_20000_21737# 0 $ **FLOATING
C576 m2_20290_22130# a_20000_21737# 0 $ **FLOATING
C577 m2_20180_22200# a_20000_21737# 0 $ **FLOATING
C578 m2_20000_22130# a_20000_21737# 0 $ **FLOATING
C579 m2_22560_22600# a_20000_21737# 0 $ **FLOATING
C580 m2_23230_22690# a_20000_21737# 0 $ **FLOATING
C581 m2_23120_22900# a_20000_21737# 0 $ **FLOATING
C582 m2_22670_22690# a_20000_21737# 0 $ **FLOATING
C583 m2_22110_22690# a_20000_21737# 0 $ **FLOATING
C584 m2_22000_22800# a_20000_21737# 0 $ **FLOATING
C585 m2_21550_22690# a_20000_21737# 0 $ **FLOATING
C586 m2_21440_23000# a_20000_21737# 0 $ **FLOATING
C587 m2_20990_22690# a_20000_21737# 0 $ **FLOATING
C588 m2_20880_22700# a_20000_21737# 0 $ **FLOATING
C589 m2_20430_22690# a_20000_21737# 0 $ **FLOATING
C590 m2_20320_22900# a_20000_21737# 0 $ **FLOATING
C591 m2_20000_22690# a_20000_21737# 0 $ **FLOATING
C592 m2_22560_23100# a_20000_21737# 0 $ **FLOATING
C593 m2_109660_65100# a_20000_21737# 0 $ **FLOATING
C594 m2_109504_65100# a_20000_21737# 0 $ **FLOATING
C595 m2_109348_65100# a_20000_21737# 0 $ **FLOATING
C596 m2_109192_65100# a_20000_21737# 0 $ **FLOATING
C597 m2_109036_65100# a_20000_21737# 0 $ **FLOATING
C598 m2_108880_65100# a_20000_21737# 0 $ **FLOATING
C599 m2_108724_65100# a_20000_21737# 0 $ **FLOATING
C600 m2_108568_65100# a_20000_21737# 0 $ **FLOATING
C601 m2_108412_65100# a_20000_21737# 0 $ **FLOATING
C602 m2_109644_65240# a_20000_21737# 0 $ **FLOATING
C603 m2_109488_65240# a_20000_21737# 0 $ **FLOATING
C604 m2_109332_65240# a_20000_21737# 0 $ **FLOATING
C605 m2_109176_65240# a_20000_21737# 0 $ **FLOATING
C606 m2_109020_65240# a_20000_21737# 0 $ **FLOATING
C607 m2_108864_65240# a_20000_21737# 0 $ **FLOATING
C608 m2_108708_65240# a_20000_21737# 0 $ **FLOATING
C609 m2_108552_65240# a_20000_21737# 0 $ **FLOATING
C610 m2_108396_65240# a_20000_21737# 0 $ **FLOATING
C611 m2_108280_65200# a_20000_21737# 0 $ **FLOATING
C612 m2_109628_65396# a_20000_21737# 0 $ **FLOATING
C613 m2_109472_65396# a_20000_21737# 0 $ **FLOATING
C614 m2_109316_65396# a_20000_21737# 0 $ **FLOATING
C615 m2_109160_65396# a_20000_21737# 0 $ **FLOATING
C616 m2_109004_65396# a_20000_21737# 0 $ **FLOATING
C617 m2_108848_65396# a_20000_21737# 0 $ **FLOATING
C618 m2_108692_65396# a_20000_21737# 0 $ **FLOATING
C619 m2_108536_65396# a_20000_21737# 0 $ **FLOATING
C620 m2_108380_65396# a_20000_21737# 0 $ **FLOATING
C621 m2_109612_65552# a_20000_21737# 0 $ **FLOATING
C622 m2_109456_65552# a_20000_21737# 0 $ **FLOATING
C623 m2_109300_65552# a_20000_21737# 0 $ **FLOATING
C624 m2_109144_65552# a_20000_21737# 0 $ **FLOATING
C625 m2_108988_65552# a_20000_21737# 0 $ **FLOATING
C626 m2_108832_65552# a_20000_21737# 0 $ **FLOATING
C627 m2_108676_65552# a_20000_21737# 0 $ **FLOATING
C628 m2_108520_65552# a_20000_21737# 0 $ **FLOATING
C629 m2_108364_65552# a_20000_21737# 0 $ **FLOATING
C630 m2_109596_65708# a_20000_21737# 0 $ **FLOATING
C631 m2_108816_65708# a_20000_21737# 0 $ **FLOATING
C632 m2_108660_65708# a_20000_21737# 0 $ **FLOATING
C633 m2_108504_65708# a_20000_21737# 0 $ **FLOATING
C634 m2_108348_65708# a_20000_21737# 0 $ **FLOATING
C635 m2_109580_65864# a_20000_21737# 0 $ **FLOATING
C636 m2_108800_65864# a_20000_21737# 0 $ **FLOATING
C637 m2_108644_65864# a_20000_21737# 0 $ **FLOATING
C638 m2_108488_65864# a_20000_21737# 0 $ **FLOATING
C639 m2_108332_65864# a_20000_21737# 0 $ **FLOATING
C640 m2_109564_66021# a_20000_21737# 0 $ **FLOATING
C641 m2_109408_66021# a_20000_21737# 0 $ **FLOATING
C642 m2_109252_66021# a_20000_21737# 0 $ **FLOATING
C643 m2_109096_66021# a_20000_21737# 0 $ **FLOATING
C644 m2_108940_66021# a_20000_21737# 0 $ **FLOATING
C645 m2_108784_66020# a_20000_21737# 0 $ **FLOATING
C646 m2_108628_66020# a_20000_21737# 0 $ **FLOATING
C647 m2_108472_66020# a_20000_21737# 0 $ **FLOATING
C648 m2_109548_66176# a_20000_21737# 0 $ **FLOATING
C649 m2_109392_66176# a_20000_21737# 0 $ **FLOATING
C650 m2_109236_66176# a_20000_21737# 0 $ **FLOATING
C651 m2_109080_66176# a_20000_21737# 0 $ **FLOATING
C652 m2_108924_66176# a_20000_21737# 0 $ **FLOATING
C653 m2_108768_66176# a_20000_21737# 0 $ **FLOATING
C654 m2_108612_66176# a_20000_21737# 0 $ **FLOATING
C655 m2_108456_66176# a_20000_21737# 0 $ **FLOATING
C656 m2_108280_66200# a_20000_21737# 0 $ **FLOATING
C657 m2_109532_66332# a_20000_21737# 0 $ **FLOATING
C658 m2_109376_66332# a_20000_21737# 0 $ **FLOATING
C659 m2_109220_66332# a_20000_21737# 0 $ **FLOATING
C660 m2_109064_66332# a_20000_21737# 0 $ **FLOATING
C661 m2_108908_66332# a_20000_21737# 0 $ **FLOATING
C662 m2_108752_66332# a_20000_21737# 0 $ **FLOATING
C663 m2_108596_66332# a_20000_21737# 0 $ **FLOATING
C664 m2_108440_66332# a_20000_21737# 0 $ **FLOATING
C665 m2_108300_66300# a_20000_21737# 0 $ **FLOATING
C666 m2_108320_66400# a_20000_21737# 0 $ **FLOATING
C667 m2_109672_66488# a_20000_21737# 0 $ **FLOATING
C668 m2_109516_66488# a_20000_21737# 0 $ **FLOATING
C669 m2_109360_66488# a_20000_21737# 0 $ **FLOATING
C670 m2_109204_66488# a_20000_21737# 0 $ **FLOATING
C671 m2_109048_66488# a_20000_21737# 0 $ **FLOATING
C672 m2_108892_66488# a_20000_21737# 0 $ **FLOATING
C673 m2_108736_66488# a_20000_21737# 0 $ **FLOATING
C674 m2_108580_66488# a_20000_21737# 0 $ **FLOATING
C675 m2_108424_66488# a_20000_21737# 0 $ **FLOATING
C676 m2_109656_66644# a_20000_21737# 0 $ **FLOATING
C677 m2_109500_66644# a_20000_21737# 0 $ **FLOATING
C678 m2_109344_66644# a_20000_21737# 0 $ **FLOATING
C679 m2_109188_66644# a_20000_21737# 0 $ **FLOATING
C680 m2_109032_66644# a_20000_21737# 0 $ **FLOATING
C681 m2_108876_66644# a_20000_21737# 0 $ **FLOATING
C682 m2_108720_66644# a_20000_21737# 0 $ **FLOATING
C683 m2_108564_66644# a_20000_21737# 0 $ **FLOATING
C684 m2_108408_66644# a_20000_21737# 0 $ **FLOATING
C685 m2_108280_66700# a_20000_21737# 0 $ **FLOATING
C686 m2_109640_66800# a_20000_21737# 0 $ **FLOATING
C687 m2_109484_66800# a_20000_21737# 0 $ **FLOATING
C688 m2_109328_66800# a_20000_21737# 0 $ **FLOATING
C689 m2_109172_66800# a_20000_21737# 0 $ **FLOATING
C690 m2_109016_66800# a_20000_21737# 0 $ **FLOATING
C691 m2_108860_66800# a_20000_21737# 0 $ **FLOATING
C692 m2_108704_66800# a_20000_21737# 0 $ **FLOATING
C693 m2_108548_66800# a_20000_21737# 0 $ **FLOATING
C694 m2_108392_66800# a_20000_21737# 0 $ **FLOATING
C695 m2_109624_66956# a_20000_21737# 0 $ **FLOATING
C696 m2_109468_66956# a_20000_21737# 0 $ **FLOATING
C697 m2_109312_66956# a_20000_21737# 0 $ **FLOATING
C698 m2_109156_66956# a_20000_21737# 0 $ **FLOATING
C699 m2_109000_66956# a_20000_21737# 0 $ **FLOATING
C700 m2_108844_66956# a_20000_21737# 0 $ **FLOATING
C701 m2_108688_66956# a_20000_21737# 0 $ **FLOATING
C702 m2_108532_66956# a_20000_21737# 0 $ **FLOATING
C703 m2_108376_66956# a_20000_21737# 0 $ **FLOATING
C704 m2_109608_67112# a_20000_21737# 0 $ **FLOATING
C705 m2_108828_67112# a_20000_21737# 0 $ **FLOATING
C706 m2_108672_67112# a_20000_21737# 0 $ **FLOATING
C707 m2_108516_67112# a_20000_21737# 0 $ **FLOATING
C708 m2_108360_67112# a_20000_21737# 0 $ **FLOATING
C709 m2_109592_67268# a_20000_21737# 0 $ **FLOATING
C710 m2_108812_67268# a_20000_21737# 0 $ **FLOATING
C711 m2_108700_67300# a_20000_21737# 0 $ **FLOATING
C712 m2_108344_67268# a_20000_21737# 0 $ **FLOATING
C713 m2_109576_67424# a_20000_21737# 0 $ **FLOATING
C714 m2_109420_67424# a_20000_21737# 0 $ **FLOATING
C715 m2_109264_67424# a_20000_21737# 0 $ **FLOATING
C716 m2_109108_67424# a_20000_21737# 0 $ **FLOATING
C717 m2_108952_67424# a_20000_21737# 0 $ **FLOATING
C718 m2_108796_67424# a_20000_21737# 0 $ **FLOATING
C719 m2_109560_67580# a_20000_21737# 0 $ **FLOATING
C720 m2_109404_67580# a_20000_21737# 0 $ **FLOATING
C721 m2_109248_67580# a_20000_21737# 0 $ **FLOATING
C722 m2_109092_67580# a_20000_21737# 0 $ **FLOATING
C723 m2_108936_67580# a_20000_21737# 0 $ **FLOATING
C724 m2_108780_67580# a_20000_21737# 0 $ **FLOATING
C725 m2_108328_67424# a_20000_21737# 0 $ **FLOATING
C726 m2_108190_65100# a_20000_21737# 3.5299200000000008e-16
C727 m2_107998_65100# a_20000_21737# 1.9860200000000002e-16
C728 m2_107860_65100# a_20000_21737# 0 $ **FLOATING
C729 m2_107632_65100# a_20000_21737# 0 $ **FLOATING
C730 m2_107476_65100# a_20000_21737# 0 $ **FLOATING
C731 m2_107772_65240# a_20000_21737# 0 $ **FLOATING
C732 m2_107616_65240# a_20000_21737# 0 $ **FLOATING
C733 m2_107460_65240# a_20000_21737# 0 $ **FLOATING
C734 m2_107756_65396# a_20000_21737# 0 $ **FLOATING
C735 m2_107600_65396# a_20000_21737# 0 $ **FLOATING
C736 m2_107420_65400# a_20000_21737# 0 $ **FLOATING
C737 m2_107740_65552# a_20000_21737# 0 $ **FLOATING
C738 m2_107584_65552# a_20000_21737# 0 $ **FLOATING
C739 m2_107440_65500# a_20000_21737# 0 $ **FLOATING
C740 m2_107460_65600# a_20000_21737# 0 $ **FLOATING
C741 m2_107724_65708# a_20000_21737# 0 $ **FLOATING
C742 m2_107568_65708# a_20000_21737# 0 $ **FLOATING
C743 m2_107708_65864# a_20000_21737# 0 $ **FLOATING
C744 m2_107552_65864# a_20000_21737# 0 $ **FLOATING
C745 m2_107420_65900# a_20000_21737# 0 $ **FLOATING
C746 m2_107860_66100# a_20000_21737# 0 $ **FLOATING
C747 m2_107692_66020# a_20000_21737# 0 $ **FLOATING
C748 m2_107536_66020# a_20000_21737# 0 $ **FLOATING
C749 m2_107676_66176# a_20000_21737# 0 $ **FLOATING
C750 m2_107480_66200# a_20000_21737# 0 $ **FLOATING
C751 m2_107820_66400# a_20000_21737# 0 $ **FLOATING
C752 m2_107660_66332# a_20000_21737# 0 $ **FLOATING
C753 m2_107840_66500# a_20000_21737# 0 $ **FLOATING
C754 m2_107740_66500# a_20000_21737# 0 $ **FLOATING
C755 m2_107640_66500# a_20000_21737# 0 $ **FLOATING
C756 m2_107860_66600# a_20000_21737# 0 $ **FLOATING
C757 m2_107760_66600# a_20000_21737# 0 $ **FLOATING
C758 m2_107660_66600# a_20000_21737# 0 $ **FLOATING
C759 m2_107780_66700# a_20000_21737# 0 $ **FLOATING
C760 m2_107680_66700# a_20000_21737# 0 $ **FLOATING
C761 m2_107768_66800# a_20000_21737# 0 $ **FLOATING
C762 m2_107752_66956# a_20000_21737# 0 $ **FLOATING
C763 m2_107620_66900# a_20000_21737# 0 $ **FLOATING
C764 m2_107640_67000# a_20000_21737# 0 $ **FLOATING
C765 m2_107736_67112# a_20000_21737# 0 $ **FLOATING
C766 m2_107720_67268# a_20000_21737# 0 $ **FLOATING
C767 m2_107704_67424# a_20000_21737# 0 $ **FLOATING
C768 m2_107688_67580# a_20000_21737# 0 $ **FLOATING
C769 m2_107326_65100# a_20000_21737# 5.6525900000000012e-16
C770 m2_107200_65100# a_20000_21737# 0 $ **FLOATING
C771 m2_107200_65200# a_20000_21737# 0 $ **FLOATING
C772 m2_107200_65300# a_20000_21737# 0 $ **FLOATING
C773 m2_107200_65600# a_20000_21737# 0 $ **FLOATING
C774 m2_107200_65700# a_20000_21737# 0 $ **FLOATING
C775 m2_107200_65800# a_20000_21737# 0 $ **FLOATING
C776 m2_107200_66100# a_20000_21737# 0 $ **FLOATING
C777 m2_107200_66200# a_20000_21737# 0 $ **FLOATING
C778 m2_107200_66300# a_20000_21737# 0 $ **FLOATING
C779 m2_107200_66600# a_20000_21737# 0 $ **FLOATING
C780 m2_107200_66700# a_20000_21737# 0 $ **FLOATING
C781 m2_107200_66800# a_20000_21737# 0 $ **FLOATING
C782 m2_107200_67100# a_20000_21737# 0 $ **FLOATING
C783 m2_107200_67200# a_20000_21737# 0 $ **FLOATING
C784 m2_107200_67300# a_20000_21737# 0 $ **FLOATING
C785 m1_23090_20000# a_20000_21737# 0 $ **FLOATING
C786 m1_22970_20110# a_20000_21737# 0 $ **FLOATING
C787 m1_22990_20210# a_20000_21737# 0 $ **FLOATING
C788 m1_22530_20000# a_20000_21737# 0 $ **FLOATING
C789 m1_21970_20000# a_20000_21737# 0 $ **FLOATING
C790 m1_21850_20010# a_20000_21737# 0 $ **FLOATING
C791 m1_21870_20110# a_20000_21737# 0 $ **FLOATING
C792 m1_21410_20000# a_20000_21737# 0 $ **FLOATING
C793 m1_21290_20210# a_20000_21737# 0 $ **FLOATING
C794 m1_20850_20000# a_20000_21737# 0 $ **FLOATING
C795 m1_20750_20010# a_20000_21737# 0 $ **FLOATING
C796 m1_20290_20000# a_20000_21737# 0 $ **FLOATING
C797 m1_20170_20110# a_20000_21737# 0 $ **FLOATING
C798 m1_20190_20210# a_20000_21737# 0 $ **FLOATING
C799 m1_20000_20000# a_20000_21737# 0 $ **FLOATING
C800 m1_23180_20340# a_20000_21737# 0 $ **FLOATING
C801 m1_22940_20340# a_20000_21737# 0 $ **FLOATING
C802 m1_22700_20340# a_20000_21737# 0 $ **FLOATING
C803 m1_22460_20340# a_20000_21737# 0 $ **FLOATING
C804 m1_22220_20340# a_20000_21737# 0 $ **FLOATING
C805 m1_21980_20340# a_20000_21737# 0 $ **FLOATING
C806 m1_21740_20340# a_20000_21737# 0 $ **FLOATING
C807 m1_21500_20340# a_20000_21737# 0 $ **FLOATING
C808 m1_21260_20340# a_20000_21737# 0 $ **FLOATING
C809 m1_21020_20340# a_20000_21737# 0 $ **FLOATING
C810 m1_20780_20340# a_20000_21737# 0 $ **FLOATING
C811 m1_20540_20340# a_20000_21737# 0 $ **FLOATING
C812 m1_20300_20340# a_20000_21737# 0 $ **FLOATING
C813 m1_20060_20340# a_20000_21737# 0 $ **FLOATING
C814 m1_20000_20340# a_20000_21737# 0 $ **FLOATING
C815 m1_23080_20580# a_20000_21737# 0 $ **FLOATING
C816 m1_22840_20580# a_20000_21737# 0 $ **FLOATING
C817 m1_22600_20580# a_20000_21737# 0 $ **FLOATING
C818 m1_22360_20580# a_20000_21737# 0 $ **FLOATING
C819 m1_22120_20580# a_20000_21737# 0 $ **FLOATING
C820 m1_21880_20580# a_20000_21737# 0 $ **FLOATING
C821 m1_21640_20580# a_20000_21737# 0 $ **FLOATING
C822 m1_21400_20580# a_20000_21737# 0 $ **FLOATING
C823 m1_21160_20580# a_20000_21737# 0 $ **FLOATING
C824 m1_20920_20580# a_20000_21737# 0 $ **FLOATING
C825 m1_20680_20580# a_20000_21737# 0 $ **FLOATING
C826 m1_20440_20580# a_20000_21737# 0 $ **FLOATING
C827 m1_20200_20580# a_20000_21737# 0 $ **FLOATING
C828 m1_20000_20580# a_20000_21737# 0 $ **FLOATING
C829 m1_23170_20850# a_20000_21737# 0 $ **FLOATING
C830 m1_23014_20850# a_20000_21737# 0 $ **FLOATING
C831 m1_22858_20850# a_20000_21737# 0 $ **FLOATING
C832 m1_22702_20850# a_20000_21737# 0 $ **FLOATING
C833 m1_22546_20850# a_20000_21737# 0 $ **FLOATING
C834 m1_22390_20850# a_20000_21737# 0 $ **FLOATING
C835 m1_22234_20850# a_20000_21737# 0 $ **FLOATING
C836 m1_22078_20850# a_20000_21737# 0 $ **FLOATING
C837 m1_21922_20850# a_20000_21737# 0 $ **FLOATING
C838 m1_21766_20850# a_20000_21737# 0 $ **FLOATING
C839 m1_21610_20850# a_20000_21737# 0 $ **FLOATING
C840 m1_21454_20850# a_20000_21737# 0 $ **FLOATING
C841 m1_21298_20850# a_20000_21737# 0 $ **FLOATING
C842 m1_21142_20850# a_20000_21737# 0 $ **FLOATING
C843 m1_20986_20850# a_20000_21737# 0 $ **FLOATING
C844 m1_20830_20850# a_20000_21737# 0 $ **FLOATING
C845 m1_20674_20850# a_20000_21737# 0 $ **FLOATING
C846 m1_20518_20850# a_20000_21737# 0 $ **FLOATING
C847 m1_20362_20850# a_20000_21737# 0 $ **FLOATING
C848 m1_20206_20850# a_20000_21737# 0 $ **FLOATING
C849 m1_20050_20850# a_20000_21737# 0 $ **FLOATING
C850 m1_20000_20850# a_20000_21737# 0 $ **FLOATING
C851 m1_23154_21006# a_20000_21737# 0 $ **FLOATING
C852 m1_22998_21006# a_20000_21737# 0 $ **FLOATING
C853 m1_22842_21006# a_20000_21737# 0 $ **FLOATING
C854 m1_22686_21006# a_20000_21737# 0 $ **FLOATING
C855 m1_22530_21006# a_20000_21737# 0 $ **FLOATING
C856 m1_22374_21006# a_20000_21737# 0 $ **FLOATING
C857 m1_22218_21006# a_20000_21737# 0 $ **FLOATING
C858 m1_22062_21006# a_20000_21737# 0 $ **FLOATING
C859 m1_21906_21006# a_20000_21737# 0 $ **FLOATING
C860 m1_21750_21006# a_20000_21737# 0 $ **FLOATING
C861 m1_21594_21006# a_20000_21737# 0 $ **FLOATING
C862 m1_21438_21006# a_20000_21737# 0 $ **FLOATING
C863 m1_21282_21006# a_20000_21737# 0 $ **FLOATING
C864 m1_21126_21006# a_20000_21737# 0 $ **FLOATING
C865 m1_20970_21006# a_20000_21737# 0 $ **FLOATING
C866 m1_20814_21006# a_20000_21737# 0 $ **FLOATING
C867 m1_20658_21006# a_20000_21737# 0 $ **FLOATING
C868 m1_20502_21006# a_20000_21737# 0 $ **FLOATING
C869 m1_20346_21006# a_20000_21737# 0 $ **FLOATING
C870 m1_20190_21006# a_20000_21737# 0 $ **FLOATING
C871 m1_20034_21006# a_20000_21737# 0 $ **FLOATING
C872 m1_23294_21162# a_20000_21737# 0 $ **FLOATING
C873 m1_23138_21162# a_20000_21737# 0 $ **FLOATING
C874 m1_22982_21162# a_20000_21737# 0 $ **FLOATING
C875 m1_22826_21162# a_20000_21737# 0 $ **FLOATING
C876 m1_22670_21162# a_20000_21737# 0 $ **FLOATING
C877 m1_22514_21162# a_20000_21737# 0 $ **FLOATING
C878 m1_22358_21162# a_20000_21737# 0 $ **FLOATING
C879 m1_22202_21162# a_20000_21737# 0 $ **FLOATING
C880 m1_22046_21162# a_20000_21737# 0 $ **FLOATING
C881 m1_21890_21162# a_20000_21737# 0 $ **FLOATING
C882 m1_21734_21162# a_20000_21737# 0 $ **FLOATING
C883 m1_21578_21162# a_20000_21737# 0 $ **FLOATING
C884 m1_21422_21162# a_20000_21737# 0 $ **FLOATING
C885 m1_21266_21162# a_20000_21737# 0 $ **FLOATING
C886 m1_21110_21162# a_20000_21737# 0 $ **FLOATING
C887 m1_20954_21162# a_20000_21737# 0 $ **FLOATING
C888 m1_20798_21162# a_20000_21737# 0 $ **FLOATING
C889 m1_20642_21162# a_20000_21737# 0 $ **FLOATING
C890 m1_20486_21162# a_20000_21737# 0 $ **FLOATING
C891 m1_20330_21162# a_20000_21737# 0 $ **FLOATING
C892 m1_20174_21162# a_20000_21737# 0 $ **FLOATING
C893 m1_20018_21162# a_20000_21737# 0 $ **FLOATING
C894 m1_23246_21630# a_20000_21737# 0 $ **FLOATING
C895 m1_23090_21630# a_20000_21737# 0 $ **FLOATING
C896 m1_22934_21630# a_20000_21737# 0 $ **FLOATING
C897 m1_22778_21630# a_20000_21737# 0 $ **FLOATING
C898 m1_22622_21630# a_20000_21737# 0 $ **FLOATING
C899 m1_22466_21630# a_20000_21737# 0 $ **FLOATING
C900 m1_22310_21630# a_20000_21737# 0 $ **FLOATING
C901 m1_22154_21630# a_20000_21737# 0 $ **FLOATING
C902 m1_21998_21630# a_20000_21737# 0 $ **FLOATING
C903 m1_21842_21630# a_20000_21737# 0 $ **FLOATING
C904 m1_21686_21630# a_20000_21737# 0 $ **FLOATING
C905 m1_21530_21630# a_20000_21737# 0 $ **FLOATING
C906 m1_21374_21630# a_20000_21737# 0 $ **FLOATING
C907 m1_21218_21630# a_20000_21737# 0 $ **FLOATING
C908 m1_21062_21630# a_20000_21737# 0 $ **FLOATING
C909 m1_20906_21630# a_20000_21737# 0 $ **FLOATING
C910 m1_20750_21630# a_20000_21737# 0 $ **FLOATING
C911 m1_20594_21630# a_20000_21737# 0 $ **FLOATING
C912 m1_20438_21630# a_20000_21737# 0 $ **FLOATING
C913 m1_20282_21630# a_20000_21737# 0 $ **FLOATING
C914 m1_20126_21630# a_20000_21737# 0 $ **FLOATING
C915 m1_20000_21630# a_20000_21737# 0 $ **FLOATING
C916 m1_23210_21810# a_20000_21737# 0 $ **FLOATING
C917 m1_23110_21810# a_20000_21737# 0 $ **FLOATING
C918 m1_23010_21810# a_20000_21737# 0 $ **FLOATING
C919 m1_22910_21810# a_20000_21737# 0 $ **FLOATING
C920 m1_22810_21810# a_20000_21737# 0 $ **FLOATING
C921 m1_22710_21810# a_20000_21737# 0 $ **FLOATING
C922 m1_22610_21810# a_20000_21737# 0 $ **FLOATING
C923 m1_22510_21810# a_20000_21737# 0 $ **FLOATING
C924 m1_22410_21810# a_20000_21737# 0 $ **FLOATING
C925 m1_22310_21810# a_20000_21737# 0 $ **FLOATING
C926 m1_22210_21810# a_20000_21737# 0 $ **FLOATING
C927 m1_22110_21810# a_20000_21737# 0 $ **FLOATING
C928 m1_22010_21810# a_20000_21737# 0 $ **FLOATING
C929 m1_21910_21810# a_20000_21737# 0 $ **FLOATING
C930 m1_21810_21810# a_20000_21737# 0 $ **FLOATING
C931 m1_21710_21810# a_20000_21737# 0 $ **FLOATING
C932 m1_21610_21810# a_20000_21737# 0 $ **FLOATING
C933 m1_21510_21810# a_20000_21737# 0 $ **FLOATING
C934 m1_21410_21810# a_20000_21737# 0 $ **FLOATING
C935 m1_21310_21810# a_20000_21737# 0 $ **FLOATING
C936 m1_21210_21810# a_20000_21737# 0 $ **FLOATING
C937 m1_21110_21810# a_20000_21737# 0 $ **FLOATING
C938 m1_21010_21810# a_20000_21737# 0 $ **FLOATING
C939 m1_20910_21810# a_20000_21737# 0 $ **FLOATING
C940 m1_20810_21810# a_20000_21737# 0 $ **FLOATING
C941 m1_20710_21810# a_20000_21737# 0 $ **FLOATING
C942 m1_20610_21810# a_20000_21737# 0 $ **FLOATING
C943 m1_20510_21810# a_20000_21737# 0 $ **FLOATING
C944 m1_20410_21810# a_20000_21737# 0 $ **FLOATING
C945 m1_20310_21810# a_20000_21737# 0 $ **FLOATING
C946 m1_20210_21810# a_20000_21737# 0 $ **FLOATING
C947 m1_20110_21810# a_20000_21737# 0 $ **FLOATING
C948 m1_20010_21810# a_20000_21737# 0 $ **FLOATING
C949 m1_23270_22110# a_20000_21737# 0 $ **FLOATING
C950 m1_23170_22110# a_20000_21737# 0 $ **FLOATING
C951 m1_23070_22110# a_20000_21737# 0 $ **FLOATING
C952 m1_22970_22110# a_20000_21737# 0 $ **FLOATING
C953 m1_22870_22110# a_20000_21737# 0 $ **FLOATING
C954 m1_22770_22110# a_20000_21737# 0 $ **FLOATING
C955 m1_22670_22110# a_20000_21737# 0 $ **FLOATING
C956 m1_22570_22110# a_20000_21737# 0 $ **FLOATING
C957 m1_22470_22110# a_20000_21737# 0 $ **FLOATING
C958 m1_22370_22110# a_20000_21737# 0 $ **FLOATING
C959 m1_22270_22110# a_20000_21737# 0 $ **FLOATING
C960 m1_22170_22110# a_20000_21737# 0 $ **FLOATING
C961 m1_22070_22110# a_20000_21737# 0 $ **FLOATING
C962 m1_21970_22110# a_20000_21737# 0 $ **FLOATING
C963 m1_21870_22110# a_20000_21737# 0 $ **FLOATING
C964 m1_21770_22110# a_20000_21737# 0 $ **FLOATING
C965 m1_21670_22110# a_20000_21737# 0 $ **FLOATING
C966 m1_21570_22110# a_20000_21737# 0 $ **FLOATING
C967 m1_21470_22110# a_20000_21737# 0 $ **FLOATING
C968 m1_21370_22110# a_20000_21737# 0 $ **FLOATING
C969 m1_21270_22110# a_20000_21737# 0 $ **FLOATING
C970 m1_21170_22110# a_20000_21737# 0 $ **FLOATING
C971 m1_21070_22110# a_20000_21737# 0 $ **FLOATING
C972 m1_20970_22110# a_20000_21737# 0 $ **FLOATING
C973 m1_20870_22110# a_20000_21737# 0 $ **FLOATING
C974 m1_20770_22110# a_20000_21737# 0 $ **FLOATING
C975 m1_20670_22110# a_20000_21737# 0 $ **FLOATING
C976 m1_20570_22110# a_20000_21737# 0 $ **FLOATING
C977 m1_20470_22110# a_20000_21737# 0 $ **FLOATING
C978 m1_20370_22110# a_20000_21737# 0 $ **FLOATING
C979 m1_20270_22110# a_20000_21737# 0 $ **FLOATING
C980 m1_20170_22110# a_20000_21737# 0 $ **FLOATING
C981 m1_20070_22110# a_20000_21737# 0 $ **FLOATING
C982 m1_20000_22110# a_20000_21737# 0 $ **FLOATING
C983 m1_23182_22254# a_20000_21737# 0 $ **FLOATING
C984 m1_23026_22254# a_20000_21737# 0 $ **FLOATING
C985 m1_22870_22254# a_20000_21737# 0 $ **FLOATING
C986 m1_22714_22254# a_20000_21737# 0 $ **FLOATING
C987 m1_22558_22254# a_20000_21737# 0 $ **FLOATING
C988 m1_22402_22254# a_20000_21737# 0 $ **FLOATING
C989 m1_22246_22254# a_20000_21737# 0 $ **FLOATING
C990 m1_22090_22254# a_20000_21737# 0 $ **FLOATING
C991 m1_21934_22254# a_20000_21737# 0 $ **FLOATING
C992 m1_21778_22254# a_20000_21737# 0 $ **FLOATING
C993 m1_21622_22254# a_20000_21737# 0 $ **FLOATING
C994 m1_21466_22254# a_20000_21737# 0 $ **FLOATING
C995 m1_21310_22254# a_20000_21737# 0 $ **FLOATING
C996 m1_21154_22254# a_20000_21737# 0 $ **FLOATING
C997 m1_20998_22254# a_20000_21737# 0 $ **FLOATING
C998 m1_20842_22254# a_20000_21737# 0 $ **FLOATING
C999 m1_20686_22254# a_20000_21737# 0 $ **FLOATING
C1000 m1_20530_22254# a_20000_21737# 0 $ **FLOATING
C1001 m1_20374_22254# a_20000_21737# 0 $ **FLOATING
C1002 m1_20218_22254# a_20000_21737# 0 $ **FLOATING
C1003 m1_20062_22254# a_20000_21737# 0 $ **FLOATING
C1004 m1_20000_22254# a_20000_21737# 0 $ **FLOATING
C1005 m1_23290_22722# a_20000_21737# 0 $ **FLOATING
C1006 m1_23134_22722# a_20000_21737# 0 $ **FLOATING
C1007 m1_22978_22722# a_20000_21737# 0 $ **FLOATING
C1008 m1_22822_22722# a_20000_21737# 0 $ **FLOATING
C1009 m1_22666_22722# a_20000_21737# 0 $ **FLOATING
C1010 m1_22510_22722# a_20000_21737# 0 $ **FLOATING
C1011 m1_22354_22722# a_20000_21737# 0 $ **FLOATING
C1012 m1_22198_22722# a_20000_21737# 0 $ **FLOATING
C1013 m1_22042_22722# a_20000_21737# 0 $ **FLOATING
C1014 m1_21886_22722# a_20000_21737# 0 $ **FLOATING
C1015 m1_21730_22722# a_20000_21737# 0 $ **FLOATING
C1016 m1_21574_22722# a_20000_21737# 0 $ **FLOATING
C1017 m1_21418_22722# a_20000_21737# 0 $ **FLOATING
C1018 m1_21262_22722# a_20000_21737# 0 $ **FLOATING
C1019 m1_21106_22722# a_20000_21737# 0 $ **FLOATING
C1020 m1_20950_22722# a_20000_21737# 0 $ **FLOATING
C1021 m1_20794_22722# a_20000_21737# 0 $ **FLOATING
C1022 m1_20638_22722# a_20000_21737# 0 $ **FLOATING
C1023 m1_20482_22722# a_20000_21737# 0 $ **FLOATING
C1024 m1_20326_22722# a_20000_21737# 0 $ **FLOATING
C1025 m1_20170_22722# a_20000_21737# 0 $ **FLOATING
C1026 m1_20014_22722# a_20000_21737# 0 $ **FLOATING
C1027 m1_109698_65466# a_20000_21737# 0 $ **FLOATING
C1028 m1_109542_65466# a_20000_21737# 0 $ **FLOATING
C1029 m1_109386_65466# a_20000_21737# 0 $ **FLOATING
C1030 m1_109230_65466# a_20000_21737# 0 $ **FLOATING
C1031 m1_109074_65466# a_20000_21737# 0 $ **FLOATING
C1032 m1_108918_65466# a_20000_21737# 0 $ **FLOATING
C1033 m1_108762_65466# a_20000_21737# 0 $ **FLOATING
C1034 m1_108606_65466# a_20000_21737# 0 $ **FLOATING
C1035 m1_108450_65466# a_20000_21737# 0 $ **FLOATING
C1036 m1_108294_65466# a_20000_21737# 0 $ **FLOATING
C1037 m1_108138_65466# a_20000_21737# 0 $ **FLOATING
C1038 m1_107982_65466# a_20000_21737# 0 $ **FLOATING
C1039 m1_107826_65466# a_20000_21737# 0 $ **FLOATING
C1040 m1_107670_65466# a_20000_21737# 0 $ **FLOATING
C1041 m1_107514_65466# a_20000_21737# 0 $ **FLOATING
C1042 m1_107358_65466# a_20000_21737# 0 $ **FLOATING
C1043 m1_107202_65466# a_20000_21737# 0 $ **FLOATING
C1044 m1_109682_65622# a_20000_21737# 0 $ **FLOATING
C1045 m1_109490_65710# a_20000_21737# 0 $ **FLOATING
C1046 m1_109390_65710# a_20000_21737# 0 $ **FLOATING
C1047 m1_109290_65710# a_20000_21737# 0 $ **FLOATING
C1048 m1_109190_65710# a_20000_21737# 0 $ **FLOATING
C1049 m1_109090_65710# a_20000_21737# 0 $ **FLOATING
C1050 m1_108990_65710# a_20000_21737# 0 $ **FLOATING
C1051 m1_108890_65710# a_20000_21737# 0 $ **FLOATING
C1052 m1_108790_65710# a_20000_21737# 0 $ **FLOATING
C1053 m1_108690_65710# a_20000_21737# 0 $ **FLOATING
C1054 m1_108590_65710# a_20000_21737# 0 $ **FLOATING
C1055 m1_108490_65710# a_20000_21737# 0 $ **FLOATING
C1056 m1_108390_65710# a_20000_21737# 0 $ **FLOATING
C1057 m1_108290_65710# a_20000_21737# 0 $ **FLOATING
C1058 m1_108190_65710# a_20000_21737# 0 $ **FLOATING
C1059 m1_108090_65710# a_20000_21737# 0 $ **FLOATING
C1060 m1_107990_65710# a_20000_21737# 0 $ **FLOATING
C1061 m1_107890_65710# a_20000_21737# 0 $ **FLOATING
C1062 m1_107790_65710# a_20000_21737# 0 $ **FLOATING
C1063 m1_107690_65710# a_20000_21737# 0 $ **FLOATING
C1064 m1_107590_65710# a_20000_21737# 0 $ **FLOATING
C1065 m1_107490_65710# a_20000_21737# 0 $ **FLOATING
C1066 m1_107390_65710# a_20000_21737# 0 $ **FLOATING
C1067 m1_107290_65710# a_20000_21737# 0 $ **FLOATING
C1068 m1_107200_65710# a_20000_21737# 0 $ **FLOATING
C1069 m1_109666_65778# a_20000_21737# 0 $ **FLOATING
C1070 m1_109650_65934# a_20000_21737# 0 $ **FLOATING
C1071 m1_109634_66090# a_20000_21737# 0 $ **FLOATING
C1072 m1_109478_66090# a_20000_21737# 0 $ **FLOATING
C1073 m1_109322_66090# a_20000_21737# 0 $ **FLOATING
C1074 m1_109166_66090# a_20000_21737# 0 $ **FLOATING
C1075 m1_109010_66090# a_20000_21737# 0 $ **FLOATING
C1076 m1_108854_66090# a_20000_21737# 0 $ **FLOATING
C1077 m1_108698_66090# a_20000_21737# 0 $ **FLOATING
C1078 m1_108542_66090# a_20000_21737# 0 $ **FLOATING
C1079 m1_108386_66090# a_20000_21737# 0 $ **FLOATING
C1080 m1_108230_66090# a_20000_21737# 0 $ **FLOATING
C1081 m1_108074_66090# a_20000_21737# 0 $ **FLOATING
C1082 m1_107918_66090# a_20000_21737# 0 $ **FLOATING
C1083 m1_107762_66090# a_20000_21737# 0 $ **FLOATING
C1084 m1_107606_66090# a_20000_21737# 0 $ **FLOATING
C1085 m1_107450_66090# a_20000_21737# 0 $ **FLOATING
C1086 m1_107294_66090# a_20000_21737# 0 $ **FLOATING
C1087 m1_107200_66090# a_20000_21737# 0 $ **FLOATING
C1088 m1_109618_66246# a_20000_21737# 0 $ **FLOATING
C1089 m1_109462_66246# a_20000_21737# 0 $ **FLOATING
C1090 m1_109306_66246# a_20000_21737# 0 $ **FLOATING
C1091 m1_109150_66246# a_20000_21737# 0 $ **FLOATING
C1092 m1_108994_66246# a_20000_21737# 0 $ **FLOATING
C1093 m1_108838_66246# a_20000_21737# 0 $ **FLOATING
C1094 m1_108682_66246# a_20000_21737# 0 $ **FLOATING
C1095 m1_108526_66246# a_20000_21737# 0 $ **FLOATING
C1096 m1_108370_66246# a_20000_21737# 0 $ **FLOATING
C1097 m1_108214_66246# a_20000_21737# 0 $ **FLOATING
C1098 m1_108058_66246# a_20000_21737# 0 $ **FLOATING
C1099 m1_107902_66246# a_20000_21737# 0 $ **FLOATING
C1100 m1_107746_66246# a_20000_21737# 0 $ **FLOATING
C1101 m1_107200_66388# a_20000_21737# 1.31212e-16
C1102 m1_109570_66714# a_20000_21737# 0 $ **FLOATING
C1103 m1_109414_66714# a_20000_21737# 0 $ **FLOATING
C1104 m1_109258_66714# a_20000_21737# 0 $ **FLOATING
C1105 m1_109102_66714# a_20000_21737# 0 $ **FLOATING
C1106 m1_108946_66714# a_20000_21737# 0 $ **FLOATING
C1107 m1_108790_66714# a_20000_21737# 0 $ **FLOATING
C1108 m1_108634_66714# a_20000_21737# 0 $ **FLOATING
C1109 m1_108478_66714# a_20000_21737# 0 $ **FLOATING
C1110 m1_108322_66714# a_20000_21737# 0 $ **FLOATING
C1111 m1_108166_66714# a_20000_21737# 0 $ **FLOATING
C1112 m1_108010_66714# a_20000_21737# 0 $ **FLOATING
C1113 m1_107854_66714# a_20000_21737# 0 $ **FLOATING
C1114 m1_107698_66714# a_20000_21737# 0 $ **FLOATING
C1115 m1_107542_66714# a_20000_21737# 0 $ **FLOATING
C1116 m1_107386_66714# a_20000_21737# 0 $ **FLOATING
C1117 m1_107230_66714# a_20000_21737# 0 $ **FLOATING
C1118 m1_109554_66870# a_20000_21737# 0 $ **FLOATING
C1119 m1_109398_66870# a_20000_21737# 0 $ **FLOATING
C1120 m1_109242_66870# a_20000_21737# 0 $ **FLOATING
C1121 m1_109086_66870# a_20000_21737# 0 $ **FLOATING
C1122 m1_108930_66870# a_20000_21737# 0 $ **FLOATING
C1123 m1_108774_66870# a_20000_21737# 0 $ **FLOATING
C1124 m1_108618_66870# a_20000_21737# 0 $ **FLOATING
C1125 m1_108462_66870# a_20000_21737# 0 $ **FLOATING
C1126 m1_108306_66870# a_20000_21737# 0 $ **FLOATING
C1127 m1_108150_66870# a_20000_21737# 0 $ **FLOATING
C1128 m1_107994_66870# a_20000_21737# 0 $ **FLOATING
C1129 m1_107838_66870# a_20000_21737# 0 $ **FLOATING
C1130 m1_107682_66870# a_20000_21737# 0 $ **FLOATING
C1131 m1_107526_66870# a_20000_21737# 0 $ **FLOATING
C1132 m1_107370_66870# a_20000_21737# 0 $ **FLOATING
C1133 m1_107214_66870# a_20000_21737# 0 $ **FLOATING
C1134 m1_109694_67026# a_20000_21737# 0 $ **FLOATING
C1135 m1_109570_67110# a_20000_21737# 0 $ **FLOATING
C1136 m1_109690_67210# a_20000_21737# 0 $ **FLOATING
C1137 m1_109590_67210# a_20000_21737# 0 $ **FLOATING
C1138 m1_107200_67350# a_20000_21737# 3.5300800000000001e-16
C1139 m1_107200_67424# a_20000_21737# 3.7989600000000005e-16
C1140 m1_109646_67494# a_20000_21737# 0 $ **FLOATING
C1141 m1_109490_67494# a_20000_21737# 0 $ **FLOATING
C1142 m1_109334_67494# a_20000_21737# 0 $ **FLOATING
C1143 m1_109178_67494# a_20000_21737# 0 $ **FLOATING
C1144 m1_109022_67494# a_20000_21737# 0 $ **FLOATING
C1145 m1_108866_67494# a_20000_21737# 0 $ **FLOATING
C1146 m1_108750_67510# a_20000_21737# 0 $ **FLOATING
C1147 li_23150_20140# a_20000_21737# 0 $ **FLOATING
C1148 li_22370_20140# a_20000_21737# 0 $ **FLOATING
C1149 li_21590_20140# a_20000_21737# 0 $ **FLOATING
C1150 li_20810_20140# a_20000_21737# 0 $ **FLOATING
C1151 li_20030_20140# a_20000_21737# 0 $ **FLOATING
C1152 li_23102_20850# a_20000_21737# 0 $ **FLOATING
C1153 li_22886_20850# a_20000_21737# 0 $ **FLOATING
C1154 li_22670_20850# a_20000_21737# 0 $ **FLOATING
C1155 li_22454_20850# a_20000_21737# 0 $ **FLOATING
C1156 li_22238_20850# a_20000_21737# 0 $ **FLOATING
C1157 li_22022_20850# a_20000_21737# 0 $ **FLOATING
C1158 li_21806_20850# a_20000_21737# 0 $ **FLOATING
C1159 li_21590_20850# a_20000_21737# 0 $ **FLOATING
C1160 li_21374_20850# a_20000_21737# 0 $ **FLOATING
C1161 li_21158_20850# a_20000_21737# 0 $ **FLOATING
C1162 li_20942_20850# a_20000_21737# 0 $ **FLOATING
C1163 li_20726_20850# a_20000_21737# 0 $ **FLOATING
C1164 li_20510_20850# a_20000_21737# 0 $ **FLOATING
C1165 li_20294_20850# a_20000_21737# 0 $ **FLOATING
C1166 li_20078_20850# a_20000_21737# 0 $ **FLOATING
C1167 li_23242_21066# a_20000_21737# 0 $ **FLOATING
C1168 li_23026_21066# a_20000_21737# 0 $ **FLOATING
C1169 li_22810_21066# a_20000_21737# 0 $ **FLOATING
C1170 li_22594_21066# a_20000_21737# 0 $ **FLOATING
C1171 li_22378_21066# a_20000_21737# 0 $ **FLOATING
C1172 li_22162_21066# a_20000_21737# 0 $ **FLOATING
C1173 li_21946_21066# a_20000_21737# 0 $ **FLOATING
C1174 li_21730_21066# a_20000_21737# 0 $ **FLOATING
C1175 li_21514_21066# a_20000_21737# 0 $ **FLOATING
C1176 li_21298_21066# a_20000_21737# 0 $ **FLOATING
C1177 li_21082_21066# a_20000_21737# 0 $ **FLOATING
C1178 li_20866_21066# a_20000_21737# 0 $ **FLOATING
C1179 li_20650_21066# a_20000_21737# 0 $ **FLOATING
C1180 li_20434_21066# a_20000_21737# 0 $ **FLOATING
C1181 li_20218_21066# a_20000_21737# 0 $ **FLOATING
C1182 li_20002_21066# a_20000_21737# 0 $ **FLOATING
C1183 li_109042_65130# a_20000_21737# 0 $ **FLOATING
C1184 li_108826_65130# a_20000_21737# 0 $ **FLOATING
C1185 li_109330_65250# a_20000_21737# 0 $ **FLOATING
C1186 li_108966_65346# a_20000_21737# 0 $ **FLOATING
C1187 li_108102_65346# a_20000_21737# 0 $ **FLOATING
C1188 li_107886_65346# a_20000_21737# 0 $ **FLOATING
C1189 li_107670_65346# a_20000_21737# 0 $ **FLOATING
C1190 li_107454_65346# a_20000_21737# 0 $ **FLOATING
C1191 li_107238_65346# a_20000_21737# 0 $ **FLOATING
C1192 li_109470_65650# a_20000_21737# 0 $ **FLOATING
C1193 li_109106_65562# a_20000_21737# 0 $ **FLOATING
C1194 li_108890_65562# a_20000_21737# 0 $ **FLOATING
C1195 li_108026_65562# a_20000_21737# 0 $ **FLOATING
C1196 li_107810_65562# a_20000_21737# 0 $ **FLOATING
C1197 li_107594_65562# a_20000_21737# 0 $ **FLOATING
C1198 li_107378_65562# a_20000_21737# 0 $ **FLOATING
C1199 li_107200_65562# a_20000_21737# 0 $ **FLOATING
C1200 li_109246_65778# a_20000_21737# 0 $ **FLOATING
C1201 li_109030_65778# a_20000_21737# 0 $ **FLOATING
C1202 li_108814_65778# a_20000_21737# 0 $ **FLOATING
C1203 li_109170_65994# a_20000_21737# 0 $ **FLOATING
C1204 li_108954_65994# a_20000_21737# 0 $ **FLOATING
C1205 li_109410_66160# a_20000_21737# 0 $ **FLOATING
C1206 li_109094_66210# a_20000_21737# 0 $ **FLOATING
C1207 li_108878_66210# a_20000_21737# 0 $ **FLOATING
C1208 li_109018_66426# a_20000_21737# 0 $ **FLOATING
C1209 li_108802_66426# a_20000_21737# 0 $ **FLOATING
C1210 li_108014_66210# a_20000_21737# 0 $ **FLOATING
C1211 li_107798_66210# a_20000_21737# 0 $ **FLOATING
C1212 li_107582_66210# a_20000_21737# 0 $ **FLOATING
C1213 li_107366_66210# a_20000_21737# 0 $ **FLOATING
C1214 li_107200_66210# a_20000_21737# 0 $ **FLOATING
C1215 li_109158_66642# a_20000_21737# 0 $ **FLOATING
C1216 li_108942_66642# a_20000_21737# 0 $ **FLOATING
C1217 li_109550_66940# a_20000_21737# 0 $ **FLOATING
C1218 li_109082_66858# a_20000_21737# 0 $ **FLOATING
C1219 li_108866_66858# a_20000_21737# 0 $ **FLOATING
C1220 li_108002_66858# a_20000_21737# 0 $ **FLOATING
C1221 li_107786_66858# a_20000_21737# 0 $ **FLOATING
C1222 li_107570_66858# a_20000_21737# 0 $ **FLOATING
C1223 li_107354_66858# a_20000_21737# 0 $ **FLOATING
C1224 li_107200_66858# a_20000_21737# 0 $ **FLOATING
C1225 li_109222_67074# a_20000_21737# 0 $ **FLOATING
C1226 li_109006_67074# a_20000_21737# 0 $ **FLOATING
C1227 li_108790_67074# a_20000_21737# 0 $ **FLOATING
C1228 li_109146_67290# a_20000_21737# 0 $ **FLOATING
C1229 li_108930_67290# a_20000_21737# 0 $ **FLOATING
C1230 li_109286_67506# a_20000_21737# 0 $ **FLOATING
C1231 li_109070_67506# a_20000_21737# 0 $ **FLOATING
C1232 li_108854_67506# a_20000_21737# 0 $ **FLOATING
C1233 li_107990_67506# a_20000_21737# 0 $ **FLOATING
C1234 li_107774_67506# a_20000_21737# 0 $ **FLOATING
C1235 li_107558_67506# a_20000_21737# 0 $ **FLOATING
C1236 li_107342_67506# a_20000_21737# 0 $ **FLOATING
C1237 li_107200_67506# a_20000_21737# 0 $ **FLOATING
C1238 a_22644_20000# a_20000_21737# 0 $ **FLOATING
C1239 a_22386_20000# a_20000_21737# 0 $ **FLOATING
C1240 a_22388_20188# a_20000_21737# 0 $ **FLOATING
C1241 a_22436_20404# a_20000_21737# 0 $ **FLOATING
C1242 a_22398_20636# a_20000_21737# 0 $ **FLOATING
C1243 a_21508_20000# a_20000_21737# 0 $ **FLOATING
C1244 a_21260_20000# a_20000_21737# 0 $ **FLOATING
C1245 a_21270_20456# a_20000_21737# 0 $ **FLOATING
C1246 a_21318_20636# a_20000_21737# 0 $ **FLOATING
C1247 a_20372_20000# a_20000_21737# 0 $ **FLOATING
C1248 a_20152_20100# a_20000_21737# 0 $ **FLOATING
C1249 a_20142_20276# a_20000_21737# 0 $ **FLOATING
C1250 a_20190_20456# a_20000_21737# 0 $ **FLOATING
C1251 a_20000_20000# a_20000_21737# 0 $ **FLOATING
C1252 a_23180_20836# a_20000_21737# 0 $ **FLOATING
C1253 a_22964_20836# a_20000_21737# 0 $ **FLOATING
C1254 a_22748_20836# a_20000_21737# 0 $ **FLOATING
C1255 a_22532_20836# a_20000_21737# 0 $ **FLOATING
C1256 a_22316_20836# a_20000_21737# 0 $ **FLOATING
C1257 a_22100_20836# a_20000_21737# 0 $ **FLOATING
C1258 a_21884_20836# a_20000_21737# 0 $ **FLOATING
C1259 a_21668_20836# a_20000_21737# 0 $ **FLOATING
C1260 a_21452_20836# a_20000_21737# 0 $ **FLOATING
C1261 a_21236_20836# a_20000_21737# 0 $ **FLOATING
C1262 a_21020_20836# a_20000_21737# 0 $ **FLOATING
C1263 a_20804_20836# a_20000_21737# 0 $ **FLOATING
C1264 a_20588_20836# a_20000_21737# 0 $ **FLOATING
C1265 a_20372_20836# a_20000_21737# 0 $ **FLOATING
C1266 a_20156_20836# a_20000_21737# 0 $ **FLOATING
C1267 a_20000_20836# a_20000_21737# 0 $ **FLOATING
C1268 a_23228_21052# a_20000_21737# 0 $ **FLOATING
C1269 a_23012_21052# a_20000_21737# 0 $ **FLOATING
C1270 a_22796_21052# a_20000_21737# 0 $ **FLOATING
C1271 a_22580_21052# a_20000_21737# 0 $ **FLOATING
C1272 a_22364_21052# a_20000_21737# 0 $ **FLOATING
C1273 a_22148_21052# a_20000_21737# 0 $ **FLOATING
C1274 a_21932_21052# a_20000_21737# 0 $ **FLOATING
C1275 a_21716_21052# a_20000_21737# 0 $ **FLOATING
C1276 a_21500_21052# a_20000_21737# 0 $ **FLOATING
C1277 a_21284_21052# a_20000_21737# 0 $ **FLOATING
C1278 a_21068_21052# a_20000_21737# 0 $ **FLOATING
C1279 a_20852_21052# a_20000_21737# 0 $ **FLOATING
C1280 a_20636_21052# a_20000_21737# 0 $ **FLOATING
C1281 a_20420_21052# a_20000_21737# 0 $ **FLOATING
C1282 a_20204_21052# a_20000_21737# 0 $ **FLOATING
C1283 a_20000_21052# a_20000_21737# 0 $ **FLOATING
C1284 a_22591_23093# a_20000_21737# 2.3011199999999999e-16 $ **FLOATING
C1285 a_22039_23093# a_20000_21737# 9.5162400000000014e-17 $ **FLOATING
C1286 a_20751_23093# a_20000_21737# 3.0544800000000003e-16 $ **FLOATING
C1287 a_20000_23093# a_20000_21737# 2.2618000000000006e-16 $ **FLOATING
C1288 a_109674_65100# a_20000_21737# 0 $ **FLOATING
C1289 a_109494_65100# a_20000_21737# 0 $ **FLOATING
C1290 a_109268_65116# a_20000_21737# 0 $ **FLOATING
C1291 a_109052_65116# a_20000_21737# 0 $ **FLOATING
C1292 a_108402_65100# a_20000_21737# 3.4029800000000001e-18 $ **FLOATING
C1293 a_109636_65288# a_20000_21737# 0 $ **FLOATING
C1294 a_109316_65332# a_20000_21737# 0 $ **FLOATING
C1295 a_109100_65332# a_20000_21737# 0 $ **FLOATING
C1296 a_108884_65332# a_20000_21737# 0 $ **FLOATING
C1297 a_109364_65548# a_20000_21737# 0 $ **FLOATING
C1298 a_109148_65548# a_20000_21737# 0 $ **FLOATING
C1299 a_108932_65548# a_20000_21737# 0 $ **FLOATING
C1300 a_109412_65764# a_20000_21737# 0 $ **FLOATING
C1301 a_109196_65764# a_20000_21737# 0 $ **FLOATING
C1302 a_108980_65764# a_20000_21737# 0 $ **FLOATING
C1303 a_108345_65100# a_20000_21737# 1.9279333363039976e-18 $ **FLOATING
C1304 a_109244_65980# a_20000_21737# 0 $ **FLOATING
C1305 a_109028_65980# a_20000_21737# 0 $ **FLOATING
C1306 a_109508_66196# a_20000_21737# 0 $ **FLOATING
C1307 a_109292_66196# a_20000_21737# 0 $ **FLOATING
C1308 a_109076_66196# a_20000_21737# 0 $ **FLOATING
C1309 a_108860_66196# a_20000_21737# 0 $ **FLOATING
C1310 a_109556_66412# a_20000_21737# 0 $ **FLOATING
C1311 a_109340_66412# a_20000_21737# 0 $ **FLOATING
C1312 a_109124_66412# a_20000_21737# 0 $ **FLOATING
C1313 a_108908_66412# a_20000_21737# 0 $ **FLOATING
C1314 a_109604_66628# a_20000_21737# 0 $ **FLOATING
C1315 a_109388_66628# a_20000_21737# 0 $ **FLOATING
C1316 a_109172_66628# a_20000_21737# 0 $ **FLOATING
C1317 a_108956_66628# a_20000_21737# 0 $ **FLOATING
C1318 a_109652_66844# a_20000_21737# 0 $ **FLOATING
C1319 a_109436_66844# a_20000_21737# 0 $ **FLOATING
C1320 a_109220_66844# a_20000_21737# 0 $ **FLOATING
C1321 a_109004_66844# a_20000_21737# 0 $ **FLOATING
C1322 a_109484_67060# a_20000_21737# 0 $ **FLOATING
C1323 a_109268_67060# a_20000_21737# 0 $ **FLOATING
C1324 a_109052_67060# a_20000_21737# 0 $ **FLOATING
C1325 a_108345_66276# a_20000_21737# 5.7518023848872366e-18 $ **FLOATING
C1326 a_109532_67276# a_20000_21737# 0 $ **FLOATING
C1327 a_109316_67276# a_20000_21737# 0 $ **FLOATING
C1328 a_109100_67276# a_20000_21737# 0 $ **FLOATING
C1329 a_108884_67276# a_20000_21737# 0 $ **FLOATING
C1330 a_109044_67560# a_20000_21737# 0 $ **FLOATING
C1331 a_108389_67263# a_20000_21737# 2.6014299999999998e-16 $ **FLOATING
C1332 a_108332_65715# a_20000_21737# 2.164491650150681e-18 $ **FLOATING
C1333 w_19964_21727# a_20000_21737# 6.5820162451858257e-17 $ **FLOATING
C1334 w_19964_23083# a_20000_21737# 7.1780032216304343e-17 $ **FLOATING
C1335 w_107200_65100# a_20000_21737# 7.9602074284521979e-17 $ **FLOATING
C1336 w_107200_66216# a_20000_21737# 3.6528026291167593e-16 $ **FLOATING
C1337 w_107200_67548# a_20000_21737# 2.3743199999999998e-16
C1338 a_20000_21737# a_20000_21737# 0 $ **FLOATING
C1339 a_20000_21737.t29 a_20000_21737# 0 $ **FLOATING
C1340 a_20000_21737.n0 a_20000_21737# 0 $ **FLOATING
C1341 a_20000_21737.n1 a_20000_21737# 0 $ **FLOATING
C1342 a_20000_21737.n2 a_20000_21737# 0 $ **FLOATING
C1343 a_20000_21737.n3 a_20000_21737# 0 $ **FLOATING
C1344 a_20000_21737.t7 a_20000_21737# 0 $ **FLOATING
C1345 a_20000_21737.n4 a_20000_21737# 0 $ **FLOATING
C1346 a_20000_21737.t27 a_20000_21737# 0 $ **FLOATING
C1347 a_20000_21737.n5 a_20000_21737# 0 $ **FLOATING
C1348 a_20000_21737.n6 a_20000_21737# 0 $ **FLOATING
C1349 a_20000_21737.t5 a_20000_21737# 0 $ **FLOATING
C1350 a_20000_21737.n7 a_20000_21737# 0 $ **FLOATING
C1351 a_20000_21737.n8 a_20000_21737# 0 $ **FLOATING
C1352 a_20000_21737.n9 a_20000_21737# 0 $ **FLOATING
C1353 a_20000_21737.n10 a_20000_21737# 0 $ **FLOATING
C1354 a_20000_21737.n11 a_20000_21737# 0 $ **FLOATING
C1355 a_20000_21737.n12 a_20000_21737# 0 $ **FLOATING
C1356 a_20000_21737.n13 a_20000_21737# 0 $ **FLOATING
C1357 a_20000_21737.n14 a_20000_21737# 0 $ **FLOATING
C1358 a_20000_21737.n15 a_20000_21737# 0 $ **FLOATING
C1359 a_20000_21737.n16 a_20000_21737# 0 $ **FLOATING
C1360 a_20000_21737.n17 a_20000_21737# 0 $ **FLOATING
C1361 a_20000_21737.n18 a_20000_21737# 0 $ **FLOATING
C1362 a_20000_21737.n19 a_20000_21737# 0 $ **FLOATING
C1363 a_20000_21737.n20 a_20000_21737# 0 $ **FLOATING
C1364 a_20000_21737.n21 a_20000_21737# 0 $ **FLOATING
C1365 a_20000_21737.n22 a_20000_21737# 0 $ **FLOATING
C1366 a_20000_21737.n23 a_20000_21737# 0 $ **FLOATING
C1367 a_20000_21737.n24 a_20000_21737# 0 $ **FLOATING
C1368 a_20000_21737.n25 a_20000_21737# 0 $ **FLOATING
C1369 a_20000_21737.t26 a_20000_21737# 0 $ **FLOATING
C1370 a_20000_21737.n26 a_20000_21737# 0 $ **FLOATING
C1371 a_20000_21737.t38 a_20000_21737# 0 $ **FLOATING
C1372 a_20000_21737.n27 a_20000_21737# 0 $ **FLOATING
C1373 a_20000_21737.n28 a_20000_21737# 0 $ **FLOATING
C1374 a_20000_21737.n29 a_20000_21737# 0 $ **FLOATING
C1375 a_20000_21737.n30 a_20000_21737# 0 $ **FLOATING
C1376 a_20000_21737.n31 a_20000_21737# 0 $ **FLOATING
C1377 a_20000_21737.n32 a_20000_21737# 0 $ **FLOATING
C1378 a_20000_21737.n33 a_20000_21737# 0 $ **FLOATING
C1379 a_20000_21737.n34 a_20000_21737# 0 $ **FLOATING
C1380 a_20000_21737.n35 a_20000_21737# 0 $ **FLOATING
C1381 a_20000_21737.n36 a_20000_21737# 0 $ **FLOATING
C1382 a_20000_21737.n37 a_20000_21737# 0 $ **FLOATING
C1383 a_20000_21737.t39 a_20000_21737# 0 $ **FLOATING
C1384 a_20000_21737.n38 a_20000_21737# 0 $ **FLOATING
C1385 a_20000_21737.n39 a_20000_21737# 0 $ **FLOATING
C1386 a_20000_21737.n40 a_20000_21737# 0 $ **FLOATING
C1387 a_20000_21737.n41 a_20000_21737# 0 $ **FLOATING
C1388 a_20000_21737.n42 a_20000_21737# 0 $ **FLOATING
C1389 a_20000_21737.n43 a_20000_21737# 0 $ **FLOATING
C1390 a_20000_21737.n44 a_20000_21737# 0 $ **FLOATING
C1391 a_20000_21737.n45 a_20000_21737# 0 $ **FLOATING
C1392 a_20000_21737.n46 a_20000_21737# 0 $ **FLOATING
C1393 a_20000_21737.n47 a_20000_21737# 0 $ **FLOATING
C1394 a_20000_21737.n48 a_20000_21737# 0 $ **FLOATING
C1395 a_20000_21737.n49 a_20000_21737# 0 $ **FLOATING
C1396 a_20000_21737.n50 a_20000_21737# 0 $ **FLOATING
C1397 a_20000_21737.n51 a_20000_21737# 0 $ **FLOATING
C1398 a_20000_21737.n52 a_20000_21737# 0 $ **FLOATING
C1399 a_20000_21737.n53 a_20000_21737# 0 $ **FLOATING
C1400 a_20000_21737.n54 a_20000_21737# 0 $ **FLOATING
C1401 a_20000_21737.n55 a_20000_21737# 0 $ **FLOATING
C1402 a_20000_21737.n56 a_20000_21737# 0 $ **FLOATING
C1403 a_20000_21737.n57 a_20000_21737# 0 $ **FLOATING
C1404 a_20000_21737.n58 a_20000_21737# 0 $ **FLOATING
C1405 a_20000_21737.n59 a_20000_21737# 0 $ **FLOATING
C1406 a_20000_21737.n60 a_20000_21737# 0 $ **FLOATING
C1407 a_20000_21737.n61 a_20000_21737# 0 $ **FLOATING
C1408 a_20000_21737.t36 a_20000_21737# 0 $ **FLOATING
C1409 a_20000_21737.n62 a_20000_21737# 0 $ **FLOATING
C1410 a_20000_21737.n63 a_20000_21737# 0 $ **FLOATING
C1411 a_20000_21737.n64 a_20000_21737# 0 $ **FLOATING
C1412 a_20000_21737.t1 a_20000_21737# 0 $ **FLOATING
C1413 a_20000_21737.n65 a_20000_21737# 0 $ **FLOATING
C1414 a_20000_21737.t21 a_20000_21737# 0 $ **FLOATING
C1415 a_20000_21737.n66 a_20000_21737# 0 $ **FLOATING
C1416 a_20000_21737.t2 a_20000_21737# 0 $ **FLOATING
C1417 a_20000_21737.n67 a_20000_21737# 0 $ **FLOATING
C1418 a_20000_21737.t23 a_20000_21737# 0 $ **FLOATING
C1419 a_20000_21737.n68 a_20000_21737# 0 $ **FLOATING
C1420 a_20000_21737.t35 a_20000_21737# 0 $ **FLOATING
C1421 a_20000_21737.t4 a_20000_21737# 0 $ **FLOATING
C1422 a_20000_21737.n69 a_20000_21737# 0 $ **FLOATING
C1423 a_20000_21737.t24 a_20000_21737# 0 $ **FLOATING
C1424 a_20000_21737.n70 a_20000_21737# 0 $ **FLOATING
C1425 a_20000_21737.t40 a_20000_21737# 0 $ **FLOATING
C1426 a_20000_21737.n71 a_20000_21737# 0 $ **FLOATING
C1427 a_20000_21737.n72 a_20000_21737# 0 $ **FLOATING
C1428 a_20000_21737.n73 a_20000_21737# 0 $ **FLOATING
C1429 a_20000_21737.n74 a_20000_21737# 0 $ **FLOATING
C1430 a_20000_21737.n75 a_20000_21737# 0 $ **FLOATING
C1431 a_20000_21737.n76 a_20000_21737# 0 $ **FLOATING
C1432 a_20000_21737.n77 a_20000_21737# 0 $ **FLOATING
C1433 a_20000_21737.n78 a_20000_21737# 0 $ **FLOATING
C1434 a_20000_21737.t8 a_20000_21737# 0 $ **FLOATING
C1435 a_20000_21737.n79 a_20000_21737# 0 $ **FLOATING
C1436 a_20000_21737.n80 a_20000_21737# 0 $ **FLOATING
C1437 a_20000_21737.n81 a_20000_21737# 0 $ **FLOATING
C1438 a_20000_21737.n82 a_20000_21737# 0 $ **FLOATING
C1439 a_20000_21737.n83 a_20000_21737# 0 $ **FLOATING
C1440 a_20000_21737.t37 a_20000_21737# 0 $ **FLOATING
C1441 a_20000_21737.n84 a_20000_21737# 0 $ **FLOATING
C1442 a_20000_21737.n85 a_20000_21737# 0 $ **FLOATING
C1443 a_20000_21737.n86 a_20000_21737# 0 $ **FLOATING
C1444 a_20000_21737.n87 a_20000_21737# 0 $ **FLOATING
C1445 a_20000_21737.n88 a_20000_21737# 0 $ **FLOATING
C1446 a_20000_21737.n89 a_20000_21737# 0 $ **FLOATING
C1447 a_20000_21737.n90 a_20000_21737# 0 $ **FLOATING
C1448 a_20000_21737.n91 a_20000_21737# 0 $ **FLOATING
C1449 a_20000_21737.n92 a_20000_21737# 0 $ **FLOATING
C1450 a_20000_21737.n93 a_20000_21737# 0 $ **FLOATING
C1451 a_20000_21737.n94 a_20000_21737# 0 $ **FLOATING
C1452 a_20000_21737.n95 a_20000_21737# 0 $ **FLOATING
C1453 a_20000_21737.n96 a_20000_21737# 0 $ **FLOATING
C1454 a_20000_21737.n97 a_20000_21737# 0 $ **FLOATING
C1455 a_20000_21737.n98 a_20000_21737# 0 $ **FLOATING
C1456 a_20000_21737.n99 a_20000_21737# 0 $ **FLOATING
C1457 a_20000_21737.n100 a_20000_21737# 0 $ **FLOATING
C1458 a_20000_21737.n101 a_20000_21737# 0 $ **FLOATING
C1459 a_20000_21737.n102 a_20000_21737# 0 $ **FLOATING
C1460 a_20000_21737.n103 a_20000_21737# 0 $ **FLOATING
C1461 a_20000_21737.n104 a_20000_21737# 0 $ **FLOATING
C1462 a_20000_21737.n105 a_20000_21737# 0 $ **FLOATING
C1463 a_20000_21737.n106 a_20000_21737# 0 $ **FLOATING
C1464 a_20000_21737.n107 a_20000_21737# 0 $ **FLOATING
C1465 a_20000_21737.n108 a_20000_21737# 0 $ **FLOATING
C1466 a_20000_21737.n109 a_20000_21737# 0 $ **FLOATING
C1467 a_20000_21737.n110 a_20000_21737# 0 $ **FLOATING
C1468 a_20000_21737.n111 a_20000_21737# 0 $ **FLOATING
C1469 a_20000_21737.n112 a_20000_21737# 0 $ **FLOATING
C1470 a_20000_21737.n113 a_20000_21737# 0 $ **FLOATING
C1471 a_20000_21737.n114 a_20000_21737# 0 $ **FLOATING
C1472 a_20000_21737.n115 a_20000_21737# 0 $ **FLOATING
C1473 a_20000_21737.n116 a_20000_21737# 0 $ **FLOATING
C1474 a_20000_21737.n117 a_20000_21737# 0 $ **FLOATING
C1475 a_20000_21737.n118 a_20000_21737# 0 $ **FLOATING
C1476 a_20000_21737.n119 a_20000_21737# 0 $ **FLOATING
C1477 a_20000_21737.n120 a_20000_21737# 0 $ **FLOATING
C1478 a_20000_21737.n121 a_20000_21737# 0 $ **FLOATING
C1479 a_20000_21737.n122 a_20000_21737# 0 $ **FLOATING
C1480 a_20000_21737.n123 a_20000_21737# 0 $ **FLOATING
C1481 a_20000_21737.n124 a_20000_21737# 0 $ **FLOATING
C1482 a_20000_21737.n125 a_20000_21737# 0 $ **FLOATING
C1483 a_20000_21737.n126 a_20000_21737# 0 $ **FLOATING
C1484 a_20000_21737.n127 a_20000_21737# 0 $ **FLOATING
C1485 a_20000_21737.n128 a_20000_21737# 0 $ **FLOATING
C1486 a_20000_21737.n129 a_20000_21737# 0 $ **FLOATING
C1487 a_20000_21737.n130 a_20000_21737# 0 $ **FLOATING
C1488 a_20000_21737.n131 a_20000_21737# 0 $ **FLOATING
C1489 a_20000_21737.n132 a_20000_21737# 0 $ **FLOATING
C1490 a_20000_21737.n133 a_20000_21737# 0 $ **FLOATING
C1491 a_20000_21737.n134 a_20000_21737# 0 $ **FLOATING
C1492 a_20000_21737.n135 a_20000_21737# 0 $ **FLOATING
C1493 a_20000_21737.n136 a_20000_21737# 0 $ **FLOATING
C1494 a_20000_21737.n137 a_20000_21737# 0 $ **FLOATING
C1495 a_20000_21737.n138 a_20000_21737# 0 $ **FLOATING
C1496 a_20000_21737.n139 a_20000_21737# 0 $ **FLOATING
C1497 a_20000_21737.n140 a_20000_21737# 0 $ **FLOATING
C1498 a_20000_21737.n141 a_20000_21737# 0 $ **FLOATING
C1499 a_20000_21737.n142 a_20000_21737# 0 $ **FLOATING
C1500 a_20000_21737.n143 a_20000_21737# 0 $ **FLOATING
C1501 a_20000_21737.n144 a_20000_21737# 0 $ **FLOATING
C1502 a_20000_21737.n145 a_20000_21737# 0 $ **FLOATING
C1503 a_20000_21737.n146 a_20000_21737# 0 $ **FLOATING
C1504 a_20000_21737.t44 a_20000_21737# 0 $ **FLOATING
C1505 a_20000_21737.n147 a_20000_21737# 0 $ **FLOATING
C1506 a_20000_21737.n148 a_20000_21737# 0 $ **FLOATING
C1507 a_20000_21737.n149 a_20000_21737# 0 $ **FLOATING
C1508 a_20000_21737.t10 a_20000_21737# 0 $ **FLOATING
C1509 a_20000_21737.n150 a_20000_21737# 0 $ **FLOATING
C1510 a_20000_21737.t11 a_20000_21737# 0 $ **FLOATING
C1511 a_20000_21737.n151 a_20000_21737# 0 $ **FLOATING
C1512 a_20000_21737.t14 a_20000_21737# 0 $ **FLOATING
C1513 a_20000_21737.n152 a_20000_21737# 0 $ **FLOATING
C1514 a_20000_21737.t13 a_20000_21737# 0 $ **FLOATING
C1515 a_20000_21737.n153 a_20000_21737# 0 $ **FLOATING
C1516 a_20000_21737.t43 a_20000_21737# 0 $ **FLOATING
C1517 a_20000_21737.n154 a_20000_21737# 0 $ **FLOATING
C1518 a_20000_21737.n155 a_20000_21737# 0 $ **FLOATING
C1519 a_20000_21737.n156 a_20000_21737# 0 $ **FLOATING
C1520 a_20000_21737.n157 a_20000_21737# 0 $ **FLOATING
C1521 a_20000_21737.n158 a_20000_21737# 0 $ **FLOATING
C1522 a_20000_21737.n159 a_20000_21737# 0 $ **FLOATING
C1523 a_20000_21737.n160 a_20000_21737# 0 $ **FLOATING
C1524 a_20000_21737.n161 a_20000_21737# 0 $ **FLOATING
C1525 a_20000_21737.n162 a_20000_21737# 0 $ **FLOATING
C1526 a_20000_21737.n163 a_20000_21737# 0 $ **FLOATING
C1527 a_20000_21737.n164 a_20000_21737# 0 $ **FLOATING
C1528 a_20000_21737.n165 a_20000_21737# 0 $ **FLOATING
C1529 a_20000_21737.n166 a_20000_21737# 0 $ **FLOATING
C1530 a_20000_21737.n167 a_20000_21737# 0 $ **FLOATING
C1531 a_20000_21737.n168 a_20000_21737# 0 $ **FLOATING
C1532 a_20000_21737.t41 a_20000_21737# 0 $ **FLOATING
C1533 a_20000_21737.n169 a_20000_21737# 0 $ **FLOATING
C1534 a_20000_21737.n170 a_20000_21737# 0 $ **FLOATING
C1535 a_20000_21737.n171 a_20000_21737# 0 $ **FLOATING
C1536 a_20000_21737.t19 a_20000_21737# 0 $ **FLOATING
C1537 a_20000_21737.n172 a_20000_21737# 0 $ **FLOATING
C1538 a_20000_21737.t17 a_20000_21737# 0 $ **FLOATING
C1539 a_20000_21737.n173 a_20000_21737# 0 $ **FLOATING
C1540 a_20000_21737.n174 a_20000_21737# 0 $ **FLOATING
C1541 a_20000_21737.n175 a_20000_21737# 0 $ **FLOATING
C1542 a_20000_21737.n176 a_20000_21737# 0 $ **FLOATING
C1543 a_20000_21737.n177 a_20000_21737# 0 $ **FLOATING
C1544 a_20000_21737.n178 a_20000_21737# 0 $ **FLOATING
C1545 a_20000_21737.t42 a_20000_21737# 0 $ **FLOATING
C1546 a_20000_21737.n179 a_20000_21737# 0 $ **FLOATING
C1547 a_20000_21737.n180 a_20000_21737# 0 $ **FLOATING
C1548 a_20000_21737.n181 a_20000_21737# 0 $ **FLOATING
C1549 a_20000_21737.t16 a_20000_21737# 0 $ **FLOATING
C1550 a_20000_21737.n182 a_20000_21737# 0 $ **FLOATING
C1551 a_20000_21737.n183 a_20000_21737# 0 $ **FLOATING
C1552 a_20000_21737.t18 a_20000_21737# 0 $ **FLOATING
C1553 a_20000_21737.t15 a_20000_21737# 0 $ **FLOATING
C1554 a_20000_21737.t12 a_20000_21737# 0 $ **FLOATING
C1555 a_20000_21737.t9 a_20000_21737# 0 $ **FLOATING
C1556 a_20000_21737.n184 a_20000_21737# 0 $ **FLOATING
C1557 a_20000_21737.n185 a_20000_21737# 0 $ **FLOATING
C1558 a_20000_21737.t31 a_20000_21737# 0 $ **FLOATING
C1559 a_20000_21737.t33 a_20000_21737# 0 $ **FLOATING
C1560 a_20000_21737.t30 a_20000_21737# 0 $ **FLOATING
C1561 a_20000_21737.t32 a_20000_21737# 0 $ **FLOATING
C1562 a_20000_21737.t6 a_20000_21737# 0 $ **FLOATING
C1563 a_20000_21737.t3 a_20000_21737# 0 $ **FLOATING
C1564 a_20000_21737.t0 a_20000_21737# 0 $ **FLOATING
C1565 a_20000_21737.t28 a_20000_21737# 0 $ **FLOATING
C1566 a_20000_21737.t25 a_20000_21737# 0 $ **FLOATING
C1567 a_20000_21737.t22 a_20000_21737# 0 $ **FLOATING
C1568 a_20000_21737.t20 a_20000_21737# 0 $ **FLOATING
C1569 a_20000_21737.n186 a_20000_21737# 0 $ **FLOATING
C1570 a_20000_21737.n187 a_20000_21737# 0 $ **FLOATING
C1571 a_20000_21737.n188 a_20000_21737# 0 $ **FLOATING
C1572 a_20000_21737.t34 a_20000_21737# 0 $ **FLOATING
C1573 a_20000_21737.n189 a_20000_21737# 0 $ **FLOATING
C1574 w_107200_66216.t0 a_20000_21737# 1.1597647370883241e-15 $ **FLOATING
C1575 w_107200_66216.t1 a_20000_21737# 1.5250450000000003e-15 $ **FLOATING
C1576 w_107200_65100.t1 a_20000_21737# 6.6663660183081496e-16 $ **FLOATING
C1577 w_107200_65100.t0 a_20000_21737# 1.3469713238846633e-15 $ **FLOATING
C1578 w_19964_23083.t4 a_20000_21737# 1.4933720882522985e-17 $ **FLOATING
C1579 w_19964_23083.n0 a_20000_21737# 1.0511217980664789e-16 $ **FLOATING
C1580 w_19964_23083.n1 a_20000_21737# 4.3573593278516374e-17 $ **FLOATING
C1581 w_19964_23083.n2 a_20000_21737# 1.1868477879180713e-16 $ **FLOATING
C1582 w_19964_23083.t13 a_20000_21737# 1.4430073164842385e-17 $ **FLOATING
C1583 w_19964_23083.n3 a_20000_21737# 6.2991428990782698e-17 $ **FLOATING
C1584 w_19964_23083.n4 a_20000_21737# 6.7650516324627061e-17 $ **FLOATING
C1585 w_19964_23083.t9 a_20000_21737# 2.7676787386992141e-17 $ **FLOATING
C1586 w_19964_23083.n5 a_20000_21737# 1.2260483732203027e-16 $ **FLOATING
C1587 w_19964_23083.n6 a_20000_21737# 4.361604322239088e-17 $ **FLOATING
C1588 w_19964_23083.n7 a_20000_21737# 1.196201042535784e-16 $ **FLOATING
C1589 w_19964_23083.n8 a_20000_21737# 3.2701418023476224e-17 $ **FLOATING
C1590 w_19964_23083.n9 a_20000_21737# 1.196201042535784e-16 $ **FLOATING
C1591 w_19964_23083.n10 a_20000_21737# 3.2701418023476224e-17 $ **FLOATING
C1592 w_19964_23083.n11 a_20000_21737# 5.1636793796707268e-17 $ **FLOATING
C1593 w_19964_23083.n12 a_20000_21737# 3.2701418023476224e-17 $ **FLOATING
C1594 w_19964_23083.n13 a_20000_21737# 6.634349445458434e-17 $ **FLOATING
C1595 w_19964_23083.t18 a_20000_21737# 2.7676787386992141e-17 $ **FLOATING
C1596 w_19964_23083.n14 a_20000_21737# 7.8184625536708285e-17 $ **FLOATING
C1597 w_19964_23083.n15 a_20000_21737# 7.9539392149520001e-17 $ **FLOATING
C1598 w_19964_23083.n16 a_20000_21737# 3.5196977286859465e-17 $ **FLOATING
C1599 w_19964_23083.n17 a_20000_21737# 7.9539392149520001e-17 $ **FLOATING
C1600 w_19964_23083.n18 a_20000_21737# 6.0386242976225349e-17 $ **FLOATING
C1601 w_19964_23083.n19 a_20000_21737# 7.9539392149520001e-17 $ **FLOATING
C1602 w_19964_23083.t20 a_20000_21737# 3.3818829635586596e-16 $ **FLOATING
C1603 w_19964_23083.n20 a_20000_21737# 1.6577308856817628e-16 $ **FLOATING
C1604 w_19964_23083.n21 a_20000_21737# 8.5085457480302326e-17 $ **FLOATING
C1605 w_19964_23083.n22 a_20000_21737# 6.376604128438065e-17 $ **FLOATING
C1606 w_19964_23083.n23 a_20000_21737# 3.2701418023476224e-17 $ **FLOATING
C1607 w_19964_23083.n24 a_20000_21737# 9.8559675439893298e-17 $ **FLOATING
C1608 w_19964_23083.n25 a_20000_21737# 3.2701418023476224e-17 $ **FLOATING
C1609 w_19964_23083.n26 a_20000_21737# 9.1643210869592077e-17 $ **FLOATING
C1610 w_19964_23083.n27 a_20000_21737# 3.2701418023476224e-17 $ **FLOATING
C1611 w_19964_23083.n28 a_20000_21737# 1.1066350178935857e-16 $ **FLOATING
C1612 w_19964_23083.n29 a_20000_21737# 3.2701418023476224e-17 $ **FLOATING
C1613 w_19964_23083.n30 a_20000_21737# 1.1066350178935857e-16 $ **FLOATING
C1614 w_19964_23083.n31 a_20000_21737# 3.2701418023476224e-17 $ **FLOATING
C1615 w_19964_23083.n32 a_20000_21737# 3.1988668664800368e-17 $ **FLOATING
C1616 w_19964_23083.n33 a_20000_21737# 4.361604322239088e-17 $ **FLOATING
C1617 w_19964_23083.t12 a_20000_21737# 1.4933721836197139e-17 $ **FLOATING
C1618 w_19964_23083.n34 a_20000_21737# 1.0511217980664789e-16 $ **FLOATING
C1619 w_19964_23083.n35 a_20000_21737# 4.3573593278516374e-17 $ **FLOATING
C1620 w_19964_23083.t3 a_20000_21737# 4.7915668642930945e-16 $ **FLOATING
C1621 w_19964_23083.t11 a_20000_21737# 4.8658911923366703e-16 $ **FLOATING
C1622 w_19964_23083.t8 a_20000_21737# 1.183493693035673e-15 $ **FLOATING
C1623 w_19964_23083.t14 a_20000_21737# 6.766272640553589e-16 $ **FLOATING
C1624 w_19964_23083.t5 a_20000_21737# 2.5819014116265114e-16 $ **FLOATING
C1625 w_19964_23083.t0 a_20000_21737# 1.0022640488970199e-15 $ **FLOATING
C1626 w_19964_23083.t16 a_20000_21737# 1.2162585799813425e-15 $ **FLOATING
C1627 w_19964_23083.n36 a_20000_21737# 2.6525447100294366e-16 $ **FLOATING
C1628 w_19964_23083.n37 a_20000_21737# 4.361604322239088e-17 $ **FLOATING
C1629 w_19964_23083.n38 a_20000_21737# 1.0544584368971902e-16 $ **FLOATING
C1630 w_19964_23083.n39 a_20000_21737# 4.361604322239088e-17 $ **FLOATING
C1631 w_19964_23083.t7 a_20000_21737# 1.4528609639297498e-17 $ **FLOATING
C1632 w_19964_23083.n40 a_20000_21737# 1.0499467189227778e-16 $ **FLOATING
C1633 w_19964_23083.t17 a_20000_21737# 2.8093331275957378e-17 $ **FLOATING
C1634 w_19964_23083.n41 a_20000_21737# 4.2460651727893431e-17 $ **FLOATING
C1635 w_19964_23083.n42 a_20000_21737# 7.5996691037337294e-17 $ **FLOATING
C1636 w_19964_23083.t6 a_20000_21737# 1.4526997929979832e-17 $ **FLOATING
C1637 w_19964_23083.t2 a_20000_21737# 2.7786501876188295e-17 $ **FLOATING
C1638 w_19964_23083.n43 a_20000_21737# 1.0230307537011391e-16 $ **FLOATING
C1639 w_19964_23083.n44 a_20000_21737# 4.0551424303413977e-16 $ **FLOATING
C1640 w_19964_23083.n45 a_20000_21737# 8.0759400789891862e-17 $ **FLOATING
C1641 w_19964_23083.n46 a_20000_21737# 8.778276841798776e-17 $ **FLOATING
C1642 w_19964_23083.n47 a_20000_21737# 2.6821720853074307e-16 $ **FLOATING
C1643 w_19964_23083.t15 a_20000_21737# 1.4934826190865692e-17 $ **FLOATING
C1644 w_19964_23083.n48 a_20000_21737# 8.7320053348605086e-17 $ **FLOATING
C1645 w_19964_23083.n49 a_20000_21737# 2.2005899842560001e-16 $ **FLOATING
C1646 w_19964_23083.t1 a_20000_21737# 3.0311626945646238e-17 $ **FLOATING
C1647 w_19964_23083.n50 a_20000_21737# 7.3887755852999185e-16 $ **FLOATING
C1648 w_19964_23083.n51 a_20000_21737# 3.1988668664800368e-17 $ **FLOATING
C1649 w_19964_23083.n52 a_20000_21737# 4.361604322239088e-17 $ **FLOATING
C1650 w_19964_23083.n53 a_20000_21737# 1.1066350178935857e-16 $ **FLOATING
C1651 w_19964_23083.n54 a_20000_21737# 3.2701418023476224e-17 $ **FLOATING
C1652 w_19964_23083.n55 a_20000_21737# 1.1066350178935857e-16 $ **FLOATING
C1653 w_19964_23083.n56 a_20000_21737# 1.0540299701739707e-16 $ **FLOATING
C1654 w_19964_23083.t10 a_20000_21737# 6.158082857104078e-18 $ **FLOATING
C1655 w_19964_23083.n57 a_20000_21737# 7.8184625536708285e-17 $ **FLOATING
C1656 w_19964_23083.n58 a_20000_21737# 7.9539392149520001e-17 $ **FLOATING
C1657 w_19964_23083.n59 a_20000_21737# 3.5196977286859465e-17 $ **FLOATING
C1658 w_19964_23083.n60 a_20000_21737# 7.9539392149520001e-17 $ **FLOATING
C1659 w_19964_23083.n61 a_20000_21737# 6.0386242976225349e-17 $ **FLOATING
C1660 w_19964_23083.n62 a_20000_21737# 1.4755367031346998e-16 $ **FLOATING
C1661 w_19964_23083.t19 a_20000_21737# 3.3818829635586596e-16 $ **FLOATING
C1662 w_19964_23083.n63 a_20000_21737# 1.6577308856817628e-16 $ **FLOATING
C1663 w_19964_23083.n64 a_20000_21737# 1.8756765574442872e-16 $ **FLOATING
C1664 w_19964_23083.n65 a_20000_21737# 6.0448338607640625e-17 $ **FLOATING
C1665 w_19964_23083.n66 a_20000_21737# 2.237817455883749e-16 $ **FLOATING
C1666 w_19964_23083.t21 a_20000_21737# 4.648307611576353e-16 $ **FLOATING
C1667 w_19964_23083.n67 a_20000_21737# 1.3437702157762766e-16 $ **FLOATING
C1668 w_19964_23083.n68 a_20000_21737# 6.6278926899765854e-17 $ **FLOATING
C1669 w_19964_23083.n69 a_20000_21737# 1.2366488047476431e-16 $ **FLOATING
C1670 w_19964_21727.t1 a_20000_21737# 3.1966683667554357e-17 $ **FLOATING
C1671 w_19964_21727.n0 a_20000_21737# 3.1385648794060221e-16 $ **FLOATING
C1672 w_19964_21727.t8 a_20000_21737# 3.1966672223462122e-17 $ **FLOATING
C1673 w_19964_21727.n1 a_20000_21737# 6.5071207650009711e-17 $ **FLOATING
C1674 w_19964_21727.n2 a_20000_21737# 2.6230036412507632e-16 $ **FLOATING
C1675 w_19964_21727.n3 a_20000_21737# 6.2768227519642603e-16 $ **FLOATING
C1676 w_19964_21727.n4 a_20000_21737# 3.9893138136003639e-16 $ **FLOATING
C1677 w_19964_21727.t20 a_20000_21737# 5.3836232546084752e-16 $ **FLOATING
C1678 w_19964_21727.n5 a_20000_21737# 8.4930630718555163e-16 $ **FLOATING
C1679 w_19964_21727.t4 a_20000_21737# 3.1966683667554357e-17 $ **FLOATING
C1680 w_19964_21727.n6 a_20000_21737# 8.4930630718555163e-16 $ **FLOATING
C1681 w_19964_21727.t15 a_20000_21737# 3.1966681760205656e-17 $ **FLOATING
C1682 w_19964_21727.t24 a_20000_21737# 5.3836232546084752e-16 $ **FLOATING
C1683 w_19964_21727.n7 a_20000_21737# 1.0306463257794505e-16 $ **FLOATING
C1684 w_19964_21727.n8 a_20000_21737# 1.5376184675339536e-16 $ **FLOATING
C1685 w_19964_21727.n9 a_20000_21737# 9.951198198920167e-17 $ **FLOATING
C1686 w_19964_21727.n10 a_20000_21737# 1.8491620586567941e-16 $ **FLOATING
C1687 w_19964_21727.n11 a_20000_21737# 3.7770120170783701e-17 $ **FLOATING
C1688 w_19964_21727.n12 a_20000_21737# 1.8491620586567941e-16 $ **FLOATING
C1689 w_19964_21727.n13 a_20000_21737# 3.7770120170783701e-17 $ **FLOATING
C1690 w_19964_21727.n14 a_20000_21737# 1.8491620586567941e-16 $ **FLOATING
C1691 w_19964_21727.n15 a_20000_21737# 3.7770120170783701e-17 $ **FLOATING
C1692 w_19964_21727.n16 a_20000_21737# 1.7888632892402511e-16 $ **FLOATING
C1693 w_19964_21727.n17 a_20000_21737# 3.7770120170783701e-17 $ **FLOATING
C1694 w_19964_21727.n18 a_20000_21737# 6.4953089359319182e-17 $ **FLOATING
C1695 w_19964_21727.n19 a_20000_21737# 3.7770120170783701e-17 $ **FLOATING
C1696 w_19964_21727.n20 a_20000_21737# 6.2884352249465212e-17 $ **FLOATING
C1697 w_19964_21727.n21 a_20000_21737# 1.0591244915511659e-16 $ **FLOATING
C1698 w_19964_21727.t3 a_20000_21737# 3.196667794550824e-17 $ **FLOATING
C1699 w_19964_21727.t14 a_20000_21737# 3.1966672223462122e-17 $ **FLOATING
C1700 w_19964_21727.n22 a_20000_21737# 1.3996788564984998e-16 $ **FLOATING
C1701 w_19964_21727.n23 a_20000_21737# 9.8813925931992898e-16 $ **FLOATING
C1702 w_19964_21727.t0 a_20000_21737# 1.8495081280060806e-15 $ **FLOATING
C1703 w_19964_21727.t2 a_20000_21737# 1.8468443095439235e-15 $ **FLOATING
C1704 w_19964_21727.t5 a_20000_21737# 8.3507376269105944e-16 $ **FLOATING
C1705 w_19964_21727.t9 a_20000_21737# 1.1985041966363279e-15 $ **FLOATING
C1706 w_19964_21727.t16 a_20000_21737# 5.0104423930408809e-16 $ **FLOATING
C1707 w_19964_21727.t11 a_20000_21737# 8.5806851455490173e-16 $ **FLOATING
C1708 w_19964_21727.n24 a_20000_21737# 8.1690684609651288e-17 $ **FLOATING
C1709 w_19964_21727.n25 a_20000_21737# 1.0050719839723218e-16 $ **FLOATING
C1710 w_19964_21727.n26 a_20000_21737# 1.0822987020400968e-16 $ **FLOATING
C1711 w_19964_21727.n27 a_20000_21737# 4.0910255484820631e-16 $ **FLOATING
C1712 w_19964_21727.n28 a_20000_21737# 8.5013186874084441e-16 $ **FLOATING
C1713 w_19964_21727.t22 a_20000_21737# 4.4845915426721788e-16 $ **FLOATING
C1714 w_19964_21727.n29 a_20000_21737# 7.7501711974870278e-16 $ **FLOATING
C1715 w_19964_21727.t10 a_20000_21737# 3.1966683667554357e-17 $ **FLOATING
C1716 w_19964_21727.n30 a_20000_21737# 2.8354319331389662e-16 $ **FLOATING
C1717 w_19964_21727.n31 a_20000_21737# 9.1072444615212297e-17 $ **FLOATING
C1718 w_19964_21727.n32 a_20000_21737# 4.1053563748406984e-17 $ **FLOATING
C1719 w_19964_21727.n33 a_20000_21737# 8.1133982928014045e-17 $ **FLOATING
C1720 w_19964_21727.t6 a_20000_21737# 3.1966683667554357e-17 $ **FLOATING
C1721 w_19964_21727.n34 a_20000_21737# 1.3243286643820391e-16 $ **FLOATING
C1722 w_19964_21727.n35 a_20000_21737# 2.6783106502207865e-16 $ **FLOATING
C1723 w_19964_21727.t13 a_20000_21737# 3.1966681760205656e-17 $ **FLOATING
C1724 w_19964_21727.n36 a_20000_21737# 1.1815998533326867e-16 $ **FLOATING
C1725 w_19964_21727.t26 a_20000_21737# 3.9060725384157443e-16 $ **FLOATING
C1726 w_19964_21727.n37 a_20000_21737# 2.5036641896244248e-16 $ **FLOATING
C1727 w_19964_21727.n38 a_20000_21737# 1.1297679574117932e-16 $ **FLOATING
C1728 w_19964_21727.t21 a_20000_21737# 2.7373725421481971e-16 $ **FLOATING
C1729 w_19964_21727.n39 a_20000_21737# 4.6639665495935765e-17 $ **FLOATING
C1730 w_19964_21727.t7 a_20000_21737# 3.1966683667554357e-17 $ **FLOATING
C1731 w_19964_21727.n40 a_20000_21737# 7.3618098238590693e-17 $ **FLOATING
C1732 w_19964_21727.n41 a_20000_21737# 5.7920019477344148e-17 $ **FLOATING
C1733 w_19964_21727.t17 a_20000_21737# 3.2227612785288632e-17 $ **FLOATING
C1734 w_19964_21727.n42 a_20000_21737# 4.3339502099552082e-17 $ **FLOATING
C1735 w_19964_21727.n43 a_20000_21737# 4.9158460606554183e-17 $ **FLOATING
C1736 w_19964_21727.n44 a_20000_21737# 3.5009721199524342e-17 $ **FLOATING
C1737 w_19964_21727.t18 a_20000_21737# 3.2227612785288632e-17 $ **FLOATING
C1738 w_19964_21727.n45 a_20000_21737# 2.8308409829496116e-17 $ **FLOATING
C1739 w_19964_21727.t25 a_20000_21737# 9.2223361712844448e-17 $ **FLOATING
C1740 w_19964_21727.n46 a_20000_21737# 5.8992922198186725e-17 $ **FLOATING
C1741 w_19964_21727.n47 a_20000_21737# 1.6410027183493291e-16 $ **FLOATING
C1742 w_19964_21727.n48 a_20000_21737# 8.5949260213426608e-17 $ **FLOATING
C1743 w_19964_21727.n49 a_20000_21737# 3.349025092605003e-17 $ **FLOATING
C1744 w_19964_21727.n50 a_20000_21737# 1.8953963438880648e-16 $ **FLOATING
C1745 w_19964_21727.t12 a_20000_21737# 3.4941338933702137e-17 $ **FLOATING
C1746 w_19964_21727.t23 a_20000_21737# 3.9435200496263267e-16 $ **FLOATING
C1747 w_19964_21727.t19 a_20000_21737# 3.9435200496263267e-16 $ **FLOATING
C1748 w_19964_21727.n51 a_20000_21737# 5.8806642894123907e-16 $ **FLOATING
C1749 a_108332_65715.t5 a_20000_21737# 8.6114415991476e-18 $ **FLOATING
C1750 a_108332_65715.t1 a_20000_21737# 8.6114435064962293e-18 $ **FLOATING
C1751 a_108332_65715.n0 a_20000_21737# 5.7179641636675533e-17 $ **FLOATING
C1752 a_108332_65715.n1 a_20000_21737# 2.6537622029954787e-16 $ **FLOATING
C1753 a_108332_65715.n2 a_20000_21737# 9.91394804400516e-17 $ **FLOATING
C1754 a_108332_65715.t0 a_20000_21737# 1.1210031492351495e-17 $ **FLOATING
C1755 a_108332_65715.t4 a_20000_21737# 6.8766150369970592e-18 $ **FLOATING
C1756 a_108332_65715.n3 a_20000_21737# 5.7403499515973762e-17 $ **FLOATING
C1757 a_108332_65715.t8 a_20000_21737# 9.7939468234845311e-17 $ **FLOATING
C1758 a_108332_65715.n4 a_20000_21737# 1.0652160628331725e-17 $ **FLOATING
C1759 a_108332_65715.n5 a_20000_21737# 3.3074119517572845e-17 $ **FLOATING
C1760 a_108332_65715.n6 a_20000_21737# 5.2601766506308327e-18 $ **FLOATING
C1761 a_108332_65715.n7 a_20000_21737# 1.091842077502153e-17 $ **FLOATING
C1762 a_108332_65715.n8 a_20000_21737# 5.2601766506308327e-18 $ **FLOATING
C1763 a_108332_65715.n9 a_20000_21737# 1.091842077502153e-17 $ **FLOATING
C1764 a_108332_65715.n10 a_20000_21737# 5.2601766506308327e-18 $ **FLOATING
C1765 a_108332_65715.n11 a_20000_21737# 1.2739642314610261e-16 $ **FLOATING
C1766 a_108332_65715.n12 a_20000_21737# 7.9667487023314018e-18 $ **FLOATING
C1767 a_108332_65715.n13 a_20000_21737# 4.2081413205046663e-18 $ **FLOATING
C1768 a_108332_65715.n14 a_20000_21737# 9.3830184793828963e-18 $ **FLOATING
C1769 a_108332_65715.n15 a_20000_21737# 4.2081413205046663e-18 $ **FLOATING
C1770 a_108332_65715.n16 a_20000_21737# 9.3830184793828963e-18 $ **FLOATING
C1771 a_108332_65715.n17 a_20000_21737# 7.7012867810432134e-18 $ **FLOATING
C1772 a_108332_65715.n18 a_20000_21737# 9.3830184793828963e-18 $ **FLOATING
C1773 a_108332_65715.n19 a_20000_21737# 9.0719594817480371e-18 $ **FLOATING
C1774 a_108332_65715.n20 a_20000_21737# 9.199524865465171e-18 $ **FLOATING
C1775 a_108332_65715.n21 a_20000_21737# 7.4637646370868031e-16 $ **FLOATING
C1776 a_108332_65715.n22 a_20000_21737# 1.0307103255809612e-15 $ **FLOATING
C1777 a_108332_65715.n23 a_20000_21737# 9.148442254458871e-18 $ **FLOATING
C1778 a_108332_65715.n24 a_20000_21737# 9.3830184793828963e-18 $ **FLOATING
C1779 a_108332_65715.n25 a_20000_21737# 0 $ **FLOATING
C1780 a_108332_65715.n26 a_20000_21737# 9.3830184793828963e-18 $ **FLOATING
C1781 a_108332_65715.n27 a_20000_21737# 9.1995258191394879e-18 $ **FLOATING
C1782 a_108332_65715.n28 a_20000_21737# 9.3830184793828963e-18 $ **FLOATING
C1783 a_108332_65715.n29 a_20000_21737# 7.8902649759462509e-18 $ **FLOATING
C1784 a_108332_65715.n30 a_20000_21737# 4.2081413205046663e-18 $ **FLOATING
C1785 a_108332_65715.n31 a_20000_21737# 4.2081413205046663e-18 $ **FLOATING
C1786 a_108332_65715.n32 a_20000_21737# 1.0652160628331725e-17 $ **FLOATING
C1787 a_108332_65715.n33 a_20000_21737# 3.3074119517572845e-17 $ **FLOATING
C1788 a_108332_65715.n34 a_20000_21737# 5.2601766506308327e-18 $ **FLOATING
C1789 a_108332_65715.n35 a_20000_21737# 1.091842077502153e-17 $ **FLOATING
C1790 a_108332_65715.n36 a_20000_21737# 5.2601766506308327e-18 $ **FLOATING
C1791 a_108332_65715.n37 a_20000_21737# 1.091842077502153e-17 $ **FLOATING
C1792 a_108332_65715.n38 a_20000_21737# 5.2601766506308327e-18 $ **FLOATING
C1793 a_108332_65715.n39 a_20000_21737# 2.6537622029954787e-16 $ **FLOATING
C1794 a_108332_65715.n40 a_20000_21737# 3.1297594022838015e-17 $ **FLOATING
C1795 a_108332_65715.t9 a_20000_21737# 9.7939468234845311e-17 $ **FLOATING
C1796 a_108332_65715.t2 a_20000_21737# 6.8766150369970592e-18 $ **FLOATING
C1797 a_108332_65715.n41 a_20000_21737# 5.7403495701276482e-17 $ **FLOATING
C1798 a_108332_65715.t6 a_20000_21737# 6.8766150369970592e-18 $ **FLOATING
C1799 a_108332_65715.n42 a_20000_21737# 5.7403499515973762e-17 $ **FLOATING
C1800 a_108332_65715.t10 a_20000_21737# 9.7939468234845311e-17 $ **FLOATING
C1801 a_108332_65715.n43 a_20000_21737# 5.5936393652726374e-17 $ **FLOATING
C1802 a_108332_65715.t3 a_20000_21737# 8.6114435064962293e-18 $ **FLOATING
C1803 a_108332_65715.t7 a_20000_21737# 2.0898539988207066e-18 $ **FLOATING
C1804 a_108332_65715.n44 a_20000_21737# 5.600344649381093e-18 $ **FLOATING
C1805 a_108332_65715.n45 a_20000_21737# 1.2739642314610261e-16 $ **FLOATING
C1806 a_108332_65715.n46 a_20000_21737# 7.7012867810432134e-18 $ **FLOATING
C1807 a_108345_66276.t1 a_20000_21737# 2.0463307911519324e-17 $ **FLOATING
C1808 a_108345_66276.n0 a_20000_21737# 7.8463033646228028e-17 $ **FLOATING
C1809 a_108345_66276.t4 a_20000_21737# 7.4248159072880433e-17 $ **FLOATING
C1810 a_108345_66276.n1 a_20000_21737# 7.6315809064187377e-17 $ **FLOATING
C1811 a_108345_66276.n2 a_20000_21737# 1.1305266246779982e-17 $ **FLOATING
C1812 a_108345_66276.t3 a_20000_21737# 5.553464338729939e-18 $ **FLOATING
C1813 a_108345_66276.t5 a_20000_21737# 7.4248166702275523e-17 $ **FLOATING
C1814 a_108345_66276.n3 a_20000_21737# 4.1859069809140856e-16 $ **FLOATING
C1815 a_108345_66276.n4 a_20000_21737# 2.6540562838479754e-16 $ **FLOATING
C1816 a_108345_66276.t0 a_20000_21737# 2.3152330170804308e-17 $ **FLOATING
C1817 a_108345_66276.t2 a_20000_21737# 2.3152333985501854e-17 $ **FLOATING
C1818 a_108345_65100.t3 a_20000_21737# 1.861452818882134e-18 $ **FLOATING
C1819 a_108345_65100.n0 a_20000_21737# 4.2325663588537492e-18 $ **FLOATING
C1820 a_108345_65100.t4 a_20000_21737# 1.1312297063971505e-16 $ **FLOATING
C1821 a_108345_65100.n1 a_20000_21737# 1.1954475409031072e-16 $ **FLOATING
C1822 a_108345_65100.t1 a_20000_21737# 3.1177494065239483e-17 $ **FLOATING
C1823 a_108345_65100.n2 a_20000_21737# 6.4480401644764704e-16 $ **FLOATING
C1824 a_108345_65100.n3 a_20000_21737# 3.7470040912984918e-16 $ **FLOATING
C1825 a_108345_65100.t0 a_20000_21737# 3.5274436968975293e-17 $ **FLOATING
C1826 a_108345_65100.t2 a_20000_21737# 6.7039661442234391e-18 $ **FLOATING
.ends
