* NGSPICE file created from RotatedCrop.ext - technology: sky130A

.subckt RotatedCrop
X0 a_21487_106400# w_21701_106400# a_21487_106400# a_21487_106400# sky130_fd_pr__nfet_01v8 ad=0.143 pd=1.62 as=0 ps=0 w=0.55 l=4.73
X1 a_21487_106400# w_21701_106400# a_21487_106400# a_21487_106400# sky130_fd_pr__nfet_01v8 ad=0.143 pd=1.62 as=0 ps=0 w=0.55 l=2.69
X2 w_21701_106400# a_21487_106400# w_21701_106400# w_21701_106400# sky130_fd_pr__pfet_01v8_hvt ad=0.2262 pd=2.26 as=0 ps=0 w=0.87 l=4.73
X3 w_21701_106400# a_21487_106400# w_21701_106400# w_21701_106400# sky130_fd_pr__pfet_01v8_hvt ad=0.2262 pd=2.26 as=0 ps=0 w=0.87 l=0.59
X4 w_21701_106400# a_21487_106400# w_21701_106400# w_21701_106400# sky130_fd_pr__pfet_01v8_hvt ad=0.2262 pd=2.26 as=0 ps=0 w=0.87 l=3.11
X5 a_65266_21098# a_67263_21111# a_65266_21098# a_21487_106400# sky130_fd_pr__nfet_01v8_lvt ad=0.1197 pd=1.41 as=0 ps=0 w=0.42 l=1
X6 a_21487_106400# w_21701_106400# a_21487_106400# a_21487_106400# sky130_fd_pr__nfet_01v8 ad=0.143 pd=1.62 as=0 ps=0 w=0.55 l=0.59
X7 a_21487_106400# w_21701_106400# a_21487_106400# a_21487_106400# sky130_fd_pr__nfet_01v8 ad=0.143 pd=1.62 as=0 ps=0 w=0.55 l=4.73
X8 a_65931_21111# a_65266_21098# a_65931_21111# w_66216_20978# sky130_fd_pr__pfet_01v8 ad=0.285 pd=2.57 as=0 ps=0 w=1 l=1
X9 w_21701_106400# a_21487_106400# w_21701_106400# w_21701_106400# sky130_fd_pr__pfet_01v8_hvt ad=0.2262 pd=2.26 as=0 ps=0 w=0.87 l=2.53
X10 w_21701_106400# a_21487_106400# w_21701_106400# w_21701_106400# sky130_fd_pr__pfet_01v8_hvt ad=0.2262 pd=2.26 as=0 ps=0 w=0.87 l=4.73
X11 a_21487_106400# w_21701_106400# a_21487_106400# a_21487_106400# sky130_fd_pr__nfet_01v8 ad=0.143 pd=1.62 as=0 ps=0 w=0.55 l=4.73
X12 w_21701_106400# a_21487_106400# w_21701_106400# w_21701_106400# sky130_fd_pr__pfet_01v8_hvt ad=0.2262 pd=2.26 as=0 ps=0 w=0.87 l=1.97
X13 a_21487_106400# w_21701_106400# a_21487_106400# a_21487_106400# sky130_fd_pr__nfet_01v8 ad=0.143 pd=1.62 as=0 ps=0 w=0.55 l=2.69
X14 w_21701_106400# a_21487_106400# w_21701_106400# w_21701_106400# sky130_fd_pr__pfet_01v8_hvt ad=0.2262 pd=2.26 as=0 ps=0 w=0.87 l=4.73
X15 w_21701_106400# a_21487_106400# w_21701_106400# w_21701_106400# sky130_fd_pr__pfet_01v8_hvt ad=0.2262 pd=2.26 as=0 ps=0 w=0.87 l=2.53
X16 a_65266_21098# a_65100_21043# a_65266_21098# a_21487_106400# sky130_fd_pr__nfet_01v8_lvt ad=0.1197 pd=1.41 as=0 ps=0 w=0.42 l=1
X17 w_22789_106400# a_23093_106400# w_22789_106400# w_22789_106400# sky130_fd_pr__pfet_01v8_hvt ad=0.1053 pd=1.33 as=0 ps=0 w=0.405 l=1.57
X18 a_65931_21111# a_65266_21098# a_65931_21111# w_66216_20978# sky130_fd_pr__pfet_01v8 ad=0.285 pd=2.57 as=0 ps=0 w=1 l=1
X19 a_65266_21098# a_65931_21111# a_65266_21098# a_21487_106400# sky130_fd_pr__nfet_01v8_lvt ad=0.1197 pd=1.41 as=0 ps=0 w=0.42 l=1
X20 w_22789_106400# a_23093_107267# w_22789_106400# w_22789_106400# sky130_fd_pr__pfet_01v8_hvt ad=0.1053 pd=1.33 as=0 ps=0 w=0.405 l=1.97
X21 w_22789_106400# a_23093_109107# w_22789_106400# w_22789_106400# sky130_fd_pr__pfet_01v8_hvt ad=0.1053 pd=1.33 as=0 ps=0 w=0.405 l=1.28
X22 w_22789_106400# a_23093_108003# w_22789_106400# w_22789_106400# sky130_fd_pr__pfet_01v8_hvt ad=0.1053 pd=1.33 as=0 ps=0 w=0.405 l=4.73
X23 a_65100_21043# a_65100_21098# a_65100_21043# w_65064_21062# sky130_fd_pr__pfet_01v8 ad=0.0627 pd=1.01 as=0 ps=0 w=0.22 l=1
X24 a_65266_21098# a_65931_21111# a_65266_21098# a_21487_106400# sky130_fd_pr__nfet_01v8_lvt ad=0.1197 pd=1.41 as=0 ps=0 w=0.42 l=1
X25 a_21487_106400# w_21701_106400# a_21487_106400# a_21487_106400# sky130_fd_pr__nfet_01v8 ad=0.143 pd=1.62 as=0 ps=0 w=0.55 l=3.27
X26 w_22789_106400# a_21487_106400# w_22789_106400# w_22789_106400# sky130_fd_pr__pfet_01v8_hvt ad=0.2262 pd=2.26 as=0 ps=0 w=0.87 l=4.73
X27 w_22789_106400# a_21487_106400# w_22789_106400# w_22789_106400# sky130_fd_pr__pfet_01v8_hvt ad=0.2262 pd=2.26 as=0 ps=0 w=0.87 l=4.73
X28 a_65100_21043# a_65266_21098# a_65100_21043# w_65064_21062# sky130_fd_pr__pfet_01v8 ad=0.285 pd=2.57 as=0 ps=0 w=1 l=1
X29 w_22789_106400# a_21487_106400# w_22789_106400# w_22789_106400# sky130_fd_pr__pfet_01v8_hvt ad=0.06525 pd=1.89 as=0 ps=0 w=0.87 l=4.73
X30 a_21487_106400# w_22789_106400# a_21487_106400# a_21487_106400# sky130_fd_pr__nfet_01v8 ad=0.143 pd=1.62 as=0 ps=0 w=0.55 l=4.73
X31 a_21487_106400# w_22789_106400# a_21487_106400# a_21487_106400# sky130_fd_pr__nfet_01v8 ad=0.04125 pd=1.25 as=0 ps=0 w=0.55 l=4.73
X32 a_21487_106400# w_21701_106400# a_21487_106400# a_21487_106400# sky130_fd_pr__nfet_01v8 ad=0.143 pd=1.62 as=0 ps=0 w=0.55 l=1.97
X33 a_21487_106400# w_22789_106400# a_21487_106400# a_21487_106400# sky130_fd_pr__nfet_01v8 ad=0.143 pd=1.62 as=0 ps=0 w=0.55 l=4.73
C0 m1_67350_20000# a_65266_21098# 8.5240000000000001e-16
C1 w_67548_20978# a_65266_21098# 6.0162100000000004e-17
C2 a_23093_106400# w_21701_106400# 3.5767900000000004e-18
C3 m2_65100_21482# a_65100_21043# 1.01416e-16
C4 m1_66376_22136# m2_65100_22346# 1.6445500000000003e-16
C5 m4_65100_22042# a_65266_21098# 1.6941400000000004e-17
C6 m5_66336_20000# m1_67350_20000# 2.3707300000000004e-18
C7 m5_66336_20000# w_67548_20978# 1.5137900000000001e-18
C8 m1_67350_20000# m1_67412_21080# 6.5872900000000004e-16
C9 w_67548_20978# m1_67412_21080# 1.4178000000000003e-17
C10 a_65100_21098# w_65064_21062# 5.2726700000000005e-17
C11 m3_66000_22226# a_65266_21098# 2.8119599999999999e-17
C12 m5_66336_20000# m4_65100_22042# 1.98648e-16
C13 m2_65100_22346# a_65931_21111# 7.4594999999999995e-17
C14 a_65100_21043# m4_65100_21658# 1.6507000000000003e-17
C15 m4_65100_22042# m1_67412_21080# 1.6285e-18
C16 w_65064_21062# m2_65100_22346# 3.1349100000000002e-17
C17 m1_67350_20000# a_67263_21111# 1.7539699999999999e-17
C18 a_67263_21111# w_67548_20978# 2.2428400000000003e-17
C19 w_66216_20978# a_65266_21098# 4.0230400000000002e-16
C20 m5_66336_20000# m3_66000_22226# 1.7783400000000002e-16
C21 m2_65100_21482# a_65266_21098# 2.3021e-16
C22 m3_66000_22226# m1_67412_21080# 1.6020600000000002e-18
C23 m4_65100_22042# a_67263_21111# 1.2061800000000001e-19
C24 w_66216_20978# m5_66336_20000# 2.0536599999999999e-17
C25 a_65100_21098# m2_65100_21674# 3.1880400000000006e-20
C26 m1_66376_22136# a_65100_21043# 6.1075300000000006e-20
C27 m2_65100_21482# m5_66336_20000# 1.3326700000000002e-17
C28 a_65100_21098# m4_65100_22426# 9.3524300000000013e-22
C29 w_66216_20978# m1_67412_21080# 8.5384699999999998e-20
C30 m3_66000_22226# a_67263_21111# 9.1782600000000015e-20
C31 m1_67350_20000# w_67548_20978# 1.4063000000000002e-18
C32 m2_65100_21482# m1_67412_21080# 4.8298300000000001e-17
C33 m2_65100_22346# m2_65100_21674# 1.3387800000000001e-16
C34 m2_65100_22346# m4_65100_22426# 2.5023100000000001e-17
C35 m4_65100_21658# a_65266_21098# 2.27618e-16
C36 a_65100_21043# a_65931_21111# 4.1809300000000004e-17
C37 w_22789_106400# a_23093_108003# 4.4880300000000007e-16
C38 m1_67350_20000# m4_65100_22042# 2.5642200000000004e-18
C39 m4_65100_22042# w_67548_20978# 1.08472e-18
C40 a_23093_107267# a_23093_106400# 2.6329100000000002e-18
C41 w_65064_21062# a_65100_21043# 5.3274900000000011e-16
C42 m5_66336_20000# m4_65100_21658# 2.4036099999999999e-16
C43 m2_65100_21482# a_67263_21111# 1.1578200000000001e-17
C44 m1_67412_21080# m4_65100_21658# 2.9948400000000002e-18
C45 m3_66000_22226# m1_67350_20000# 1.5272800000000001e-18
C46 m3_66000_22226# w_67548_20978# 8.4649000000000005e-19
C47 m1_66376_22136# a_65266_21098# 1.08716e-16
C48 m3_66000_22226# m4_65100_22042# 6.140160000000001e-16
C49 a_67263_21111# m4_65100_21658# 1.9722600000000002e-18
C50 m1_66376_22136# m5_66336_20000# 1.1621500000000001e-17
C51 a_65931_21111# a_65266_21098# 1.2376300000000002e-15
C52 a_65100_21098# m2_65100_22346# 7.8486300000000013e-21
C53 m2_65100_21482# m1_67350_20000# 2.4562000000000002e-17
C54 m2_65100_21482# w_67548_20978# 3.3428399999999998e-18
C55 w_21701_106400# a_23093_108003# 4.3139900000000006e-18
C56 a_65100_21043# m2_65100_21674# 7.6047300000000016e-17
C57 m1_66376_22136# m1_67412_21080# 2.4991099999999999e-17
C58 a_65100_21043# m4_65100_22426# 4.5276800000000007e-18
C59 w_65064_21062# a_65266_21098# 2.0189100000000001e-16
C60 w_66216_20978# m4_65100_22042# 9.0080500000000004e-18
C61 m5_66336_20000# a_65931_21111# 2.8862400000000001e-17
C62 a_65931_21111# m1_67412_21080# 4.434400000000001e-19
C63 m5_66336_20000# w_65064_21062# 4.8700000000000003e-18
C64 w_66216_20978# m3_66000_22226# 1.6701200000000002e-17
C65 m1_66376_22136# a_67263_21111# 1.6522900000000002e-19
C66 w_22789_106400# w_21701_106400# 8.8069700000000004e-16
C67 m1_67350_20000# m4_65100_21658# 3.8046000000000005e-18
C68 w_67548_20978# m4_65100_21658# 2.5581000000000003e-18
C69 m2_65100_21482# m3_66000_22226# 8.4636000000000015e-20
C70 a_65931_21111# a_67263_21111# 3.4042600000000001e-17
C71 m4_65100_22042# m4_65100_21658# 5.3652999999999996e-16
C72 m2_65100_21674# a_65266_21098# 1.5544400000000001e-16
C73 m4_65100_22426# a_65266_21098# 1.7684100000000003e-17
C74 w_66216_20978# m2_65100_21482# 3.0487600000000004e-17
C75 a_65100_21098# a_65100_21043# 5.9348399999999998e-17
C76 m1_66376_22136# m1_67350_20000# 2.3896500000000002e-17
C77 m3_66000_22226# m4_65100_21658# 2.0485600000000002e-19
C78 m1_66376_22136# w_67548_20978# 3.2119600000000002e-18
C79 m5_66336_20000# m2_65100_21674# 8.0638400000000022e-18
C80 m5_66336_20000# m4_65100_22426# 1.6045500000000004e-16
C81 a_65100_21043# m2_65100_22346# 7.3327300000000006e-17
C82 m1_67412_21080# m2_65100_21674# 2.49988e-17
C83 m1_67412_21080# m4_65100_22426# 1.7991299999999999e-18
C84 m1_66376_22136# m4_65100_22042# 1.4423900000000002e-17
C85 w_66216_20978# m4_65100_21658# 1.1378399999999999e-17
C86 m1_67350_20000# a_65931_21111# 1.1850400000000001e-17
C87 m2_65100_21482# m4_65100_21658# 1.4945500000000001e-17
C88 m1_66376_22136# m3_66000_22226# 1.9391000000000001e-17
C89 a_23093_107267# a_23093_108003# 1.2163700000000001e-18
C90 a_67263_21111# m2_65100_21674# 5.5591599999999995e-19
C91 a_65931_21111# m4_65100_22042# 8.8562999999999996e-18
C92 a_67263_21111# m4_65100_22426# 1.0530900000000002e-19
C93 a_23093_109107# a_23093_108003# 2.6329100000000002e-18
C94 a_65100_21098# a_65266_21098# 3.35961e-17
C95 w_65064_21062# m4_65100_22042# 6.5861000000000007e-18
C96 w_66216_20978# m1_66376_22136# 8.1488200000000022e-17
C97 m2_65100_22346# a_65266_21098# 1.5127600000000004e-16
C98 m3_66000_22226# a_65931_21111# 1.24753e-17
C99 a_65100_21098# m5_66336_20000# -6.8540499999999999e-35
C100 m1_66376_22136# m2_65100_21482# 4.0203900000000004e-20
C101 w_22789_106400# a_23093_107267# 2.1416300000000004e-16
C102 m3_66000_22226# w_65064_21062# 4.9466100000000001e-18
C103 a_23093_109107# w_22789_106400# 2.63403e-16
C104 m5_66336_20000# m2_65100_22346# 1.2434900000000002e-17
C105 w_66216_20978# a_65931_21111# 7.2327600000000002e-16
C106 m1_67350_20000# m2_65100_21674# 2.3884200000000004e-17
C107 m1_67350_20000# m4_65100_22426# 1.4477500000000001e-18
C108 w_67548_20978# m2_65100_21674# 2.9277600000000006e-18
C109 w_67548_20978# m4_65100_22426# 9.3597800000000002e-19
C110 m2_65100_21482# a_65931_21111# 1.1764e-16
C111 m2_65100_22346# m1_67412_21080# 2.4623200000000003e-17
C112 m2_65100_21482# w_65064_21062# 1.8931300000000003e-17
C113 m4_65100_22042# m2_65100_21674# 1.0179600000000001e-17
C114 m1_66376_22136# m4_65100_21658# 4.7e-19
C115 m4_65100_22042# m4_65100_22426# 3.6473300000000006e-16
C116 m2_65100_22346# a_67263_21111# 1.10534e-19
C117 m3_66000_22226# m2_65100_21674# 1.5491500000000002e-18
C118 m3_66000_22226# m4_65100_22426# 3.5329800000000001e-16
C119 a_65931_21111# m4_65100_21658# 1.6397200000000001e-17
C120 a_23093_107267# w_21701_106400# 4.3139900000000006e-18
C121 a_65100_21043# a_65266_21098# 6.3810599999999996e-16
C122 a_23093_109107# w_21701_106400# 4.0955600000000003e-19
C123 w_65064_21062# m4_65100_21658# 8.1896100000000012e-18
C124 w_66216_20978# m2_65100_21674# 4.7071100000000005e-17
C125 w_66216_20978# m4_65100_22426# 8.2920700000000015e-18
C126 m5_66336_20000# a_65100_21043# 5.1755800000000002e-18
C127 m2_65100_21482# m2_65100_21674# 5.5803600000000002e-16
C128 m1_67350_20000# m2_65100_22346# 2.3529000000000002e-17
C129 m2_65100_22346# w_67548_20978# 3.5987800000000002e-18
C130 m1_66376_22136# a_65931_21111# 2.0253100000000003e-16
C131 a_65100_21098# m4_65100_22042# 1.0612000000000001e-20
C132 m1_66376_22136# w_65064_21062# 3.8351200000000004e-19
C133 m2_65100_22346# m4_65100_22042# 1.5639100000000002e-17
C134 m2_65100_21674# m4_65100_21658# 2.66712e-17
C135 m3_66000_22226# m2_65100_22346# 5.1122700000000006e-17
C136 m5_66336_20000# a_65266_21098# 7.4302000000000009e-16
C137 a_65100_21098# m2_65100_21482# 2.0855700000000003e-18
C138 m1_67412_21080# a_65266_21098# 7.302050000000001e-17
C139 w_66216_20978# m2_65100_22346# 5.2978499999999999e-17
C140 m1_66376_22136# m2_65100_21674# 1.2037300000000002e-16
C141 m1_66376_22136# m4_65100_22426# 8.8940900000000013e-18
C142 m5_66336_20000# m1_67412_21080# 1.4143500000000001e-18
C143 w_22789_106400# a_23093_106400# 3.3554199999999996e-16
C144 a_67263_21111# a_65266_21098# 2.1590700000000004e-16
C145 a_65931_21111# m2_65100_21674# 7.9094400000000003e-17
C146 a_65100_21098# m4_65100_21658# 2.8074700000000005e-19
C147 a_65931_21111# m4_65100_22426# 7.7190600000000003e-18
C148 a_65100_21043# m4_65100_22042# 9.049500000000001e-18
C149 w_65064_21062# m2_65100_21674# 3.3636200000000009e-17
C150 m5_66336_20000# a_67263_21111# 3.5281500000000001e-19
C151 w_65064_21062# m4_65100_22426# 4.0374999999999995e-18
C152 m2_65100_22346# m4_65100_21658# 1.1895700000000002e-18
C153 m3_66000_22226# a_65100_21043# 1.61041e-18
C154 a_67263_21111# m1_67412_21080# 4.1616900000000002e-17
C155 m5_67100_20000# a_21487_106400# 0 $ **FLOATING
C156 m5_67100_21500# a_21487_106400# 0 $ **FLOATING
C157 m5_66336_20000# a_21487_106400# 8.8871e-16
C158 m5_65100_20000# a_21487_106400# 0 $ **FLOATING
C159 m5_65100_21500# a_21487_106400# 0 $ **FLOATING
C160 m5_23100_106400# a_21487_106400# 0 $ **FLOATING
C161 m5_21100_106400# a_21487_106400# 0 $ **FLOATING
C162 m5_20000_106400# a_21487_106400# 0 $ **FLOATING
C163 m5_23100_107500# a_21487_106400# 0 $ **FLOATING
C164 m5_21100_107500# a_21487_106400# 0 $ **FLOATING
C165 m5_20000_107500# a_21487_106400# 0 $ **FLOATING
C166 m5_23100_109500# a_21487_106400# 0 $ **FLOATING
C167 m5_21100_109500# a_21487_106400# 0 $ **FLOATING
C168 m5_20000_109500# a_21487_106400# 0 $ **FLOATING
C169 m4_66850_20000# a_21487_106400# 0 $ **FLOATING
C170 m4_66660_20000# a_21487_106400# 0 $ **FLOATING
C171 m4_66484_20000# a_21487_106400# 0 $ **FLOATING
C172 m4_66308_20000# a_21487_106400# 0 $ **FLOATING
C173 m4_66050_20000# a_21487_106400# 0 $ **FLOATING
C174 m4_65780_20000# a_21487_106400# 0 $ **FLOATING
C175 m4_65604_20000# a_21487_106400# 0 $ **FLOATING
C176 m4_65428_20000# a_21487_106400# 0 $ **FLOATING
C177 m4_65250_20000# a_21487_106400# 0 $ **FLOATING
C178 m4_65100_20000# a_21487_106400# 0 $ **FLOATING
C179 m4_67540_20876# a_21487_106400# 0 $ **FLOATING
C180 m4_67364_20840# a_21487_106400# 0 $ **FLOATING
C181 m4_67188_20804# a_21487_106400# 0 $ **FLOATING
C182 m4_67012_20768# a_21487_106400# 0 $ **FLOATING
C183 m4_66836_20732# a_21487_106400# 0 $ **FLOATING
C184 m4_67540_21052# a_21487_106400# 0 $ **FLOATING
C185 m4_67364_21016# a_21487_106400# 0 $ **FLOATING
C186 m4_67188_20980# a_21487_106400# 0 $ **FLOATING
C187 m4_67012_20944# a_21487_106400# 0 $ **FLOATING
C188 m4_66836_20908# a_21487_106400# 0 $ **FLOATING
C189 m4_66660_20872# a_21487_106400# 0 $ **FLOATING
C190 m4_66484_20836# a_21487_106400# 0 $ **FLOATING
C191 m4_66308_20800# a_21487_106400# 0 $ **FLOATING
C192 m4_66132_20764# a_21487_106400# 0 $ **FLOATING
C193 m4_65956_20728# a_21487_106400# 0 $ **FLOATING
C194 m4_67540_21228# a_21487_106400# 0 $ **FLOATING
C195 m4_67364_21192# a_21487_106400# 0 $ **FLOATING
C196 m4_67188_21156# a_21487_106400# 0 $ **FLOATING
C197 m4_67012_21120# a_21487_106400# 0 $ **FLOATING
C198 m4_66836_21084# a_21487_106400# 0 $ **FLOATING
C199 m4_66660_21048# a_21487_106400# 0 $ **FLOATING
C200 m4_66484_21012# a_21487_106400# 0 $ **FLOATING
C201 m4_66308_20976# a_21487_106400# 0 $ **FLOATING
C202 m4_66132_20940# a_21487_106400# 0 $ **FLOATING
C203 m4_65956_20904# a_21487_106400# 0 $ **FLOATING
C204 m4_65780_20868# a_21487_106400# 0 $ **FLOATING
C205 m4_65604_20832# a_21487_106400# 0 $ **FLOATING
C206 m4_65428_20796# a_21487_106400# 0 $ **FLOATING
C207 m4_65252_20760# a_21487_106400# 0 $ **FLOATING
C208 m4_65100_20724# a_21487_106400# 0 $ **FLOATING
C209 m4_67540_21404# a_21487_106400# 0 $ **FLOATING
C210 m4_67364_21368# a_21487_106400# 0 $ **FLOATING
C211 m4_67188_21332# a_21487_106400# 0 $ **FLOATING
C212 m4_67012_21296# a_21487_106400# 0 $ **FLOATING
C213 m4_66836_21260# a_21487_106400# 0 $ **FLOATING
C214 m4_66660_21224# a_21487_106400# 0 $ **FLOATING
C215 m4_66484_21188# a_21487_106400# 0 $ **FLOATING
C216 m4_66308_21152# a_21487_106400# 0 $ **FLOATING
C217 m4_66132_21116# a_21487_106400# 0 $ **FLOATING
C218 m4_65956_21080# a_21487_106400# 0 $ **FLOATING
C219 m4_65780_21044# a_21487_106400# 0 $ **FLOATING
C220 m4_65604_21008# a_21487_106400# 0 $ **FLOATING
C221 m4_65428_20972# a_21487_106400# 0 $ **FLOATING
C222 m4_65252_20936# a_21487_106400# 0 $ **FLOATING
C223 m4_65100_20900# a_21487_106400# 0 $ **FLOATING
C224 m4_66836_21436# a_21487_106400# 0 $ **FLOATING
C225 m4_66660_21400# a_21487_106400# 0 $ **FLOATING
C226 m4_66484_21364# a_21487_106400# 0 $ **FLOATING
C227 m4_66308_21328# a_21487_106400# 0 $ **FLOATING
C228 m4_66132_21292# a_21487_106400# 0 $ **FLOATING
C229 m4_65956_21256# a_21487_106400# 0 $ **FLOATING
C230 m4_65780_21220# a_21487_106400# 0 $ **FLOATING
C231 m4_65604_21184# a_21487_106400# 0 $ **FLOATING
C232 m4_65428_21148# a_21487_106400# 0 $ **FLOATING
C233 m4_65252_21112# a_21487_106400# 0 $ **FLOATING
C234 m4_65100_21076# a_21487_106400# 0 $ **FLOATING
C235 m4_65956_21432# a_21487_106400# 0 $ **FLOATING
C236 m4_65780_21396# a_21487_106400# 0 $ **FLOATING
C237 m4_65604_21360# a_21487_106400# 0 $ **FLOATING
C238 m4_65428_21324# a_21487_106400# 0 $ **FLOATING
C239 m4_65252_21288# a_21487_106400# 0 $ **FLOATING
C240 m4_65100_21252# a_21487_106400# 0 $ **FLOATING
C241 m4_65100_21428# a_21487_106400# 0 $ **FLOATING
C242 m4_65100_21658# a_21487_106400# 2.46726e-16
C243 m4_67012_21824# a_21487_106400# 0 $ **FLOATING
C244 m4_66850_21850# a_21487_106400# 0 $ **FLOATING
C245 m4_66132_21820# a_21487_106400# 0 $ **FLOATING
C246 m4_65410_21800# a_21487_106400# 0 $ **FLOATING
C247 m4_65250_21830# a_21487_106400# 0 $ **FLOATING
C248 m4_65100_21860# a_21487_106400# 0 $ **FLOATING
C249 m4_65100_22042# a_21487_106400# 1.1617500000000001e-16
C250 m4_65730_22220# a_21487_106400# 0 $ **FLOATING
C251 m4_65428_22204# a_21487_106400# 0 $ **FLOATING
C252 m4_65100_22426# a_21487_106400# 5.3096900000000011e-16
C253 m4_22690_106400# a_21487_106400# 0 $ **FLOATING
C254 m4_22130_106400# a_21487_106400# 0 $ **FLOATING
C255 m4_22690_106630# a_21487_106400# 0 $ **FLOATING
C256 m4_21570_106400# a_21487_106400# 0 $ **FLOATING
C257 m4_20450_106400# a_21487_106400# 0 $ **FLOATING
C258 m4_22130_106770# a_21487_106400# 0 $ **FLOATING
C259 m4_21010_106490# a_21487_106400# 0 $ **FLOATING
C260 m4_20000_106400# a_21487_106400# 0 $ **FLOATING
C261 m4_22690_107190# a_21487_106400# 0 $ **FLOATING
C262 m4_21570_106910# a_21487_106400# 0 $ **FLOATING
C263 m4_20450_106630# a_21487_106400# 0 $ **FLOATING
C264 m4_22130_107330# a_21487_106400# 0 $ **FLOATING
C265 m4_21010_107050# a_21487_106400# 0 $ **FLOATING
C266 m4_20000_106770# a_21487_106400# 0 $ **FLOATING
C267 m4_22690_107750# a_21487_106400# 0 $ **FLOATING
C268 m4_21570_107470# a_21487_106400# 0 $ **FLOATING
C269 m4_20450_107190# a_21487_106400# 0 $ **FLOATING
C270 m4_22130_107890# a_21487_106400# 0 $ **FLOATING
C271 m4_21010_107610# a_21487_106400# 0 $ **FLOATING
C272 m4_20000_107330# a_21487_106400# 0 $ **FLOATING
C273 m4_22690_108310# a_21487_106400# 0 $ **FLOATING
C274 m4_21570_108030# a_21487_106400# 0 $ **FLOATING
C275 m4_20450_107750# a_21487_106400# 0 $ **FLOATING
C276 m4_22130_108450# a_21487_106400# 0 $ **FLOATING
C277 m4_21010_108170# a_21487_106400# 0 $ **FLOATING
C278 m4_20000_107890# a_21487_106400# 0 $ **FLOATING
C279 m4_22690_108870# a_21487_106400# 0 $ **FLOATING
C280 m4_21570_108590# a_21487_106400# 0 $ **FLOATING
C281 m4_20450_108310# a_21487_106400# 0 $ **FLOATING
C282 m4_22130_109010# a_21487_106400# 0 $ **FLOATING
C283 m4_21010_108730# a_21487_106400# 0 $ **FLOATING
C284 m4_20000_108450# a_21487_106400# 0 $ **FLOATING
C285 m4_22690_109430# a_21487_106400# 0 $ **FLOATING
C286 m4_21570_109150# a_21487_106400# 0 $ **FLOATING
C287 m4_20450_108870# a_21487_106400# 0 $ **FLOATING
C288 m4_22130_109570# a_21487_106400# 0 $ **FLOATING
C289 m4_21010_109290# a_21487_106400# 0 $ **FLOATING
C290 m4_20000_109010# a_21487_106400# 0 $ **FLOATING
C291 m4_20450_109430# a_21487_106400# 0 $ **FLOATING
C292 m4_20000_109570# a_21487_106400# 0 $ **FLOATING
C293 m3_67434_20000# a_21487_106400# 0 $ **FLOATING
C294 m3_67434_20066# a_21487_106400# 0 $ **FLOATING
C295 m3_66906_20000# a_21487_106400# 0 $ **FLOATING
C296 m3_66730_20000# a_21487_106400# 0 $ **FLOATING
C297 m3_67434_20242# a_21487_106400# 0 $ **FLOATING
C298 m3_66906_20134# a_21487_106400# 0 $ **FLOATING
C299 m3_66730_20098# a_21487_106400# 0 $ **FLOATING
C300 m3_66554_20062# a_21487_106400# 0 $ **FLOATING
C301 m3_66378_20026# a_21487_106400# 0 $ **FLOATING
C302 m3_66202_20000# a_21487_106400# 0 $ **FLOATING
C303 m3_66026_20000# a_21487_106400# 0 $ **FLOATING
C304 m3_65850_20000# a_21487_106400# 0 $ **FLOATING
C305 m3_67434_20418# a_21487_106400# 0 $ **FLOATING
C306 m3_66906_20310# a_21487_106400# 0 $ **FLOATING
C307 m3_66730_20274# a_21487_106400# 0 $ **FLOATING
C308 m3_66554_20238# a_21487_106400# 0 $ **FLOATING
C309 m3_66378_20202# a_21487_106400# 0 $ **FLOATING
C310 m3_66202_20166# a_21487_106400# 0 $ **FLOATING
C311 m3_66026_20130# a_21487_106400# 0 $ **FLOATING
C312 m3_65498_20022# a_21487_106400# 0 $ **FLOATING
C313 m3_65322_20000# a_21487_106400# 0 $ **FLOATING
C314 m3_65146_20000# a_21487_106400# 0 $ **FLOATING
C315 m3_67434_20594# a_21487_106400# 0 $ **FLOATING
C316 m3_66906_20486# a_21487_106400# 0 $ **FLOATING
C317 m3_66730_20450# a_21487_106400# 0 $ **FLOATING
C318 m3_66554_20414# a_21487_106400# 0 $ **FLOATING
C319 m3_66378_20378# a_21487_106400# 0 $ **FLOATING
C320 m3_66202_20342# a_21487_106400# 0 $ **FLOATING
C321 m3_66026_20306# a_21487_106400# 0 $ **FLOATING
C322 m3_65498_20198# a_21487_106400# 0 $ **FLOATING
C323 m3_65322_20162# a_21487_106400# 0 $ **FLOATING
C324 m3_65146_20126# a_21487_106400# 0 $ **FLOATING
C325 m3_67434_20770# a_21487_106400# 0 $ **FLOATING
C326 m3_67258_20734# a_21487_106400# 0 $ **FLOATING
C327 m3_66906_20662# a_21487_106400# 0 $ **FLOATING
C328 m3_66730_20626# a_21487_106400# 0 $ **FLOATING
C329 m3_66554_20590# a_21487_106400# 0 $ **FLOATING
C330 m3_66378_20554# a_21487_106400# 0 $ **FLOATING
C331 m3_66202_20518# a_21487_106400# 0 $ **FLOATING
C332 m3_66026_20482# a_21487_106400# 0 $ **FLOATING
C333 m3_65498_20374# a_21487_106400# 0 $ **FLOATING
C334 m3_65322_20338# a_21487_106400# 0 $ **FLOATING
C335 m3_65146_20302# a_21487_106400# 0 $ **FLOATING
C336 m3_67434_20946# a_21487_106400# 0 $ **FLOATING
C337 m3_67258_20910# a_21487_106400# 0 $ **FLOATING
C338 m3_67082_20874# a_21487_106400# 0 $ **FLOATING
C339 m3_66906_20838# a_21487_106400# 0 $ **FLOATING
C340 m3_66730_20802# a_21487_106400# 0 $ **FLOATING
C341 m3_66554_20766# a_21487_106400# 0 $ **FLOATING
C342 m3_66378_20730# a_21487_106400# 0 $ **FLOATING
C343 m3_66202_20694# a_21487_106400# 0 $ **FLOATING
C344 m3_66026_20658# a_21487_106400# 0 $ **FLOATING
C345 m3_65498_20550# a_21487_106400# 0 $ **FLOATING
C346 m3_65322_20514# a_21487_106400# 0 $ **FLOATING
C347 m3_65146_20478# a_21487_106400# 0 $ **FLOATING
C348 m3_67434_21122# a_21487_106400# 0 $ **FLOATING
C349 m3_67258_21086# a_21487_106400# 0 $ **FLOATING
C350 m3_67082_21050# a_21487_106400# 0 $ **FLOATING
C351 m3_66906_21014# a_21487_106400# 0 $ **FLOATING
C352 m3_66730_20978# a_21487_106400# 0 $ **FLOATING
C353 m3_66554_20942# a_21487_106400# 0 $ **FLOATING
C354 m3_66378_20906# a_21487_106400# 0 $ **FLOATING
C355 m3_66202_20870# a_21487_106400# 0 $ **FLOATING
C356 m3_66026_20834# a_21487_106400# 0 $ **FLOATING
C357 m3_65850_20798# a_21487_106400# 0 $ **FLOATING
C358 m3_65674_20762# a_21487_106400# 0 $ **FLOATING
C359 m3_65498_20726# a_21487_106400# 0 $ **FLOATING
C360 m3_65322_20690# a_21487_106400# 0 $ **FLOATING
C361 m3_65146_20654# a_21487_106400# 0 $ **FLOATING
C362 m3_66026_21010# a_21487_106400# 0 $ **FLOATING
C363 m3_65850_20974# a_21487_106400# 0 $ **FLOATING
C364 m3_65674_20938# a_21487_106400# 0 $ **FLOATING
C365 m3_65498_20902# a_21487_106400# 0 $ **FLOATING
C366 m3_65322_20866# a_21487_106400# 0 $ **FLOATING
C367 m3_65146_20830# a_21487_106400# 0 $ **FLOATING
C368 m3_67434_21298# a_21487_106400# 0 $ **FLOATING
C369 m3_66906_21190# a_21487_106400# 0 $ **FLOATING
C370 m3_66730_21154# a_21487_106400# 0 $ **FLOATING
C371 m3_65498_21078# a_21487_106400# 0 $ **FLOATING
C372 m3_65322_21042# a_21487_106400# 0 $ **FLOATING
C373 m3_65146_21006# a_21487_106400# 0 $ **FLOATING
C374 m3_67434_21474# a_21487_106400# 0 $ **FLOATING
C375 m3_67130_21320# a_21487_106400# 0 $ **FLOATING
C376 m3_66906_21366# a_21487_106400# 0 $ **FLOATING
C377 m3_66610_21340# a_21487_106400# 0 $ **FLOATING
C378 m3_66350_21220# a_21487_106400# 0 $ **FLOATING
C379 m3_66090_21360# a_21487_106400# 0 $ **FLOATING
C380 m3_65830_21240# a_21487_106400# 0 $ **FLOATING
C381 m3_67434_21650# a_21487_106400# 0 $ **FLOATING
C382 m3_67434_21826# a_21487_106400# 0 $ **FLOATING
C383 m3_67434_22002# a_21487_106400# 0 $ **FLOATING
C384 m3_66930_21650# a_21487_106400# 0 $ **FLOATING
C385 m3_66730_21682# a_21487_106400# 0 $ **FLOATING
C386 m3_66554_21646# a_21487_106400# 0 $ **FLOATING
C387 m3_66378_21610# a_21487_106400# 0 $ **FLOATING
C388 m3_65850_21502# a_21487_106400# 0 $ **FLOATING
C389 m3_65570_21380# a_21487_106400# 0 $ **FLOATING
C390 m3_65310_21260# a_21487_106400# 0 $ **FLOATING
C391 m3_65110_21200# a_21487_106400# 0 $ **FLOATING
C392 m3_65110_21360# a_21487_106400# 0 $ **FLOATING
C393 m3_66730_21858# a_21487_106400# 0 $ **FLOATING
C394 m3_66554_21822# a_21487_106400# 0 $ **FLOATING
C395 m3_66378_21786# a_21487_106400# 0 $ **FLOATING
C396 m3_66202_21750# a_21487_106400# 0 $ **FLOATING
C397 m3_66026_21714# a_21487_106400# 0 $ **FLOATING
C398 m3_65850_21678# a_21487_106400# 0 $ **FLOATING
C399 m3_65674_21642# a_21487_106400# 0 $ **FLOATING
C400 m3_65322_21570# a_21487_106400# 0 $ **FLOATING
C401 m3_67434_22178# a_21487_106400# 0 $ **FLOATING
C402 m3_67258_22142# a_21487_106400# 0 $ **FLOATING
C403 m3_66730_22034# a_21487_106400# 0 $ **FLOATING
C404 m3_66554_21998# a_21487_106400# 0 $ **FLOATING
C405 m3_66378_21962# a_21487_106400# 0 $ **FLOATING
C406 m3_66202_21926# a_21487_106400# 0 $ **FLOATING
C407 m3_66026_21890# a_21487_106400# 0 $ **FLOATING
C408 m3_65850_21854# a_21487_106400# 0 $ **FLOATING
C409 m3_65674_21818# a_21487_106400# 0 $ **FLOATING
C410 m3_65498_21782# a_21487_106400# 0 $ **FLOATING
C411 m3_65322_21746# a_21487_106400# 0 $ **FLOATING
C412 m3_67434_22354# a_21487_106400# 0 $ **FLOATING
C413 m3_67258_22318# a_21487_106400# 0 $ **FLOATING
C414 m3_67082_22282# a_21487_106400# 0 $ **FLOATING
C415 m3_66906_22246# a_21487_106400# 0 $ **FLOATING
C416 m3_66730_22210# a_21487_106400# 0 $ **FLOATING
C417 m3_66554_22174# a_21487_106400# 0 $ **FLOATING
C418 m3_66378_22138# a_21487_106400# 0 $ **FLOATING
C419 m3_66202_22102# a_21487_106400# 0 $ **FLOATING
C420 m3_65674_21994# a_21487_106400# 0 $ **FLOATING
C421 m3_65498_21958# a_21487_106400# 0 $ **FLOATING
C422 m3_65322_21922# a_21487_106400# 0 $ **FLOATING
C423 m3_67258_22494# a_21487_106400# 0 $ **FLOATING
C424 m3_67082_22458# a_21487_106400# 0 $ **FLOATING
C425 m3_66906_22422# a_21487_106400# 0 $ **FLOATING
C426 m3_66730_22386# a_21487_106400# 0 $ **FLOATING
C427 m3_66554_22350# a_21487_106400# 0 $ **FLOATING
C428 m3_66378_22314# a_21487_106400# 0 $ **FLOATING
C429 m3_66202_22278# a_21487_106400# 0 $ **FLOATING
C430 m3_65674_22170# a_21487_106400# 0 $ **FLOATING
C431 m3_65498_22134# a_21487_106400# 0 $ **FLOATING
C432 m3_65322_22098# a_21487_106400# 0 $ **FLOATING
C433 m3_66378_22490# a_21487_106400# 0 $ **FLOATING
C434 m3_66202_22454# a_21487_106400# 0 $ **FLOATING
C435 m3_66000_22226# a_21487_106400# 1.5996000000000004e-16
C436 m3_65674_22346# a_21487_106400# 0 $ **FLOATING
C437 m3_65498_22310# a_21487_106400# 0 $ **FLOATING
C438 m3_65322_22274# a_21487_106400# 0 $ **FLOATING
C439 m3_65146_22238# a_21487_106400# 0 $ **FLOATING
C440 m3_65498_22486# a_21487_106400# 0 $ **FLOATING
C441 m3_65322_22450# a_21487_106400# 0 $ **FLOATING
C442 m3_65146_22414# a_21487_106400# 0 $ **FLOATING
C443 m3_22690_106400# a_21487_106400# 0 $ **FLOATING
C444 m3_22130_106400# a_21487_106400# 0 $ **FLOATING
C445 m3_22690_106630# a_21487_106400# 0 $ **FLOATING
C446 m3_21570_106400# a_21487_106400# 0 $ **FLOATING
C447 m3_20450_106400# a_21487_106400# 0 $ **FLOATING
C448 m3_22130_106770# a_21487_106400# 0 $ **FLOATING
C449 m3_21010_106490# a_21487_106400# 0 $ **FLOATING
C450 m3_20000_106400# a_21487_106400# 0 $ **FLOATING
C451 m3_22690_107190# a_21487_106400# 0 $ **FLOATING
C452 m3_21570_106910# a_21487_106400# 0 $ **FLOATING
C453 m3_20450_106630# a_21487_106400# 0 $ **FLOATING
C454 m3_22130_107330# a_21487_106400# 0 $ **FLOATING
C455 m3_21010_107050# a_21487_106400# 0 $ **FLOATING
C456 m3_20000_106770# a_21487_106400# 0 $ **FLOATING
C457 m3_22690_107750# a_21487_106400# 0 $ **FLOATING
C458 m3_21570_107470# a_21487_106400# 0 $ **FLOATING
C459 m3_20450_107190# a_21487_106400# 0 $ **FLOATING
C460 m3_22130_107890# a_21487_106400# 0 $ **FLOATING
C461 m3_21010_107610# a_21487_106400# 0 $ **FLOATING
C462 m3_20000_107330# a_21487_106400# 0 $ **FLOATING
C463 m3_22690_108310# a_21487_106400# 0 $ **FLOATING
C464 m3_21570_108030# a_21487_106400# 0 $ **FLOATING
C465 m3_20450_107750# a_21487_106400# 0 $ **FLOATING
C466 m3_22130_108450# a_21487_106400# 0 $ **FLOATING
C467 m3_21010_108170# a_21487_106400# 0 $ **FLOATING
C468 m3_20000_107890# a_21487_106400# 0 $ **FLOATING
C469 m3_22690_108870# a_21487_106400# 0 $ **FLOATING
C470 m3_21570_108590# a_21487_106400# 0 $ **FLOATING
C471 m3_20450_108310# a_21487_106400# 0 $ **FLOATING
C472 m3_22130_109010# a_21487_106400# 0 $ **FLOATING
C473 m3_21010_108730# a_21487_106400# 0 $ **FLOATING
C474 m3_20000_108450# a_21487_106400# 0 $ **FLOATING
C475 m3_22690_109430# a_21487_106400# 0 $ **FLOATING
C476 m3_21570_109150# a_21487_106400# 0 $ **FLOATING
C477 m3_20450_108870# a_21487_106400# 0 $ **FLOATING
C478 m3_22130_109570# a_21487_106400# 0 $ **FLOATING
C479 m3_21010_109290# a_21487_106400# 0 $ **FLOATING
C480 m3_20000_109010# a_21487_106400# 0 $ **FLOATING
C481 m3_20450_109430# a_21487_106400# 0 $ **FLOATING
C482 m3_20000_109570# a_21487_106400# 0 $ **FLOATING
C483 m2_67580_20024# a_21487_106400# 0 $ **FLOATING
C484 m2_67424_20008# a_21487_106400# 0 $ **FLOATING
C485 m2_67268_20000# a_21487_106400# 0 $ **FLOATING
C486 m2_67112_20000# a_21487_106400# 0 $ **FLOATING
C487 m2_66956_20000# a_21487_106400# 0 $ **FLOATING
C488 m2_66800_20000# a_21487_106400# 0 $ **FLOATING
C489 m2_66644_20000# a_21487_106400# 0 $ **FLOATING
C490 m2_66488_20000# a_21487_106400# 0 $ **FLOATING
C491 m2_67580_20180# a_21487_106400# 0 $ **FLOATING
C492 m2_67424_20164# a_21487_106400# 0 $ **FLOATING
C493 m2_66956_20116# a_21487_106400# 0 $ **FLOATING
C494 m2_66800_20100# a_21487_106400# 0 $ **FLOATING
C495 m2_66644_20084# a_21487_106400# 0 $ **FLOATING
C496 m2_66488_20068# a_21487_106400# 0 $ **FLOATING
C497 m2_66332_20052# a_21487_106400# 0 $ **FLOATING
C498 m2_66176_20036# a_21487_106400# 0 $ **FLOATING
C499 m2_66021_20020# a_21487_106400# 0 $ **FLOATING
C500 m2_65864_20004# a_21487_106400# 0 $ **FLOATING
C501 m2_65708_20000# a_21487_106400# 0 $ **FLOATING
C502 m2_65552_20000# a_21487_106400# 0 $ **FLOATING
C503 m2_65396_20000# a_21487_106400# 0 $ **FLOATING
C504 m2_65240_20000# a_21487_106400# 0 $ **FLOATING
C505 m2_65100_20000# a_21487_106400# 0 $ **FLOATING
C506 m2_67580_20336# a_21487_106400# 0 $ **FLOATING
C507 m2_67424_20320# a_21487_106400# 0 $ **FLOATING
C508 m2_66956_20272# a_21487_106400# 0 $ **FLOATING
C509 m2_66800_20256# a_21487_106400# 0 $ **FLOATING
C510 m2_66644_20240# a_21487_106400# 0 $ **FLOATING
C511 m2_66488_20224# a_21487_106400# 0 $ **FLOATING
C512 m2_66332_20208# a_21487_106400# 0 $ **FLOATING
C513 m2_66176_20192# a_21487_106400# 0 $ **FLOATING
C514 m2_66021_20176# a_21487_106400# 0 $ **FLOATING
C515 m2_65552_20128# a_21487_106400# 0 $ **FLOATING
C516 m2_65396_20112# a_21487_106400# 0 $ **FLOATING
C517 m2_65240_20096# a_21487_106400# 0 $ **FLOATING
C518 m2_65100_20080# a_21487_106400# 0 $ **FLOATING
C519 m2_67580_20492# a_21487_106400# 0 $ **FLOATING
C520 m2_67424_20476# a_21487_106400# 0 $ **FLOATING
C521 m2_66956_20428# a_21487_106400# 0 $ **FLOATING
C522 m2_66800_20412# a_21487_106400# 0 $ **FLOATING
C523 m2_66644_20396# a_21487_106400# 0 $ **FLOATING
C524 m2_66488_20380# a_21487_106400# 0 $ **FLOATING
C525 m2_66332_20364# a_21487_106400# 0 $ **FLOATING
C526 m2_66176_20348# a_21487_106400# 0 $ **FLOATING
C527 m2_66021_20332# a_21487_106400# 0 $ **FLOATING
C528 m2_65552_20284# a_21487_106400# 0 $ **FLOATING
C529 m2_65396_20268# a_21487_106400# 0 $ **FLOATING
C530 m2_65240_20252# a_21487_106400# 0 $ **FLOATING
C531 m2_65100_20236# a_21487_106400# 0 $ **FLOATING
C532 m2_67580_20648# a_21487_106400# 0 $ **FLOATING
C533 m2_67424_20632# a_21487_106400# 0 $ **FLOATING
C534 m2_66956_20584# a_21487_106400# 0 $ **FLOATING
C535 m2_66800_20568# a_21487_106400# 0 $ **FLOATING
C536 m2_66644_20552# a_21487_106400# 0 $ **FLOATING
C537 m2_66488_20536# a_21487_106400# 0 $ **FLOATING
C538 m2_66332_20520# a_21487_106400# 0 $ **FLOATING
C539 m2_66176_20504# a_21487_106400# 0 $ **FLOATING
C540 m2_66021_20488# a_21487_106400# 0 $ **FLOATING
C541 m2_65552_20440# a_21487_106400# 0 $ **FLOATING
C542 m2_65396_20424# a_21487_106400# 0 $ **FLOATING
C543 m2_65240_20408# a_21487_106400# 0 $ **FLOATING
C544 m2_65100_20392# a_21487_106400# 0 $ **FLOATING
C545 m2_67580_20804# a_21487_106400# 0 $ **FLOATING
C546 m2_67424_20788# a_21487_106400# 0 $ **FLOATING
C547 m2_67268_20772# a_21487_106400# 0 $ **FLOATING
C548 m2_67112_20756# a_21487_106400# 0 $ **FLOATING
C549 m2_66956_20740# a_21487_106400# 0 $ **FLOATING
C550 m2_66800_20724# a_21487_106400# 0 $ **FLOATING
C551 m2_66644_20708# a_21487_106400# 0 $ **FLOATING
C552 m2_66488_20692# a_21487_106400# 0 $ **FLOATING
C553 m2_66332_20676# a_21487_106400# 0 $ **FLOATING
C554 m2_66176_20660# a_21487_106400# 0 $ **FLOATING
C555 m2_66021_20644# a_21487_106400# 0 $ **FLOATING
C556 m2_65552_20596# a_21487_106400# 0 $ **FLOATING
C557 m2_65396_20580# a_21487_106400# 0 $ **FLOATING
C558 m2_65240_20564# a_21487_106400# 0 $ **FLOATING
C559 m2_65100_20548# a_21487_106400# 0 $ **FLOATING
C560 m2_67300_20940# a_21487_106400# 0 $ **FLOATING
C561 m2_67112_20912# a_21487_106400# 0 $ **FLOATING
C562 m2_66956_20896# a_21487_106400# 0 $ **FLOATING
C563 m2_66800_20880# a_21487_106400# 0 $ **FLOATING
C564 m2_66644_20864# a_21487_106400# 0 $ **FLOATING
C565 m2_66488_20848# a_21487_106400# 0 $ **FLOATING
C566 m2_66332_20832# a_21487_106400# 0 $ **FLOATING
C567 m2_66176_20816# a_21487_106400# 0 $ **FLOATING
C568 m2_66020_20800# a_21487_106400# 0 $ **FLOATING
C569 m2_65864_20784# a_21487_106400# 0 $ **FLOATING
C570 m2_65708_20768# a_21487_106400# 0 $ **FLOATING
C571 m2_65552_20752# a_21487_106400# 0 $ **FLOATING
C572 m2_65396_20736# a_21487_106400# 0 $ **FLOATING
C573 m2_65240_20720# a_21487_106400# 0 $ **FLOATING
C574 m2_65100_20704# a_21487_106400# 0 $ **FLOATING
C575 m2_67112_21068# a_21487_106400# 0 $ **FLOATING
C576 m2_66956_21052# a_21487_106400# 0 $ **FLOATING
C577 m2_66800_21036# a_21487_106400# 0 $ **FLOATING
C578 m2_66644_21020# a_21487_106400# 0 $ **FLOATING
C579 m2_66488_21004# a_21487_106400# 0 $ **FLOATING
C580 m2_66332_20988# a_21487_106400# 0 $ **FLOATING
C581 m2_66176_20972# a_21487_106400# 0 $ **FLOATING
C582 m2_66020_20956# a_21487_106400# 0 $ **FLOATING
C583 m2_65864_20940# a_21487_106400# 0 $ **FLOATING
C584 m2_65708_20924# a_21487_106400# 0 $ **FLOATING
C585 m2_65552_20908# a_21487_106400# 0 $ **FLOATING
C586 m2_65396_20892# a_21487_106400# 0 $ **FLOATING
C587 m2_65240_20876# a_21487_106400# 0 $ **FLOATING
C588 m2_65100_20860# a_21487_106400# 0 $ **FLOATING
C589 m2_67424_21256# a_21487_106400# 0 $ **FLOATING
C590 m2_67268_21240# a_21487_106400# 0 $ **FLOATING
C591 m2_67112_21224# a_21487_106400# 0 $ **FLOATING
C592 m2_66956_21208# a_21487_106400# 0 $ **FLOATING
C593 m2_66800_21192# a_21487_106400# 0 $ **FLOATING
C594 m2_66644_21176# a_21487_106400# 0 $ **FLOATING
C595 m2_66488_21160# a_21487_106400# 0 $ **FLOATING
C596 m2_66332_21144# a_21487_106400# 0 $ **FLOATING
C597 m2_66176_21128# a_21487_106400# 0 $ **FLOATING
C598 m2_66020_21112# a_21487_106400# 0 $ **FLOATING
C599 m2_65864_21096# a_21487_106400# 0 $ **FLOATING
C600 m2_65708_21080# a_21487_106400# 0 $ **FLOATING
C601 m2_65552_21064# a_21487_106400# 0 $ **FLOATING
C602 m2_65396_21048# a_21487_106400# 0 $ **FLOATING
C603 m2_65240_21032# a_21487_106400# 0 $ **FLOATING
C604 m2_65100_21016# a_21487_106400# 0 $ **FLOATING
C605 m2_66700_21360# a_21487_106400# 0 $ **FLOATING
C606 m2_66400_21320# a_21487_106400# 0 $ **FLOATING
C607 m2_66300_21340# a_21487_106400# 0 $ **FLOATING
C608 m2_66200_21360# a_21487_106400# 0 $ **FLOATING
C609 m2_65864_21252# a_21487_106400# 0 $ **FLOATING
C610 m2_65708_21236# a_21487_106400# 0 $ **FLOATING
C611 m2_65552_21220# a_21487_106400# 0 $ **FLOATING
C612 m2_65396_21204# a_21487_106400# 0 $ **FLOATING
C613 m2_65240_21188# a_21487_106400# 0 $ **FLOATING
C614 m2_65100_21172# a_21487_106400# 0 $ **FLOATING
C615 m2_65200_21360# a_21487_106400# 0 $ **FLOATING
C616 m2_65100_21482# a_21487_106400# 3.5008700000000003e-16
C617 m2_65100_21674# a_21487_106400# 1.9860200000000002e-16
C618 m2_67580_21896# a_21487_106400# 0 $ **FLOATING
C619 m2_67424_21880# a_21487_106400# 0 $ **FLOATING
C620 m2_67268_21864# a_21487_106400# 0 $ **FLOATING
C621 m2_67112_21848# a_21487_106400# 0 $ **FLOATING
C622 m2_66956_21832# a_21487_106400# 0 $ **FLOATING
C623 m2_66800_21816# a_21487_106400# 0 $ **FLOATING
C624 m2_66600_21780# a_21487_106400# 0 $ **FLOATING
C625 m2_66500_21800# a_21487_106400# 0 $ **FLOATING
C626 m2_66700_21860# a_21487_106400# 0 $ **FLOATING
C627 m2_66400_21820# a_21487_106400# 0 $ **FLOATING
C628 m2_66100_21780# a_21487_106400# 0 $ **FLOATING
C629 m2_66600_21880# a_21487_106400# 0 $ **FLOATING
C630 m2_66500_21900# a_21487_106400# 0 $ **FLOATING
C631 m2_67000_22000# a_21487_106400# 0 $ **FLOATING
C632 m2_66700_21960# a_21487_106400# 0 $ **FLOATING
C633 m2_66900_22020# a_21487_106400# 0 $ **FLOATING
C634 m2_66600_21980# a_21487_106400# 0 $ **FLOATING
C635 m2_66500_22000# a_21487_106400# 0 $ **FLOATING
C636 m2_66332_21924# a_21487_106400# 0 $ **FLOATING
C637 m2_66176_21908# a_21487_106400# 0 $ **FLOATING
C638 m2_66020_21892# a_21487_106400# 0 $ **FLOATING
C639 m2_65864_21876# a_21487_106400# 0 $ **FLOATING
C640 m2_65708_21860# a_21487_106400# 0 $ **FLOATING
C641 m2_65552_21844# a_21487_106400# 0 $ **FLOATING
C642 m2_65396_21828# a_21487_106400# 0 $ **FLOATING
C643 m2_65240_21812# a_21487_106400# 0 $ **FLOATING
C644 m2_65100_21780# a_21487_106400# 0 $ **FLOATING
C645 m2_66200_22160# a_21487_106400# 0 $ **FLOATING
C646 m2_66020_22048# a_21487_106400# 0 $ **FLOATING
C647 m2_65864_22032# a_21487_106400# 0 $ **FLOATING
C648 m2_65708_22016# a_21487_106400# 0 $ **FLOATING
C649 m2_65552_22000# a_21487_106400# 0 $ **FLOATING
C650 m2_65396_21984# a_21487_106400# 0 $ **FLOATING
C651 m2_65240_21968# a_21487_106400# 0 $ **FLOATING
C652 m2_65100_21952# a_21487_106400# 0 $ **FLOATING
C653 m2_65900_22220# a_21487_106400# 0 $ **FLOATING
C654 m2_65600_22180# a_21487_106400# 0 $ **FLOATING
C655 m2_65500_22200# a_21487_106400# 0 $ **FLOATING
C656 m2_65400_22220# a_21487_106400# 0 $ **FLOATING
C657 m2_65240_22124# a_21487_106400# 0 $ **FLOATING
C658 m2_65100_22108# a_21487_106400# 0 $ **FLOATING
C659 m2_65100_22346# a_21487_106400# 6.0877200000000016e-16
C660 m2_67300_22440# a_21487_106400# 0 $ **FLOATING
C661 m2_67200_22460# a_21487_106400# 0 $ **FLOATING
C662 m2_67100_22480# a_21487_106400# 0 $ **FLOATING
C663 m2_66800_22440# a_21487_106400# 0 $ **FLOATING
C664 m2_66700_22460# a_21487_106400# 0 $ **FLOATING
C665 m2_66600_22480# a_21487_106400# 0 $ **FLOATING
C666 m2_66300_22440# a_21487_106400# 0 $ **FLOATING
C667 m2_66200_22460# a_21487_106400# 0 $ **FLOATING
C668 m2_66100_22480# a_21487_106400# 0 $ **FLOATING
C669 m2_65800_22440# a_21487_106400# 0 $ **FLOATING
C670 m2_65700_22460# a_21487_106400# 0 $ **FLOATING
C671 m2_65600_22480# a_21487_106400# 0 $ **FLOATING
C672 m2_65300_22440# a_21487_106400# 0 $ **FLOATING
C673 m2_65200_22460# a_21487_106400# 0 $ **FLOATING
C674 m2_65100_22480# a_21487_106400# 0 $ **FLOATING
C675 m2_22690_106400# a_21487_106400# 0 $ **FLOATING
C676 m2_22900_106520# a_21487_106400# 0 $ **FLOATING
C677 m2_22130_106400# a_21487_106400# 0 $ **FLOATING
C678 m2_22690_106630# a_21487_106400# 0 $ **FLOATING
C679 m2_22200_106660# a_21487_106400# 0 $ **FLOATING
C680 m2_21570_106400# a_21487_106400# 0 $ **FLOATING
C681 m2_21100_106400# a_21487_106400# 0 $ **FLOATING
C682 m2_20900_106420# a_21487_106400# 0 $ **FLOATING
C683 m2_20450_106400# a_21487_106400# 0 $ **FLOATING
C684 m2_23100_107080# a_21487_106400# 0 $ **FLOATING
C685 m2_22600_107080# a_21487_106400# 0 $ **FLOATING
C686 m2_22130_106770# a_21487_106400# 0 $ **FLOATING
C687 m2_22000_106800# a_21487_106400# 0 $ **FLOATING
C688 m2_21500_106800# a_21487_106400# 0 $ **FLOATING
C689 m2_21010_106490# a_21487_106400# 0 $ **FLOATING
C690 m2_20900_106520# a_21487_106400# 0 $ **FLOATING
C691 m2_20400_106520# a_21487_106400# 0 $ **FLOATING
C692 m2_20000_106400# a_21487_106400# 0 $ **FLOATING
C693 m2_20900_106620# a_21487_106400# 0 $ **FLOATING
C694 m2_20900_106720# a_21487_106400# 0 $ **FLOATING
C695 m2_20900_106820# a_21487_106400# 0 $ **FLOATING
C696 m2_22690_107190# a_21487_106400# 0 $ **FLOATING
C697 m2_22400_107220# a_21487_106400# 0 $ **FLOATING
C698 m2_21570_106910# a_21487_106400# 0 $ **FLOATING
C699 m2_21300_106940# a_21487_106400# 0 $ **FLOATING
C700 m2_20900_106920# a_21487_106400# 0 $ **FLOATING
C701 m2_22800_107640# a_21487_106400# 0 $ **FLOATING
C702 m2_22130_107330# a_21487_106400# 0 $ **FLOATING
C703 m2_21700_107360# a_21487_106400# 0 $ **FLOATING
C704 m2_21010_107050# a_21487_106400# 0 $ **FLOATING
C705 m2_20900_107020# a_21487_106400# 0 $ **FLOATING
C706 m2_20450_106630# a_21487_106400# 0 $ **FLOATING
C707 m2_20200_106660# a_21487_106400# 0 $ **FLOATING
C708 m2_20900_107120# a_21487_106400# 0 $ **FLOATING
C709 m2_20600_107080# a_21487_106400# 0 $ **FLOATING
C710 m2_20000_106770# a_21487_106400# 0 $ **FLOATING
C711 m2_20900_107220# a_21487_106400# 0 $ **FLOATING
C712 m2_20900_107320# a_21487_106400# 0 $ **FLOATING
C713 m2_22690_107750# a_21487_106400# 0 $ **FLOATING
C714 m2_22100_107780# a_21487_106400# 0 $ **FLOATING
C715 m2_21570_107470# a_21487_106400# 0 $ **FLOATING
C716 m2_20900_107420# a_21487_106400# 0 $ **FLOATING
C717 m2_21000_107500# a_21487_106400# 0 $ **FLOATING
C718 m2_20900_107520# a_21487_106400# 0 $ **FLOATING
C719 m2_20450_107190# a_21487_106400# 0 $ **FLOATING
C720 m2_23000_108200# a_21487_106400# 0 $ **FLOATING
C721 m2_22130_107890# a_21487_106400# 0 $ **FLOATING
C722 m2_21900_107920# a_21487_106400# 0 $ **FLOATING
C723 m2_21010_107610# a_21487_106400# 0 $ **FLOATING
C724 m2_20900_107620# a_21487_106400# 0 $ **FLOATING
C725 m2_20800_107640# a_21487_106400# 0 $ **FLOATING
C726 m2_20900_107720# a_21487_106400# 0 $ **FLOATING
C727 m2_20000_107330# a_21487_106400# 0 $ **FLOATING
C728 m2_20900_107820# a_21487_106400# 0 $ **FLOATING
C729 m2_20900_107920# a_21487_106400# 0 $ **FLOATING
C730 m2_22690_108310# a_21487_106400# 0 $ **FLOATING
C731 m2_22300_108340# a_21487_106400# 0 $ **FLOATING
C732 m2_21570_108030# a_21487_106400# 0 $ **FLOATING
C733 m2_21200_108060# a_21487_106400# 0 $ **FLOATING
C734 m2_20900_108020# a_21487_106400# 0 $ **FLOATING
C735 m2_22700_108760# a_21487_106400# 0 $ **FLOATING
C736 m2_22130_108450# a_21487_106400# 0 $ **FLOATING
C737 m2_21600_108480# a_21487_106400# 0 $ **FLOATING
C738 m2_21010_108170# a_21487_106400# 0 $ **FLOATING
C739 m2_20900_108120# a_21487_106400# 0 $ **FLOATING
C740 m2_20450_107750# a_21487_106400# 0 $ **FLOATING
C741 m2_20100_107780# a_21487_106400# 0 $ **FLOATING
C742 m2_20900_108220# a_21487_106400# 0 $ **FLOATING
C743 m2_20500_108200# a_21487_106400# 0 $ **FLOATING
C744 m2_20000_107890# a_21487_106400# 0 $ **FLOATING
C745 m2_20900_108320# a_21487_106400# 0 $ **FLOATING
C746 m2_20900_108420# a_21487_106400# 0 $ **FLOATING
C747 m2_20900_108520# a_21487_106400# 0 $ **FLOATING
C748 m2_22690_108870# a_21487_106400# 0 $ **FLOATING
C749 m2_22500_108900# a_21487_106400# 0 $ **FLOATING
C750 m2_21570_108590# a_21487_106400# 0 $ **FLOATING
C751 m2_21400_108620# a_21487_106400# 0 $ **FLOATING
C752 m2_20900_108620# a_21487_106400# 0 $ **FLOATING
C753 m2_20450_108310# a_21487_106400# 0 $ **FLOATING
C754 m2_20300_108340# a_21487_106400# 0 $ **FLOATING
C755 m2_22900_109320# a_21487_106400# 0 $ **FLOATING
C756 m2_22130_109010# a_21487_106400# 0 $ **FLOATING
C757 m2_21800_109040# a_21487_106400# 0 $ **FLOATING
C758 m2_21010_108730# a_21487_106400# 0 $ **FLOATING
C759 m2_20900_108720# a_21487_106400# 0 $ **FLOATING
C760 m2_20700_108760# a_21487_106400# 0 $ **FLOATING
C761 m2_20900_108820# a_21487_106400# 0 $ **FLOATING
C762 m2_20000_108450# a_21487_106400# 0 $ **FLOATING
C763 m2_20900_108920# a_21487_106400# 0 $ **FLOATING
C764 m2_20900_109020# a_21487_106400# 0 $ **FLOATING
C765 m2_22690_109430# a_21487_106400# 0 $ **FLOATING
C766 m2_22200_109460# a_21487_106400# 0 $ **FLOATING
C767 m2_21570_109150# a_21487_106400# 0 $ **FLOATING
C768 m2_20900_109120# a_21487_106400# 0 $ **FLOATING
C769 m2_21100_109180# a_21487_106400# 0 $ **FLOATING
C770 m2_20900_109220# a_21487_106400# 0 $ **FLOATING
C771 m2_20450_108870# a_21487_106400# 0 $ **FLOATING
C772 m2_20000_108900# a_21487_106400# 0 $ **FLOATING
C773 m2_22130_109570# a_21487_106400# 0 $ **FLOATING
C774 m2_22000_109600# a_21487_106400# 0 $ **FLOATING
C775 m2_21500_109600# a_21487_106400# 0 $ **FLOATING
C776 m2_21010_109290# a_21487_106400# 0 $ **FLOATING
C777 m2_20900_109320# a_21487_106400# 0 $ **FLOATING
C778 m2_20400_109320# a_21487_106400# 0 $ **FLOATING
C779 m2_20000_109010# a_21487_106400# 0 $ **FLOATING
C780 m2_20900_109420# a_21487_106400# 0 $ **FLOATING
C781 m2_20900_109520# a_21487_106400# 0 $ **FLOATING
C782 m2_20900_109620# a_21487_106400# 0 $ **FLOATING
C783 m2_20450_109430# a_21487_106400# 0 $ **FLOATING
C784 m2_20200_109460# a_21487_106400# 0 $ **FLOATING
C785 m2_20000_109570# a_21487_106400# 0 $ **FLOATING
C786 m1_67494_20000# a_21487_106400# 0 $ **FLOATING
C787 m1_67494_20094# a_21487_106400# 0 $ **FLOATING
C788 m1_67494_20250# a_21487_106400# 0 $ **FLOATING
C789 m1_67494_20406# a_21487_106400# 0 $ **FLOATING
C790 m1_67494_20562# a_21487_106400# 0 $ **FLOATING
C791 m1_67494_20718# a_21487_106400# 0 $ **FLOATING
C792 m1_67510_20890# a_21487_106400# 0 $ **FLOATING
C793 m1_67412_21080# a_21487_106400# 3.7989600000000005e-16
C794 m1_67350_20000# a_21487_106400# 3.5300800000000001e-16
C795 m1_67210_20000# a_21487_106400# 0 $ **FLOATING
C796 m1_67026_20000# a_21487_106400# 0 $ **FLOATING
C797 m1_67210_20050# a_21487_106400# 0 $ **FLOATING
C798 m1_67110_20070# a_21487_106400# 0 $ **FLOATING
C799 m1_66870_20030# a_21487_106400# 0 $ **FLOATING
C800 m1_66714_20014# a_21487_106400# 0 $ **FLOATING
C801 m1_66870_20186# a_21487_106400# 0 $ **FLOATING
C802 m1_66714_20170# a_21487_106400# 0 $ **FLOATING
C803 m1_66870_20342# a_21487_106400# 0 $ **FLOATING
C804 m1_66714_20326# a_21487_106400# 0 $ **FLOATING
C805 m1_66870_20498# a_21487_106400# 0 $ **FLOATING
C806 m1_66714_20482# a_21487_106400# 0 $ **FLOATING
C807 m1_66870_20654# a_21487_106400# 0 $ **FLOATING
C808 m1_66714_20638# a_21487_106400# 0 $ **FLOATING
C809 m1_66870_20810# a_21487_106400# 0 $ **FLOATING
C810 m1_66714_20794# a_21487_106400# 0 $ **FLOATING
C811 m1_66870_20966# a_21487_106400# 0 $ **FLOATING
C812 m1_66714_20950# a_21487_106400# 0 $ **FLOATING
C813 m1_66246_20000# a_21487_106400# 0 $ **FLOATING
C814 m1_66090_20000# a_21487_106400# 0 $ **FLOATING
C815 m1_65934_20000# a_21487_106400# 0 $ **FLOATING
C816 m1_65778_20000# a_21487_106400# 0 $ **FLOATING
C817 m1_65622_20000# a_21487_106400# 0 $ **FLOATING
C818 m1_65466_20000# a_21487_106400# 0 $ **FLOATING
C819 m1_66246_20122# a_21487_106400# 0 $ **FLOATING
C820 m1_66090_20106# a_21487_106400# 0 $ **FLOATING
C821 m1_65710_20150# a_21487_106400# 0 $ **FLOATING
C822 m1_65466_20042# a_21487_106400# 0 $ **FLOATING
C823 m1_66246_20278# a_21487_106400# 0 $ **FLOATING
C824 m1_66090_20262# a_21487_106400# 0 $ **FLOATING
C825 m1_65710_20250# a_21487_106400# 0 $ **FLOATING
C826 m1_65466_20198# a_21487_106400# 0 $ **FLOATING
C827 m1_65710_20350# a_21487_106400# 0 $ **FLOATING
C828 m1_66246_20434# a_21487_106400# 0 $ **FLOATING
C829 m1_66090_20418# a_21487_106400# 0 $ **FLOATING
C830 m1_65710_20450# a_21487_106400# 0 $ **FLOATING
C831 m1_65466_20354# a_21487_106400# 0 $ **FLOATING
C832 m1_66246_20590# a_21487_106400# 0 $ **FLOATING
C833 m1_66090_20574# a_21487_106400# 0 $ **FLOATING
C834 m1_66246_20746# a_21487_106400# 0 $ **FLOATING
C835 m1_66090_20730# a_21487_106400# 0 $ **FLOATING
C836 m1_66246_20902# a_21487_106400# 0 $ **FLOATING
C837 m1_66090_20886# a_21487_106400# 0 $ **FLOATING
C838 m1_65710_20550# a_21487_106400# 0 $ **FLOATING
C839 m1_65466_20510# a_21487_106400# 0 $ **FLOATING
C840 m1_65710_20650# a_21487_106400# 0 $ **FLOATING
C841 m1_65710_20750# a_21487_106400# 0 $ **FLOATING
C842 m1_65466_20666# a_21487_106400# 0 $ **FLOATING
C843 m1_65710_20850# a_21487_106400# 0 $ **FLOATING
C844 m1_65466_20822# a_21487_106400# 0 $ **FLOATING
C845 m1_65710_20950# a_21487_106400# 0 $ **FLOATING
C846 m1_66870_21122# a_21487_106400# 0 $ **FLOATING
C847 m1_66714_21106# a_21487_106400# 0 $ **FLOATING
C848 m1_66246_21058# a_21487_106400# 0 $ **FLOATING
C849 m1_66090_21042# a_21487_106400# 0 $ **FLOATING
C850 m1_65710_21050# a_21487_106400# 0 $ **FLOATING
C851 m1_65466_20978# a_21487_106400# 0 $ **FLOATING
C852 m1_66870_21278# a_21487_106400# 0 $ **FLOATING
C853 m1_66714_21262# a_21487_106400# 0 $ **FLOATING
C854 m1_66246_21214# a_21487_106400# 0 $ **FLOATING
C855 m1_66090_21198# a_21487_106400# 0 $ **FLOATING
C856 m1_65710_21150# a_21487_106400# 0 $ **FLOATING
C857 m1_65466_21134# a_21487_106400# 0 $ **FLOATING
C858 m1_65710_21250# a_21487_106400# 0 $ **FLOATING
C859 m1_66870_21434# a_21487_106400# 0 $ **FLOATING
C860 m1_66714_21418# a_21487_106400# 0 $ **FLOATING
C861 m1_66246_21370# a_21487_106400# 0 $ **FLOATING
C862 m1_66090_21354# a_21487_106400# 0 $ **FLOATING
C863 m1_65710_21350# a_21487_106400# 0 $ **FLOATING
C864 m1_65466_21290# a_21487_106400# 0 $ **FLOATING
C865 m1_66870_21590# a_21487_106400# 0 $ **FLOATING
C866 m1_66714_21574# a_21487_106400# 0 $ **FLOATING
C867 m1_66246_21526# a_21487_106400# 0 $ **FLOATING
C868 m1_66090_21510# a_21487_106400# 0 $ **FLOATING
C869 m1_65710_21450# a_21487_106400# 0 $ **FLOATING
C870 m1_65710_21550# a_21487_106400# 0 $ **FLOATING
C871 m1_65466_21446# a_21487_106400# 0 $ **FLOATING
C872 m1_66870_21746# a_21487_106400# 0 $ **FLOATING
C873 m1_66714_21730# a_21487_106400# 0 $ **FLOATING
C874 m1_66246_21682# a_21487_106400# 0 $ **FLOATING
C875 m1_66090_21666# a_21487_106400# 0 $ **FLOATING
C876 m1_65710_21650# a_21487_106400# 0 $ **FLOATING
C877 m1_65466_21602# a_21487_106400# 0 $ **FLOATING
C878 m1_65710_21750# a_21487_106400# 0 $ **FLOATING
C879 m1_66870_21902# a_21487_106400# 0 $ **FLOATING
C880 m1_66714_21886# a_21487_106400# 0 $ **FLOATING
C881 m1_66246_21838# a_21487_106400# 0 $ **FLOATING
C882 m1_66090_21822# a_21487_106400# 0 $ **FLOATING
C883 m1_65710_21850# a_21487_106400# 0 $ **FLOATING
C884 m1_65466_21758# a_21487_106400# 0 $ **FLOATING
C885 m1_66870_22058# a_21487_106400# 0 $ **FLOATING
C886 m1_66714_22042# a_21487_106400# 0 $ **FLOATING
C887 m1_66090_21978# a_21487_106400# 0 $ **FLOATING
C888 m1_65710_21950# a_21487_106400# 0 $ **FLOATING
C889 m1_65466_21914# a_21487_106400# 0 $ **FLOATING
C890 m1_66870_22214# a_21487_106400# 0 $ **FLOATING
C891 m1_66714_22198# a_21487_106400# 0 $ **FLOATING
C892 m1_66870_22370# a_21487_106400# 0 $ **FLOATING
C893 m1_66714_22354# a_21487_106400# 0 $ **FLOATING
C894 m1_66376_22136# a_21487_106400# 1.31212e-16
C895 m1_66090_22134# a_21487_106400# 0 $ **FLOATING
C896 m1_65710_22050# a_21487_106400# 0 $ **FLOATING
C897 m1_65710_22150# a_21487_106400# 0 $ **FLOATING
C898 m1_65466_22070# a_21487_106400# 0 $ **FLOATING
C899 m1_66090_22290# a_21487_106400# 0 $ **FLOATING
C900 m1_65710_22250# a_21487_106400# 0 $ **FLOATING
C901 m1_65466_22226# a_21487_106400# 0 $ **FLOATING
C902 m1_65710_22350# a_21487_106400# 0 $ **FLOATING
C903 m1_66090_22446# a_21487_106400# 0 $ **FLOATING
C904 m1_65710_22450# a_21487_106400# 0 $ **FLOATING
C905 m1_65466_22382# a_21487_106400# 0 $ **FLOATING
C906 m1_22722_106400# a_21487_106400# 0 $ **FLOATING
C907 m1_22722_106450# a_21487_106400# 0 $ **FLOATING
C908 m1_22254_106402# a_21487_106400# 0 $ **FLOATING
C909 m1_22110_106400# a_21487_106400# 0 $ **FLOATING
C910 m1_22110_106470# a_21487_106400# 0 $ **FLOATING
C911 m1_21810_106430# a_21487_106400# 0 $ **FLOATING
C912 m1_21630_106400# a_21487_106400# 0 $ **FLOATING
C913 m1_21162_106400# a_21487_106400# 0 $ **FLOATING
C914 m1_22722_106606# a_21487_106400# 0 $ **FLOATING
C915 m1_22254_106558# a_21487_106400# 0 $ **FLOATING
C916 m1_22110_106570# a_21487_106400# 0 $ **FLOATING
C917 m1_21810_106530# a_21487_106400# 0 $ **FLOATING
C918 m1_21630_106494# a_21487_106400# 0 $ **FLOATING
C919 m1_21162_106446# a_21487_106400# 0 $ **FLOATING
C920 m1_21006_106430# a_21487_106400# 0 $ **FLOATING
C921 m1_20850_106414# a_21487_106400# 0 $ **FLOATING
C922 m1_22722_106762# a_21487_106400# 0 $ **FLOATING
C923 m1_22254_106714# a_21487_106400# 0 $ **FLOATING
C924 m1_22110_106670# a_21487_106400# 0 $ **FLOATING
C925 m1_21810_106630# a_21487_106400# 0 $ **FLOATING
C926 m1_22110_106770# a_21487_106400# 0 $ **FLOATING
C927 m1_21810_106730# a_21487_106400# 0 $ **FLOATING
C928 m1_21630_106650# a_21487_106400# 0 $ **FLOATING
C929 m1_21162_106602# a_21487_106400# 0 $ **FLOATING
C930 m1_21006_106586# a_21487_106400# 0 $ **FLOATING
C931 m1_20850_106570# a_21487_106400# 0 $ **FLOATING
C932 m1_20580_106420# a_21487_106400# 0 $ **FLOATING
C933 m1_20340_106400# a_21487_106400# 0 $ **FLOATING
C934 m1_22722_106918# a_21487_106400# 0 $ **FLOATING
C935 m1_22254_106870# a_21487_106400# 0 $ **FLOATING
C936 m1_22110_106870# a_21487_106400# 0 $ **FLOATING
C937 m1_21810_106830# a_21487_106400# 0 $ **FLOATING
C938 m1_21630_106806# a_21487_106400# 0 $ **FLOATING
C939 m1_21162_106758# a_21487_106400# 0 $ **FLOATING
C940 m1_21006_106742# a_21487_106400# 0 $ **FLOATING
C941 m1_20850_106726# a_21487_106400# 0 $ **FLOATING
C942 m1_20580_106660# a_21487_106400# 0 $ **FLOATING
C943 m1_20340_106560# a_21487_106400# 0 $ **FLOATING
C944 m1_20000_106400# a_21487_106400# 0 $ **FLOATING
C945 m1_20210_106650# a_21487_106400# 0 $ **FLOATING
C946 m1_20110_106670# a_21487_106400# 0 $ **FLOATING
C947 m1_22722_107074# a_21487_106400# 0 $ **FLOATING
C948 m1_22254_107026# a_21487_106400# 0 $ **FLOATING
C949 m1_22110_106970# a_21487_106400# 0 $ **FLOATING
C950 m1_21810_106930# a_21487_106400# 0 $ **FLOATING
C951 m1_22110_107070# a_21487_106400# 0 $ **FLOATING
C952 m1_21810_107030# a_21487_106400# 0 $ **FLOATING
C953 m1_21630_106962# a_21487_106400# 0 $ **FLOATING
C954 m1_21162_106914# a_21487_106400# 0 $ **FLOATING
C955 m1_21006_106898# a_21487_106400# 0 $ **FLOATING
C956 m1_20850_106882# a_21487_106400# 0 $ **FLOATING
C957 m1_22722_107230# a_21487_106400# 0 $ **FLOATING
C958 m1_22254_107182# a_21487_106400# 0 $ **FLOATING
C959 m1_22110_107170# a_21487_106400# 0 $ **FLOATING
C960 m1_21810_107130# a_21487_106400# 0 $ **FLOATING
C961 m1_22110_107270# a_21487_106400# 0 $ **FLOATING
C962 m1_21810_107230# a_21487_106400# 0 $ **FLOATING
C963 m1_21630_107118# a_21487_106400# 0 $ **FLOATING
C964 m1_21162_107070# a_21487_106400# 0 $ **FLOATING
C965 m1_21006_107054# a_21487_106400# 0 $ **FLOATING
C966 m1_20850_107038# a_21487_106400# 0 $ **FLOATING
C967 m1_20580_106900# a_21487_106400# 0 $ **FLOATING
C968 m1_20340_106800# a_21487_106400# 0 $ **FLOATING
C969 m1_22722_107386# a_21487_106400# 0 $ **FLOATING
C970 m1_22254_107338# a_21487_106400# 0 $ **FLOATING
C971 m1_22110_107370# a_21487_106400# 0 $ **FLOATING
C972 m1_21810_107330# a_21487_106400# 0 $ **FLOATING
C973 m1_21630_107274# a_21487_106400# 0 $ **FLOATING
C974 m1_21162_107226# a_21487_106400# 0 $ **FLOATING
C975 m1_21006_107210# a_21487_106400# 0 $ **FLOATING
C976 m1_20850_107194# a_21487_106400# 0 $ **FLOATING
C977 m1_20580_107140# a_21487_106400# 0 $ **FLOATING
C978 m1_20340_107040# a_21487_106400# 0 $ **FLOATING
C979 m1_20000_106770# a_21487_106400# 0 $ **FLOATING
C980 m1_22722_107542# a_21487_106400# 0 $ **FLOATING
C981 m1_22254_107494# a_21487_106400# 0 $ **FLOATING
C982 m1_22110_107470# a_21487_106400# 0 $ **FLOATING
C983 m1_21810_107430# a_21487_106400# 0 $ **FLOATING
C984 m1_22110_107570# a_21487_106400# 0 $ **FLOATING
C985 m1_21810_107530# a_21487_106400# 0 $ **FLOATING
C986 m1_21630_107430# a_21487_106400# 0 $ **FLOATING
C987 m1_21162_107382# a_21487_106400# 0 $ **FLOATING
C988 m1_21006_107366# a_21487_106400# 0 $ **FLOATING
C989 m1_20850_107350# a_21487_106400# 0 $ **FLOATING
C990 m1_22722_107698# a_21487_106400# 0 $ **FLOATING
C991 m1_22254_107650# a_21487_106400# 0 $ **FLOATING
C992 m1_22110_107670# a_21487_106400# 0 $ **FLOATING
C993 m1_21810_107630# a_21487_106400# 0 $ **FLOATING
C994 m1_21630_107586# a_21487_106400# 0 $ **FLOATING
C995 m1_21162_107538# a_21487_106400# 0 $ **FLOATING
C996 m1_21006_107522# a_21487_106400# 0 $ **FLOATING
C997 m1_20850_107506# a_21487_106400# 0 $ **FLOATING
C998 m1_20580_107380# a_21487_106400# 0 $ **FLOATING
C999 m1_20340_107280# a_21487_106400# 0 $ **FLOATING
C1000 m1_22722_107854# a_21487_106400# 0 $ **FLOATING
C1001 m1_22254_107806# a_21487_106400# 0 $ **FLOATING
C1002 m1_22110_107770# a_21487_106400# 0 $ **FLOATING
C1003 m1_21810_107730# a_21487_106400# 0 $ **FLOATING
C1004 m1_22110_107870# a_21487_106400# 0 $ **FLOATING
C1005 m1_21810_107830# a_21487_106400# 0 $ **FLOATING
C1006 m1_21630_107742# a_21487_106400# 0 $ **FLOATING
C1007 m1_21162_107694# a_21487_106400# 0 $ **FLOATING
C1008 m1_21006_107678# a_21487_106400# 0 $ **FLOATING
C1009 m1_20850_107662# a_21487_106400# 0 $ **FLOATING
C1010 m1_22722_108010# a_21487_106400# 0 $ **FLOATING
C1011 m1_22254_107962# a_21487_106400# 0 $ **FLOATING
C1012 m1_22110_107970# a_21487_106400# 0 $ **FLOATING
C1013 m1_21810_107930# a_21487_106400# 0 $ **FLOATING
C1014 m1_21630_107898# a_21487_106400# 0 $ **FLOATING
C1015 m1_21162_107850# a_21487_106400# 0 $ **FLOATING
C1016 m1_21006_107834# a_21487_106400# 0 $ **FLOATING
C1017 m1_20850_107818# a_21487_106400# 0 $ **FLOATING
C1018 m1_20580_107620# a_21487_106400# 0 $ **FLOATING
C1019 m1_20340_107520# a_21487_106400# 0 $ **FLOATING
C1020 m1_20000_107330# a_21487_106400# 0 $ **FLOATING
C1021 m1_22722_108166# a_21487_106400# 0 $ **FLOATING
C1022 m1_22254_108118# a_21487_106400# 0 $ **FLOATING
C1023 m1_22110_108070# a_21487_106400# 0 $ **FLOATING
C1024 m1_21810_108030# a_21487_106400# 0 $ **FLOATING
C1025 m1_22110_108170# a_21487_106400# 0 $ **FLOATING
C1026 m1_21810_108130# a_21487_106400# 0 $ **FLOATING
C1027 m1_21630_108054# a_21487_106400# 0 $ **FLOATING
C1028 m1_21162_108006# a_21487_106400# 0 $ **FLOATING
C1029 m1_21006_107990# a_21487_106400# 0 $ **FLOATING
C1030 m1_20850_107974# a_21487_106400# 0 $ **FLOATING
C1031 m1_20580_107860# a_21487_106400# 0 $ **FLOATING
C1032 m1_20340_107760# a_21487_106400# 0 $ **FLOATING
C1033 m1_20110_107770# a_21487_106400# 0 $ **FLOATING
C1034 m1_20010_107790# a_21487_106400# 0 $ **FLOATING
C1035 m1_22722_108322# a_21487_106400# 0 $ **FLOATING
C1036 m1_22254_108274# a_21487_106400# 0 $ **FLOATING
C1037 m1_22110_108270# a_21487_106400# 0 $ **FLOATING
C1038 m1_21810_108230# a_21487_106400# 0 $ **FLOATING
C1039 m1_21630_108210# a_21487_106400# 0 $ **FLOATING
C1040 m1_21162_108162# a_21487_106400# 0 $ **FLOATING
C1041 m1_21006_108146# a_21487_106400# 0 $ **FLOATING
C1042 m1_20850_108130# a_21487_106400# 0 $ **FLOATING
C1043 m1_22110_108370# a_21487_106400# 0 $ **FLOATING
C1044 m1_21810_108330# a_21487_106400# 0 $ **FLOATING
C1045 m1_22722_108478# a_21487_106400# 0 $ **FLOATING
C1046 m1_22254_108430# a_21487_106400# 0 $ **FLOATING
C1047 m1_22110_108470# a_21487_106400# 0 $ **FLOATING
C1048 m1_21810_108430# a_21487_106400# 0 $ **FLOATING
C1049 m1_21630_108366# a_21487_106400# 0 $ **FLOATING
C1050 m1_21162_108318# a_21487_106400# 0 $ **FLOATING
C1051 m1_21006_108302# a_21487_106400# 0 $ **FLOATING
C1052 m1_20850_108286# a_21487_106400# 0 $ **FLOATING
C1053 m1_20580_108100# a_21487_106400# 0 $ **FLOATING
C1054 m1_20340_108000# a_21487_106400# 0 $ **FLOATING
C1055 m1_22722_108634# a_21487_106400# 0 $ **FLOATING
C1056 m1_22254_108586# a_21487_106400# 0 $ **FLOATING
C1057 m1_22110_108570# a_21487_106400# 0 $ **FLOATING
C1058 m1_21810_108530# a_21487_106400# 0 $ **FLOATING
C1059 m1_22110_108670# a_21487_106400# 0 $ **FLOATING
C1060 m1_21810_108630# a_21487_106400# 0 $ **FLOATING
C1061 m1_21630_108522# a_21487_106400# 0 $ **FLOATING
C1062 m1_21162_108474# a_21487_106400# 0 $ **FLOATING
C1063 m1_21006_108458# a_21487_106400# 0 $ **FLOATING
C1064 m1_20850_108442# a_21487_106400# 0 $ **FLOATING
C1065 m1_20580_108340# a_21487_106400# 0 $ **FLOATING
C1066 m1_20340_108240# a_21487_106400# 0 $ **FLOATING
C1067 m1_20000_107890# a_21487_106400# 0 $ **FLOATING
C1068 m1_20210_108350# a_21487_106400# 0 $ **FLOATING
C1069 m1_22722_108790# a_21487_106400# 0 $ **FLOATING
C1070 m1_22254_108742# a_21487_106400# 0 $ **FLOATING
C1071 m1_22110_108770# a_21487_106400# 0 $ **FLOATING
C1072 m1_21810_108730# a_21487_106400# 0 $ **FLOATING
C1073 m1_21630_108678# a_21487_106400# 0 $ **FLOATING
C1074 m1_21162_108630# a_21487_106400# 0 $ **FLOATING
C1075 m1_21006_108614# a_21487_106400# 0 $ **FLOATING
C1076 m1_20850_108598# a_21487_106400# 0 $ **FLOATING
C1077 m1_22722_108946# a_21487_106400# 0 $ **FLOATING
C1078 m1_22254_108898# a_21487_106400# 0 $ **FLOATING
C1079 m1_22110_108870# a_21487_106400# 0 $ **FLOATING
C1080 m1_21810_108830# a_21487_106400# 0 $ **FLOATING
C1081 m1_22110_108970# a_21487_106400# 0 $ **FLOATING
C1082 m1_21810_108930# a_21487_106400# 0 $ **FLOATING
C1083 m1_21630_108834# a_21487_106400# 0 $ **FLOATING
C1084 m1_21162_108786# a_21487_106400# 0 $ **FLOATING
C1085 m1_21006_108770# a_21487_106400# 0 $ **FLOATING
C1086 m1_20850_108754# a_21487_106400# 0 $ **FLOATING
C1087 m1_20580_108580# a_21487_106400# 0 $ **FLOATING
C1088 m1_20340_108480# a_21487_106400# 0 $ **FLOATING
C1089 m1_22722_109102# a_21487_106400# 0 $ **FLOATING
C1090 m1_22254_109054# a_21487_106400# 0 $ **FLOATING
C1091 m1_22110_109070# a_21487_106400# 0 $ **FLOATING
C1092 m1_21810_109030# a_21487_106400# 0 $ **FLOATING
C1093 m1_21630_108990# a_21487_106400# 0 $ **FLOATING
C1094 m1_21162_108942# a_21487_106400# 0 $ **FLOATING
C1095 m1_21006_108926# a_21487_106400# 0 $ **FLOATING
C1096 m1_20850_108910# a_21487_106400# 0 $ **FLOATING
C1097 m1_20580_108820# a_21487_106400# 0 $ **FLOATING
C1098 m1_20340_108720# a_21487_106400# 0 $ **FLOATING
C1099 m1_20000_108450# a_21487_106400# 0 $ **FLOATING
C1100 m1_20010_108890# a_21487_106400# 0 $ **FLOATING
C1101 m1_22722_109258# a_21487_106400# 0 $ **FLOATING
C1102 m1_22254_109210# a_21487_106400# 0 $ **FLOATING
C1103 m1_22110_109170# a_21487_106400# 0 $ **FLOATING
C1104 m1_21810_109130# a_21487_106400# 0 $ **FLOATING
C1105 m1_22110_109270# a_21487_106400# 0 $ **FLOATING
C1106 m1_21810_109230# a_21487_106400# 0 $ **FLOATING
C1107 m1_21630_109146# a_21487_106400# 0 $ **FLOATING
C1108 m1_21162_109098# a_21487_106400# 0 $ **FLOATING
C1109 m1_21006_109082# a_21487_106400# 0 $ **FLOATING
C1110 m1_20850_109066# a_21487_106400# 0 $ **FLOATING
C1111 m1_22722_109414# a_21487_106400# 0 $ **FLOATING
C1112 m1_22254_109366# a_21487_106400# 0 $ **FLOATING
C1113 m1_22110_109370# a_21487_106400# 0 $ **FLOATING
C1114 m1_21810_109330# a_21487_106400# 0 $ **FLOATING
C1115 m1_21630_109302# a_21487_106400# 0 $ **FLOATING
C1116 m1_21162_109254# a_21487_106400# 0 $ **FLOATING
C1117 m1_21006_109238# a_21487_106400# 0 $ **FLOATING
C1118 m1_20850_109222# a_21487_106400# 0 $ **FLOATING
C1119 m1_20580_109060# a_21487_106400# 0 $ **FLOATING
C1120 m1_20340_108960# a_21487_106400# 0 $ **FLOATING
C1121 m1_22722_109570# a_21487_106400# 0 $ **FLOATING
C1122 m1_22254_109522# a_21487_106400# 0 $ **FLOATING
C1123 m1_22110_109470# a_21487_106400# 0 $ **FLOATING
C1124 m1_21810_109430# a_21487_106400# 0 $ **FLOATING
C1125 m1_22110_109570# a_21487_106400# 0 $ **FLOATING
C1126 m1_21810_109530# a_21487_106400# 0 $ **FLOATING
C1127 m1_21630_109458# a_21487_106400# 0 $ **FLOATING
C1128 m1_21162_109410# a_21487_106400# 0 $ **FLOATING
C1129 m1_21006_109394# a_21487_106400# 0 $ **FLOATING
C1130 m1_20850_109378# a_21487_106400# 0 $ **FLOATING
C1131 m1_20580_109300# a_21487_106400# 0 $ **FLOATING
C1132 m1_20340_109200# a_21487_106400# 0 $ **FLOATING
C1133 m1_20000_109010# a_21487_106400# 0 $ **FLOATING
C1134 m1_22254_109678# a_21487_106400# 0 $ **FLOATING
C1135 m1_22110_109670# a_21487_106400# 0 $ **FLOATING
C1136 m1_21810_109630# a_21487_106400# 0 $ **FLOATING
C1137 m1_21630_109614# a_21487_106400# 0 $ **FLOATING
C1138 m1_21162_109566# a_21487_106400# 0 $ **FLOATING
C1139 m1_21006_109550# a_21487_106400# 0 $ **FLOATING
C1140 m1_20850_109534# a_21487_106400# 0 $ **FLOATING
C1141 m1_20850_109690# a_21487_106400# 0 $ **FLOATING
C1142 m1_20580_109540# a_21487_106400# 0 $ **FLOATING
C1143 m1_20340_109440# a_21487_106400# 0 $ **FLOATING
C1144 m1_20210_109450# a_21487_106400# 0 $ **FLOATING
C1145 m1_20110_109470# a_21487_106400# 0 $ **FLOATING
C1146 m1_20340_109680# a_21487_106400# 0 $ **FLOATING
C1147 m1_20000_109570# a_21487_106400# 0 $ **FLOATING
C1148 li_66940_20000# a_21487_106400# 0 $ **FLOATING
C1149 li_66160_20000# a_21487_106400# 0 $ **FLOATING
C1150 li_65650_20000# a_21487_106400# 0 $ **FLOATING
C1151 li_67506_20298# a_21487_106400# 0 $ **FLOATING
C1152 li_67506_20514# a_21487_106400# 0 $ **FLOATING
C1153 li_67290_20438# a_21487_106400# 0 $ **FLOATING
C1154 li_67074_20362# a_21487_106400# 0 $ **FLOATING
C1155 li_67506_20730# a_21487_106400# 0 $ **FLOATING
C1156 li_67290_20654# a_21487_106400# 0 $ **FLOATING
C1157 li_67074_20578# a_21487_106400# 0 $ **FLOATING
C1158 li_66858_20502# a_21487_106400# 0 $ **FLOATING
C1159 li_66642_20426# a_21487_106400# 0 $ **FLOATING
C1160 li_67074_20794# a_21487_106400# 0 $ **FLOATING
C1161 li_66858_20718# a_21487_106400# 0 $ **FLOATING
C1162 li_66642_20642# a_21487_106400# 0 $ **FLOATING
C1163 li_66426_20566# a_21487_106400# 0 $ **FLOATING
C1164 li_66210_20490# a_21487_106400# 0 $ **FLOATING
C1165 li_65994_20414# a_21487_106400# 0 $ **FLOATING
C1166 li_65778_20338# a_21487_106400# 0 $ **FLOATING
C1167 li_65250_20070# a_21487_106400# 0 $ **FLOATING
C1168 li_66426_20782# a_21487_106400# 0 $ **FLOATING
C1169 li_66210_20706# a_21487_106400# 0 $ **FLOATING
C1170 li_65994_20630# a_21487_106400# 0 $ **FLOATING
C1171 li_65778_20554# a_21487_106400# 0 $ **FLOATING
C1172 li_65562_20478# a_21487_106400# 0 $ **FLOATING
C1173 li_65778_20770# a_21487_106400# 0 $ **FLOATING
C1174 li_65562_20694# a_21487_106400# 0 $ **FLOATING
C1175 li_65346_20618# a_21487_106400# 0 $ **FLOATING
C1176 li_65130_20542# a_21487_106400# 0 $ **FLOATING
C1177 li_65130_20758# a_21487_106400# 0 $ **FLOATING
C1178 li_67506_21594# a_21487_106400# 0 $ **FLOATING
C1179 li_66858_21582# a_21487_106400# 0 $ **FLOATING
C1180 li_67506_21810# a_21487_106400# 0 $ **FLOATING
C1181 li_66210_21570# a_21487_106400# 0 $ **FLOATING
C1182 li_66858_21798# a_21487_106400# 0 $ **FLOATING
C1183 li_65562_21558# a_21487_106400# 0 $ **FLOATING
C1184 li_65346_21482# a_21487_106400# 0 $ **FLOATING
C1185 li_66210_21786# a_21487_106400# 0 $ **FLOATING
C1186 li_67506_22026# a_21487_106400# 0 $ **FLOATING
C1187 li_65562_21774# a_21487_106400# 0 $ **FLOATING
C1188 li_65346_21698# a_21487_106400# 0 $ **FLOATING
C1189 li_66858_22014# a_21487_106400# 0 $ **FLOATING
C1190 li_66210_22002# a_21487_106400# 0 $ **FLOATING
C1191 li_67506_22242# a_21487_106400# 0 $ **FLOATING
C1192 li_66858_22230# a_21487_106400# 0 $ **FLOATING
C1193 li_65562_21990# a_21487_106400# 0 $ **FLOATING
C1194 li_65346_21914# a_21487_106400# 0 $ **FLOATING
C1195 li_67506_22458# a_21487_106400# 0 $ **FLOATING
C1196 li_66210_22218# a_21487_106400# 0 $ **FLOATING
C1197 li_65562_22206# a_21487_106400# 0 $ **FLOATING
C1198 li_65346_22130# a_21487_106400# 0 $ **FLOATING
C1199 li_66858_22446# a_21487_106400# 0 $ **FLOATING
C1200 li_66210_22434# a_21487_106400# 0 $ **FLOATING
C1201 li_65562_22422# a_21487_106400# 0 $ **FLOATING
C1202 li_65346_22346# a_21487_106400# 0 $ **FLOATING
C1203 li_21066_106400# a_21487_106400# 0 $ **FLOATING
C1204 li_21066_106558# a_21487_106400# 0 $ **FLOATING
C1205 li_20850_106482# a_21487_106400# 0 $ **FLOATING
C1206 li_20140_106400# a_21487_106400# 0 $ **FLOATING
C1207 li_21066_106774# a_21487_106400# 0 $ **FLOATING
C1208 li_20850_106698# a_21487_106400# 0 $ **FLOATING
C1209 li_21066_106990# a_21487_106400# 0 $ **FLOATING
C1210 li_20850_106914# a_21487_106400# 0 $ **FLOATING
C1211 li_21066_107206# a_21487_106400# 0 $ **FLOATING
C1212 li_20850_107130# a_21487_106400# 0 $ **FLOATING
C1213 li_20140_106730# a_21487_106400# 0 $ **FLOATING
C1214 li_21066_107422# a_21487_106400# 0 $ **FLOATING
C1215 li_20850_107346# a_21487_106400# 0 $ **FLOATING
C1216 li_21066_107638# a_21487_106400# 0 $ **FLOATING
C1217 li_20850_107562# a_21487_106400# 0 $ **FLOATING
C1218 li_21066_107854# a_21487_106400# 0 $ **FLOATING
C1219 li_20850_107778# a_21487_106400# 0 $ **FLOATING
C1220 li_21066_108070# a_21487_106400# 0 $ **FLOATING
C1221 li_20850_107994# a_21487_106400# 0 $ **FLOATING
C1222 li_20140_107510# a_21487_106400# 0 $ **FLOATING
C1223 li_21066_108286# a_21487_106400# 0 $ **FLOATING
C1224 li_20850_108210# a_21487_106400# 0 $ **FLOATING
C1225 li_21066_108502# a_21487_106400# 0 $ **FLOATING
C1226 li_20850_108426# a_21487_106400# 0 $ **FLOATING
C1227 li_21066_108718# a_21487_106400# 0 $ **FLOATING
C1228 li_20850_108642# a_21487_106400# 0 $ **FLOATING
C1229 li_21066_108934# a_21487_106400# 0 $ **FLOATING
C1230 li_20850_108858# a_21487_106400# 0 $ **FLOATING
C1231 li_20140_108290# a_21487_106400# 0 $ **FLOATING
C1232 li_21066_109150# a_21487_106400# 0 $ **FLOATING
C1233 li_20850_109074# a_21487_106400# 0 $ **FLOATING
C1234 li_21066_109366# a_21487_106400# 0 $ **FLOATING
C1235 li_20850_109290# a_21487_106400# 0 $ **FLOATING
C1236 li_21066_109582# a_21487_106400# 0 $ **FLOATING
C1237 li_20850_109506# a_21487_106400# 0 $ **FLOATING
C1238 li_20140_109070# a_21487_106400# 0 $ **FLOATING
C1239 a_67560_20000# a_21487_106400# 0 $ **FLOATING
C1240 a_67276_20024# a_21487_106400# 0 $ **FLOATING
C1241 a_66844_20000# a_21487_106400# 0 $ **FLOATING
C1242 a_67060_20072# a_21487_106400# 0 $ **FLOATING
C1243 a_66628_20000# a_21487_106400# 0 $ **FLOATING
C1244 a_67276_20240# a_21487_106400# 0 $ **FLOATING
C1245 a_66844_20120# a_21487_106400# 0 $ **FLOATING
C1246 a_66412_20000# a_21487_106400# 0 $ **FLOATING
C1247 a_67060_20288# a_21487_106400# 0 $ **FLOATING
C1248 a_66628_20168# a_21487_106400# 0 $ **FLOATING
C1249 a_66196_20048# a_21487_106400# 0 $ **FLOATING
C1250 a_65288_20000# a_21487_106400# 0 $ **FLOATING
C1251 a_65100_20000# a_21487_106400# 0 $ **FLOATING
C1252 a_67276_20456# a_21487_106400# 0 $ **FLOATING
C1253 a_66844_20336# a_21487_106400# 0 $ **FLOATING
C1254 a_66412_20216# a_21487_106400# 0 $ **FLOATING
C1255 a_67060_20504# a_21487_106400# 0 $ **FLOATING
C1256 a_66628_20384# a_21487_106400# 0 $ **FLOATING
C1257 a_66196_20264# a_21487_106400# 0 $ **FLOATING
C1258 a_65764_20144# a_21487_106400# 0 $ **FLOATING
C1259 a_67276_20672# a_21487_106400# 0 $ **FLOATING
C1260 a_66844_20552# a_21487_106400# 0 $ **FLOATING
C1261 a_66412_20432# a_21487_106400# 0 $ **FLOATING
C1262 a_65980_20312# a_21487_106400# 0 $ **FLOATING
C1263 a_65548_20192# a_21487_106400# 0 $ **FLOATING
C1264 a_65100_20098# a_21487_106400# 0 $ **FLOATING
C1265 a_66628_20600# a_21487_106400# 0 $ **FLOATING
C1266 a_66196_20480# a_21487_106400# 0 $ **FLOATING
C1267 a_65764_20360# a_21487_106400# 0 $ **FLOATING
C1268 a_65332_20240# a_21487_106400# 0 $ **FLOATING
C1269 a_66412_20648# a_21487_106400# 0 $ **FLOATING
C1270 a_65980_20528# a_21487_106400# 0 $ **FLOATING
C1271 a_65548_20408# a_21487_106400# 0 $ **FLOATING
C1272 a_65116_20288# a_21487_106400# 0 $ **FLOATING
C1273 a_66196_20696# a_21487_106400# 0 $ **FLOATING
C1274 a_65764_20576# a_21487_106400# 0 $ **FLOATING
C1275 a_65332_20456# a_21487_106400# 0 $ **FLOATING
C1276 a_65548_20624# a_21487_106400# 0 $ **FLOATING
C1277 a_65116_20504# a_21487_106400# 0 $ **FLOATING
C1278 a_65332_20672# a_21487_106400# 0 $ **FLOATING
C1279 a_67263_21111# a_21487_106400# 2.6014299999999998e-16 $ **FLOATING
C1280 a_65100_21098# a_21487_106400# 3.4029800000000001e-18 $ **FLOATING
C1281 a_65931_21111# a_21487_106400# 1.0774900000000001e-15 $ **FLOATING
C1282 a_65100_21043# a_21487_106400# 1.3333199999999999e-15 $ **FLOATING
C1283 a_65266_21098# a_21487_106400# 3.6434400000000007e-15 $ **FLOATING
C1284 a_23093_106400# a_21487_106400# 2.3011199999999999e-16 $ **FLOATING
C1285 a_23093_107267# a_21487_106400# 9.5162400000000014e-17 $ **FLOATING
C1286 a_21052_106400# a_21487_106400# 0 $ **FLOATING
C1287 a_20836_106400# a_21487_106400# 0 $ **FLOATING
C1288 a_23093_108003# a_21487_106400# 3.0544800000000003e-16 $ **FLOATING
C1289 a_21052_106544# a_21487_106400# 0 $ **FLOATING
C1290 a_20836_106592# a_21487_106400# 0 $ **FLOATING
C1291 a_21052_106760# a_21487_106400# 0 $ **FLOATING
C1292 a_20836_106808# a_21487_106400# 0 $ **FLOATING
C1293 a_21052_106976# a_21487_106400# 0 $ **FLOATING
C1294 a_20836_107024# a_21487_106400# 0 $ **FLOATING
C1295 a_20000_106400# a_21487_106400# 0 $ **FLOATING
C1296 a_21052_107192# a_21487_106400# 0 $ **FLOATING
C1297 a_20836_107240# a_21487_106400# 0 $ **FLOATING
C1298 a_20636_107194# a_21487_106400# 0 $ **FLOATING
C1299 a_20404_107120# a_21487_106400# 0 $ **FLOATING
C1300 a_20188_107168# a_21487_106400# 0 $ **FLOATING
C1301 a_20000_107206# a_21487_106400# 0 $ **FLOATING
C1302 a_21052_107408# a_21487_106400# 0 $ **FLOATING
C1303 a_20836_107456# a_21487_106400# 0 $ **FLOATING
C1304 a_21052_107624# a_21487_106400# 0 $ **FLOATING
C1305 a_20836_107672# a_21487_106400# 0 $ **FLOATING
C1306 a_21052_107840# a_21487_106400# 0 $ **FLOATING
C1307 a_23093_109107# a_21487_106400# 2.2618000000000006e-16 $ **FLOATING
C1308 a_20836_107888# a_21487_106400# 0 $ **FLOATING
C1309 a_21052_108056# a_21487_106400# 0 $ **FLOATING
C1310 a_20836_108104# a_21487_106400# 0 $ **FLOATING
C1311 a_20000_107376# a_21487_106400# 0 $ **FLOATING
C1312 a_21052_108272# a_21487_106400# 0 $ **FLOATING
C1313 a_20836_108320# a_21487_106400# 0 $ **FLOATING
C1314 a_20636_108274# a_21487_106400# 0 $ **FLOATING
C1315 a_20456_108322# a_21487_106400# 0 $ **FLOATING
C1316 a_20000_108296# a_21487_106400# 0 $ **FLOATING
C1317 a_21052_108488# a_21487_106400# 0 $ **FLOATING
C1318 a_20836_108536# a_21487_106400# 0 $ **FLOATING
C1319 a_21052_108704# a_21487_106400# 0 $ **FLOATING
C1320 a_20836_108752# a_21487_106400# 0 $ **FLOATING
C1321 a_21052_108920# a_21487_106400# 0 $ **FLOATING
C1322 a_20836_108968# a_21487_106400# 0 $ **FLOATING
C1323 a_21052_109136# a_21487_106400# 0 $ **FLOATING
C1324 a_20836_109184# a_21487_106400# 0 $ **FLOATING
C1325 a_20000_108512# a_21487_106400# 0 $ **FLOATING
C1326 a_21052_109352# a_21487_106400# 0 $ **FLOATING
C1327 a_20836_109400# a_21487_106400# 0 $ **FLOATING
C1328 a_20456_109402# a_21487_106400# 0 $ **FLOATING
C1329 a_20276_109450# a_21487_106400# 0 $ **FLOATING
C1330 a_20100_109452# a_21487_106400# 0 $ **FLOATING
C1331 a_21052_109568# a_21487_106400# 0 $ **FLOATING
C1332 a_20836_109616# a_21487_106400# 0 $ **FLOATING
C1333 a_20000_109648# a_21487_106400# 0 $ **FLOATING
C1334 w_67548_20978# a_21487_106400# 2.3743199999999998e-16
C1335 w_66216_20978# a_21487_106400# 3.0500900000000002e-15 $ **FLOATING
C1336 w_65064_21062# a_21487_106400# 2.0932100000000003e-15 $ **FLOATING
C1337 w_22789_106400# a_21487_106400# 1.3847000000000001e-14 $ **FLOATING
C1338 w_21701_106400# a_21487_106400# 2.1809099999999999e-14 $ **FLOATING
C1339 a_21487_106400# a_21487_106400# 0 $ **FLOATING
.ends
