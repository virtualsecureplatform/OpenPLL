* NGSPICE file created from RotatedCrop.ext - technology: sky130A

.subckt RotatedCrop
X0 a_108345_66276# a_108332_65715# a_108345_66276# w_107200_66216# sky130_fd_pr__pfet_01v8 ad=0.285 pd=2.57 as=0 ps=0 w=1 l=1
X1 a_20000_21737# w_19964_21727# a_20000_21737# a_20000_21737# sky130_fd_pr__nfet_01v8 ad=0.143 pd=1.62 as=0 ps=0 w=0.55 l=2.69
X2 w_19964_21727# a_20000_21737# w_19964_21727# w_19964_21727# sky130_fd_pr__pfet_01v8_hvt ad=0.2262 pd=2.26 as=0 ps=0 w=0.87 l=4.73
X3 w_19964_23083# a_22039_23093# w_19964_23083# w_19964_23083# sky130_fd_pr__pfet_01v8_hvt ad=0.1053 pd=1.33 as=0 ps=0 w=0.405 l=1.97
X4 a_20000_21737# w_19964_21727# a_20000_21737# a_20000_21737# sky130_fd_pr__nfet_01v8 ad=0.143 pd=1.62 as=0 ps=0 w=0.55 l=1.97
X5 w_19964_21727# a_20000_21737# w_19964_21727# w_19964_21727# sky130_fd_pr__pfet_01v8_hvt ad=0.2262 pd=2.26 as=0 ps=0 w=0.87 l=1.97
X6 a_20000_21737# w_19964_21727# a_20000_21737# a_20000_21737# sky130_fd_pr__nfet_01v8 ad=0.143 pd=1.62 as=0 ps=0 w=0.55 l=0.59
X7 w_19964_21727# a_20000_21737# w_19964_21727# w_19964_21727# sky130_fd_pr__pfet_01v8_hvt ad=0.2262 pd=2.26 as=0 ps=0 w=0.87 l=2.53
X8 a_20000_21737# w_19964_23083# a_20000_21737# a_20000_21737# sky130_fd_pr__nfet_01v8 ad=0.143 pd=1.62 as=0 ps=0 w=0.55 l=4.73
X9 a_108332_65715# a_108345_66276# a_108332_65715# a_20000_21737# sky130_fd_pr__nfet_01v8_lvt ad=0.1197 pd=1.41 as=0 ps=0 w=0.42 l=1
X10 a_108345_66276# a_108332_65715# a_108345_66276# w_107200_66216# sky130_fd_pr__pfet_01v8 ad=0.285 pd=2.57 as=0 ps=0 w=1 l=1
X11 w_19964_21727# a_20000_21737# w_19964_21727# w_19964_21727# sky130_fd_pr__pfet_01v8_hvt ad=0.2262 pd=2.26 as=0 ps=0 w=0.87 l=0.59
X12 a_108345_65100# a_108332_65715# a_108345_65100# w_107200_65100# sky130_fd_pr__pfet_01v8 ad=0.285 pd=2.57 as=0 ps=0 w=1 l=1
X13 w_19964_23083# a_20751_23093# w_19964_23083# w_19964_23083# sky130_fd_pr__pfet_01v8_hvt ad=0.1053 pd=1.33 as=0 ps=0 w=0.405 l=4.73
X14 a_20000_21737# w_19964_21727# a_20000_21737# a_20000_21737# sky130_fd_pr__nfet_01v8 ad=0.143 pd=1.62 as=0 ps=0 w=0.55 l=4.73
X15 a_20000_21737# w_19964_21727# a_20000_21737# a_20000_21737# sky130_fd_pr__nfet_01v8 ad=0.143 pd=1.62 as=0 ps=0 w=0.55 l=4.73
X16 a_108332_65715# a_108345_65100# a_108332_65715# a_20000_21737# sky130_fd_pr__nfet_01v8_lvt ad=0.1197 pd=1.41 as=0 ps=0 w=0.42 l=1
X17 w_19964_23083# a_20000_21737# w_19964_23083# w_19964_23083# sky130_fd_pr__pfet_01v8_hvt ad=0.2262 pd=2.26 as=0 ps=0 w=0.87 l=4.73
X18 w_19964_21727# a_20000_21737# w_19964_21727# w_19964_21727# sky130_fd_pr__pfet_01v8_hvt ad=0.2262 pd=2.26 as=0 ps=0 w=0.87 l=4.73
X19 a_108332_65715# a_108389_67263# a_108332_65715# a_20000_21737# sky130_fd_pr__nfet_01v8_lvt ad=0.1197 pd=1.41 as=0 ps=0 w=0.42 l=1
X20 w_19964_23083# a_20000_23093# w_19964_23083# w_19964_23083# sky130_fd_pr__pfet_01v8_hvt ad=0.1053 pd=1.33 as=0 ps=0 w=0.405 l=1.28
X21 w_19964_23083# a_22591_23093# w_19964_23083# w_19964_23083# sky130_fd_pr__pfet_01v8_hvt ad=0.1053 pd=1.33 as=0 ps=0 w=0.405 l=1.57
X22 a_20000_21737# w_19964_23083# a_20000_21737# a_20000_21737# sky130_fd_pr__nfet_01v8 ad=0.04125 pd=1.25 as=0 ps=0 w=0.55 l=4.73
X23 a_20000_21737# w_19964_21727# a_20000_21737# a_20000_21737# sky130_fd_pr__nfet_01v8 ad=0.143 pd=1.62 as=0 ps=0 w=0.55 l=2.69
X24 a_20000_21737# w_19964_21727# a_20000_21737# a_20000_21737# sky130_fd_pr__nfet_01v8 ad=0.143 pd=1.62 as=0 ps=0 w=0.55 l=3.27
X25 w_19964_21727# a_20000_21737# w_19964_21727# w_19964_21727# sky130_fd_pr__pfet_01v8_hvt ad=0.2262 pd=2.26 as=0 ps=0 w=0.87 l=2.53
X26 w_19964_21727# a_20000_21737# w_19964_21727# w_19964_21727# sky130_fd_pr__pfet_01v8_hvt ad=0.2262 pd=2.26 as=0 ps=0 w=0.87 l=3.11
X27 w_19964_21727# a_20000_21737# w_19964_21727# w_19964_21727# sky130_fd_pr__pfet_01v8_hvt ad=0.2262 pd=2.26 as=0 ps=0 w=0.87 l=4.73
X28 a_108332_65715# a_108345_66276# a_108332_65715# a_20000_21737# sky130_fd_pr__nfet_01v8_lvt ad=0.1197 pd=1.41 as=0 ps=0 w=0.42 l=1
X29 a_20000_21737# w_19964_23083# a_20000_21737# a_20000_21737# sky130_fd_pr__nfet_01v8 ad=0.143 pd=1.62 as=0 ps=0 w=0.55 l=4.73
X30 a_108345_65100# a_108402_65100# a_108345_65100# w_107200_65100# sky130_fd_pr__pfet_01v8 ad=0.0627 pd=1.01 as=0 ps=0 w=0.22 l=1
X31 w_19964_23083# a_20000_21737# w_19964_23083# w_19964_23083# sky130_fd_pr__pfet_01v8_hvt ad=0.06525 pd=1.89 as=0 ps=0 w=0.87 l=4.73
X32 w_19964_23083# a_20000_21737# w_19964_23083# w_19964_23083# sky130_fd_pr__pfet_01v8_hvt ad=0.2262 pd=2.26 as=0 ps=0 w=0.87 l=4.73
X33 a_20000_21737# w_19964_21727# a_20000_21737# a_20000_21737# sky130_fd_pr__nfet_01v8 ad=0.143 pd=1.62 as=0 ps=0 w=0.55 l=4.73
C0 m3_107200_66002# m2_107326_65100# 5.1122700000000006e-17
C1 m1_107200_67350# m4_107214_65100# 9.9906400000000019e-19
C2 a_22039_23093# a_22591_23093# 2.6329100000000002e-18
C3 m4_107214_65100# m4_107598_65100# 1.9293600000000002e-16
C4 m2_108190_65100# w_107200_66216# 3.0487600000000004e-17
C5 m4_107982_65100# w_107200_67548# 2.5581000000000003e-18
C6 a_108332_65715# m2_107326_65100# 1.4475200000000002e-16
C7 m1_107200_66388# m1_107200_67350# 2.3896500000000002e-17
C8 m3_107200_66002# m4_107214_65100# 6.5634300000000008e-16
C9 a_108345_66276# w_107200_66216# 7.2327600000000002e-16
C10 a_108402_65100# a_108345_65100# 5.9348399999999998e-17
C11 m5_107200_66336# w_107200_66216# 2.0536599999999999e-17
C12 m1_107200_66388# m4_107598_65100# 1.4423900000000002e-17
C13 w_107200_65100# m4_107598_65100# 6.5861000000000007e-18
C14 w_107200_66216# m2_107998_65100# 4.7392200000000009e-17
C15 a_108332_65715# m4_107214_65100# 1.4939600000000003e-17
C16 m1_107200_66388# m3_107200_66002# 1.9391000000000001e-17
C17 w_107200_65100# m3_107200_66002# 4.9466100000000001e-18
C18 m1_107200_67350# w_107200_67548# 1.4063000000000002e-18
C19 m4_107214_65100# m2_107326_65100# 2.5023100000000001e-17
C20 w_107200_67548# m4_107598_65100# 1.08472e-18
C21 m1_107200_66388# a_108332_65715# 1.08716e-16
C22 w_107200_65100# a_108332_65715# 2.0189100000000001e-16
C23 m3_107200_66002# w_107200_67548# 8.4649000000000005e-19
C24 m1_107200_66388# m2_107326_65100# 3.00859e-16
C25 w_107200_65100# m2_107326_65100# 3.1349100000000002e-17
C26 a_108402_65100# m2_108190_65100# 2.0855700000000003e-18
C27 a_108332_65715# w_107200_67548# 6.0162100000000004e-17
C28 m1_107200_66388# m4_107214_65100# 2.3672700000000001e-18
C29 w_107200_65100# m4_107214_65100# 4.0374999999999995e-18
C30 w_107200_67548# m2_107326_65100# 1.8978e-18
C31 a_108402_65100# m2_107998_65100# 3.1880400000000006e-20
C32 w_107200_65100# m1_107200_66388# 3.8351200000000004e-19
C33 w_107200_67548# m4_107214_65100# 5.92231e-19
C34 m4_107982_65100# w_107200_66216# 1.1378399999999999e-17
C35 m1_107200_66388# w_107200_67548# 3.2119600000000002e-18
C36 m2_108190_65100# m1_107200_67424# 4.8298300000000001e-17
C37 w_107200_66216# m4_107598_65100# 9.0080500000000004e-18
C38 m3_107200_66002# w_107200_66216# 1.6701200000000002e-17
C39 a_108345_66276# m1_107200_67424# 4.434400000000001e-19
C40 w_19964_21727# a_20751_23093# 4.3139900000000006e-18
C41 m5_107200_66336# m1_107200_67424# 1.4143500000000001e-18
C42 w_19964_21727# w_19964_23083# 8.8069700000000004e-16
C43 m1_107200_67424# m2_107998_65100# 2.49988e-17
C44 a_108402_65100# m4_107982_65100# 2.8074700000000005e-19
C45 m2_108190_65100# a_108345_65100# 1.01416e-16
C46 w_107200_66216# a_108332_65715# 4.0230400000000002e-16
C47 a_22039_23093# a_20751_23093# 1.2163700000000001e-18
C48 a_22039_23093# w_19964_23083# 2.1416300000000004e-16
C49 w_107200_66216# m2_107326_65100# 3.2141400000000004e-17
C50 a_108345_66276# a_108345_65100# 4.1432899999999998e-17
C51 m5_107200_66336# a_108345_65100# 5.1755800000000002e-18
C52 a_108345_65100# m2_107998_65100# 7.6047300000000016e-17
C53 w_107200_66216# m4_107214_65100# 4.9793700000000006e-18
C54 a_108389_67263# m1_107200_67424# 4.1616900000000002e-17
C55 a_108402_65100# m4_107598_65100# 1.0612000000000001e-20
C56 a_20000_23093# a_20751_23093# 2.6329100000000002e-18
C57 a_20000_23093# w_19964_23083# 2.63403e-16
C58 m1_107200_66388# w_107200_66216# 8.1488200000000022e-17
C59 a_108345_66276# m2_108190_65100# 1.1764e-16
C60 a_108402_65100# a_108332_65715# 3.35961e-17
C61 m2_108190_65100# m5_107200_66336# 1.3326700000000002e-17
C62 m2_108190_65100# m2_107998_65100# 5.5803600000000002e-16
C63 a_108402_65100# m2_107326_65100# 7.8486300000000013e-21
C64 a_108345_66276# m5_107200_66336# 2.8862400000000001e-17
C65 m4_107982_65100# m1_107200_67424# 2.9948400000000002e-18
C66 a_108345_66276# m2_107998_65100# 7.9094400000000003e-17
C67 m5_107200_66336# m2_107998_65100# 8.1286e-18
C68 a_108402_65100# m4_107214_65100# 9.3524300000000013e-22
C69 m4_107982_65100# a_108345_65100# 1.6507000000000003e-17
C70 m2_108190_65100# a_108389_67263# 1.1578200000000001e-17
C71 m1_107200_67350# m1_107200_67424# 6.5872900000000004e-16
C72 w_107200_65100# a_108402_65100# 5.2726700000000005e-17
C73 a_108345_66276# a_108389_67263# 3.4042600000000001e-17
C74 m1_107200_67424# m4_107598_65100# 1.6285e-18
C75 m5_107200_66336# a_108389_67263# 3.5281500000000001e-19
C76 a_108389_67263# m2_107998_65100# 5.5591599999999995e-19
C77 m3_107200_66002# m1_107200_67424# 1.6020600000000002e-18
C78 a_108332_65715# m1_107200_67424# 7.302050000000001e-17
C79 a_108345_65100# m4_107598_65100# 9.049500000000001e-18
C80 m4_107982_65100# m2_108190_65100# 1.4945500000000001e-17
C81 m1_107200_67424# m2_107326_65100# 2.2759100000000004e-17
C82 m3_107200_66002# a_108345_65100# 1.61041e-18
C83 m4_107982_65100# a_108345_66276# 1.6397200000000001e-17
C84 m4_107982_65100# m5_107200_66336# 2.4036099999999999e-16
C85 a_108332_65715# a_108345_65100# 6.3762400000000006e-16
C86 m4_107982_65100# m2_107998_65100# 2.66712e-17
C87 m1_107200_67424# m4_107214_65100# 1.3892400000000002e-18
C88 a_108345_65100# m2_107326_65100# 7.3327300000000006e-17
C89 a_22591_23093# w_19964_23083# 3.3554199999999996e-16
C90 m2_108190_65100# m1_107200_67350# 2.4562000000000002e-17
C91 m1_107200_66388# m1_107200_67424# 2.4991099999999999e-17
C92 w_19964_21727# a_22039_23093# 4.3139900000000006e-18
C93 a_108345_66276# m1_107200_67350# 1.1850400000000001e-17
C94 m1_107200_67350# m5_107200_66336# 2.3707300000000004e-18
C95 a_108345_65100# m4_107214_65100# 4.5276800000000007e-18
C96 m2_108190_65100# m3_107200_66002# 8.4636000000000015e-20
C97 m1_107200_67350# m2_107998_65100# 2.3884200000000004e-17
C98 a_108345_66276# m4_107598_65100# 8.8562999999999996e-18
C99 m5_107200_66336# m4_107598_65100# 1.98648e-16
C100 m4_107982_65100# a_108389_67263# 1.9722600000000002e-18
C101 m4_107598_65100# m2_107998_65100# 1.0179600000000001e-17
C102 a_108345_66276# m3_107200_66002# 1.24753e-17
C103 m5_107200_66336# m3_107200_66002# 1.7783400000000002e-16
C104 m1_107200_67424# w_107200_67548# 1.4178000000000003e-17
C105 m1_107200_66388# a_108345_65100# 6.1075300000000006e-20
C106 m2_108190_65100# a_108332_65715# 2.31152e-16
C107 m3_107200_66002# m2_107998_65100# 1.63333e-18
C108 w_107200_65100# a_108345_65100# 5.3274900000000011e-16
C109 a_20000_23093# w_19964_21727# 4.0955600000000003e-19
C110 a_108345_66276# a_108332_65715# 1.2381600000000002e-15
C111 m5_107200_66336# a_108332_65715# 7.4302000000000009e-16
C112 a_108332_65715# m2_107998_65100# 1.5544400000000001e-16
C113 a_108345_66276# m2_107326_65100# 6.8070499999999998e-17
C114 m1_107200_67350# a_108389_67263# 1.7539699999999999e-17
C115 m5_107200_66336# m2_107326_65100# 8.1952200000000019e-18
C116 m2_107326_65100# m2_107998_65100# 9.1264200000000011e-17
C117 a_108389_67263# m4_107598_65100# 1.2061800000000001e-19
C118 a_108345_66276# m4_107214_65100# 5.7916999999999998e-18
C119 m3_107200_66002# a_108389_67263# 9.1782600000000015e-20
C120 m5_107200_66336# m4_107214_65100# 1.3577300000000001e-16
C121 m1_107200_66388# m2_108190_65100# 4.0203900000000004e-20
C122 w_107200_65100# m2_108190_65100# 1.8931300000000003e-17
C123 a_108332_65715# a_108389_67263# 2.1590700000000004e-16
C124 m1_107200_66388# a_108345_66276# 2.0253100000000003e-16
C125 m1_107200_66388# m5_107200_66336# 1.1621500000000001e-17
C126 w_107200_65100# m5_107200_66336# 4.8700000000000003e-18
C127 a_108389_67263# m2_107326_65100# 1.10534e-19
C128 m1_107200_66388# m2_107998_65100# 1.1905800000000002e-16
C129 m4_107982_65100# m1_107200_67350# 3.8046000000000005e-18
C130 w_107200_65100# m2_107998_65100# 3.3636200000000009e-17
C131 m2_108190_65100# w_107200_67548# 3.3428399999999998e-18
C132 m4_107982_65100# m4_107598_65100# 5.3652999999999996e-16
C133 a_108389_67263# m4_107214_65100# 1.0530900000000002e-19
C134 m5_107200_66336# w_107200_67548# 1.5137900000000001e-18
C135 m4_107982_65100# m3_107200_66002# 2.0485600000000002e-19
C136 w_107200_67548# m2_107998_65100# 2.9277600000000006e-18
C137 w_107200_66216# m1_107200_67424# 8.5384699999999998e-20
C138 m1_107200_66388# a_108389_67263# 1.6522900000000002e-19
C139 m4_107982_65100# a_108332_65715# 2.27618e-16
C140 m1_107200_67350# m4_107598_65100# 2.5642200000000004e-18
C141 m4_107982_65100# m2_107326_65100# 8.7285199999999993e-19
C142 m1_107200_67350# m3_107200_66002# 1.5272800000000001e-18
C143 m3_107200_66002# m4_107598_65100# 6.140160000000001e-16
C144 a_108389_67263# w_107200_67548# 2.2428400000000003e-17
C145 m1_107200_67350# a_108332_65715# 8.5240000000000001e-16
C146 m1_107200_67350# m2_107326_65100# 2.1664900000000002e-17
C147 a_20751_23093# w_19964_23083# 4.4880300000000007e-16
C148 a_108332_65715# m4_107598_65100# 1.6941400000000004e-17
C149 w_19964_21727# a_22591_23093# 3.5767900000000004e-18
C150 m1_107200_66388# m4_107982_65100# 4.7e-19
C151 m4_107598_65100# m2_107326_65100# 1.0591400000000002e-17
C152 w_107200_65100# m4_107982_65100# 8.1896100000000012e-18
C153 m3_107200_66002# a_108332_65715# 2.8119599999999999e-17
C154 m5_22600_20000# a_20000_21737# 0 $ **FLOATING
C155 m5_20600_20000# a_20000_21737# 0 $ **FLOATING
C156 m5_20000_20000# a_20000_21737# 0 $ **FLOATING
C157 m5_22600_21100# a_20000_21737# 0 $ **FLOATING
C158 m5_20600_21100# a_20000_21737# 0 $ **FLOATING
C159 m5_20000_21100# a_20000_21737# 0 $ **FLOATING
C160 m5_22600_23100# a_20000_21737# 0 $ **FLOATING
C161 m5_20600_23100# a_20000_21737# 0 $ **FLOATING
C162 m5_20000_23100# a_20000_21737# 0 $ **FLOATING
C163 m5_108600_65100# a_20000_21737# 0 $ **FLOATING
C164 m5_107200_65100# a_20000_21737# 0 $ **FLOATING
C165 m5_107200_66336# a_20000_21737# 8.8871e-16
C166 m5_108600_67100# a_20000_21737# 0 $ **FLOATING
C167 m5_107200_67100# a_20000_21737# 0 $ **FLOATING
C168 m4_23090_20000# a_20000_21737# 0 $ **FLOATING
C169 m4_22530_20000# a_20000_21737# 0 $ **FLOATING
C170 m4_21970_20000# a_20000_21737# 0 $ **FLOATING
C171 m4_21410_20000# a_20000_21737# 0 $ **FLOATING
C172 m4_20850_20000# a_20000_21737# 0 $ **FLOATING
C173 m4_20290_20000# a_20000_21737# 0 $ **FLOATING
C174 m4_20000_20000# a_20000_21737# 0 $ **FLOATING
C175 m4_23230_20450# a_20000_21737# 0 $ **FLOATING
C176 m4_22670_20450# a_20000_21737# 0 $ **FLOATING
C177 m4_22110_20450# a_20000_21737# 0 $ **FLOATING
C178 m4_21550_20450# a_20000_21737# 0 $ **FLOATING
C179 m4_20990_20450# a_20000_21737# 0 $ **FLOATING
C180 m4_20430_20450# a_20000_21737# 0 $ **FLOATING
C181 m4_20000_20450# a_20000_21737# 0 $ **FLOATING
C182 m4_22810_21010# a_20000_21737# 0 $ **FLOATING
C183 m4_22250_21010# a_20000_21737# 0 $ **FLOATING
C184 m4_21690_21010# a_20000_21737# 0 $ **FLOATING
C185 m4_21130_21010# a_20000_21737# 0 $ **FLOATING
C186 m4_20570_21010# a_20000_21737# 0 $ **FLOATING
C187 m4_20010_21010# a_20000_21737# 0 $ **FLOATING
C188 m4_22950_21570# a_20000_21737# 0 $ **FLOATING
C189 m4_22390_21570# a_20000_21737# 0 $ **FLOATING
C190 m4_21830_21570# a_20000_21737# 0 $ **FLOATING
C191 m4_21270_21570# a_20000_21737# 0 $ **FLOATING
C192 m4_20710_21570# a_20000_21737# 0 $ **FLOATING
C193 m4_20150_21570# a_20000_21737# 0 $ **FLOATING
C194 m4_23090_22130# a_20000_21737# 0 $ **FLOATING
C195 m4_22530_22130# a_20000_21737# 0 $ **FLOATING
C196 m4_21970_22130# a_20000_21737# 0 $ **FLOATING
C197 m4_21410_22130# a_20000_21737# 0 $ **FLOATING
C198 m4_20850_22130# a_20000_21737# 0 $ **FLOATING
C199 m4_20290_22130# a_20000_21737# 0 $ **FLOATING
C200 m4_20000_22130# a_20000_21737# 0 $ **FLOATING
C201 m4_23230_22690# a_20000_21737# 0 $ **FLOATING
C202 m4_22670_22690# a_20000_21737# 0 $ **FLOATING
C203 m4_22110_22690# a_20000_21737# 0 $ **FLOATING
C204 m4_21550_22690# a_20000_21737# 0 $ **FLOATING
C205 m4_20990_22690# a_20000_21737# 0 $ **FLOATING
C206 m4_20430_22690# a_20000_21737# 0 $ **FLOATING
C207 m4_20000_22690# a_20000_21737# 0 $ **FLOATING
C208 m4_109660_65100# a_20000_21737# 0 $ **FLOATING
C209 m4_109690_65250# a_20000_21737# 0 $ **FLOATING
C210 m4_109668_65428# a_20000_21737# 0 $ **FLOATING
C211 m4_109632_65604# a_20000_21737# 0 $ **FLOATING
C212 m4_109596_65780# a_20000_21737# 0 $ **FLOATING
C213 m4_108860_65100# a_20000_21737# 0 $ **FLOATING
C214 m4_108684_65100# a_20000_21737# 0 $ **FLOATING
C215 m4_108508_65100# a_20000_21737# 0 $ **FLOATING
C216 m4_108332_65100# a_20000_21737# 0 $ **FLOATING
C217 m4_108156_65100# a_20000_21737# 0 $ **FLOATING
C218 m4_108824_65252# a_20000_21737# 0 $ **FLOATING
C219 m4_108648_65252# a_20000_21737# 0 $ **FLOATING
C220 m4_108472_65252# a_20000_21737# 0 $ **FLOATING
C221 m4_108296_65252# a_20000_21737# 0 $ **FLOATING
C222 m4_108788_65428# a_20000_21737# 0 $ **FLOATING
C223 m4_108612_65428# a_20000_21737# 0 $ **FLOATING
C224 m4_108436_65428# a_20000_21737# 0 $ **FLOATING
C225 m4_108260_65428# a_20000_21737# 0 $ **FLOATING
C226 m4_108752_65604# a_20000_21737# 0 $ **FLOATING
C227 m4_108576_65604# a_20000_21737# 0 $ **FLOATING
C228 m4_108400_65604# a_20000_21737# 0 $ **FLOATING
C229 m4_108224_65604# a_20000_21737# 0 $ **FLOATING
C230 m4_108716_65780# a_20000_21737# 0 $ **FLOATING
C231 m4_108540_65780# a_20000_21737# 0 $ **FLOATING
C232 m4_108364_65780# a_20000_21737# 0 $ **FLOATING
C233 m4_108188_65780# a_20000_21737# 0 $ **FLOATING
C234 m4_109680_66050# a_20000_21737# 0 $ **FLOATING
C235 m4_109664_66308# a_20000_21737# 0 $ **FLOATING
C236 m4_109628_66484# a_20000_21737# 0 $ **FLOATING
C237 m4_109592_66660# a_20000_21737# 0 $ **FLOATING
C238 m4_109670_66850# a_20000_21737# 0 $ **FLOATING
C239 m4_108856_65956# a_20000_21737# 0 $ **FLOATING
C240 m4_108680_65956# a_20000_21737# 0 $ **FLOATING
C241 m4_108504_65956# a_20000_21737# 0 $ **FLOATING
C242 m4_108328_65956# a_20000_21737# 0 $ **FLOATING
C243 m4_108152_65956# a_20000_21737# 0 $ **FLOATING
C244 m4_108820_66132# a_20000_21737# 0 $ **FLOATING
C245 m4_108644_66132# a_20000_21737# 0 $ **FLOATING
C246 m4_108468_66132# a_20000_21737# 0 $ **FLOATING
C247 m4_108292_66132# a_20000_21737# 0 $ **FLOATING
C248 m4_108784_66308# a_20000_21737# 0 $ **FLOATING
C249 m4_108608_66308# a_20000_21737# 0 $ **FLOATING
C250 m4_108432_66308# a_20000_21737# 0 $ **FLOATING
C251 m4_108256_66308# a_20000_21737# 0 $ **FLOATING
C252 m4_108748_66484# a_20000_21737# 0 $ **FLOATING
C253 m4_108572_66484# a_20000_21737# 0 $ **FLOATING
C254 m4_108396_66484# a_20000_21737# 0 $ **FLOATING
C255 m4_108220_66484# a_20000_21737# 0 $ **FLOATING
C256 m4_108712_66660# a_20000_21737# 0 $ **FLOATING
C257 m4_108536_66660# a_20000_21737# 0 $ **FLOATING
C258 m4_108360_66660# a_20000_21737# 0 $ **FLOATING
C259 m4_108184_66660# a_20000_21737# 0 $ **FLOATING
C260 m4_108852_66836# a_20000_21737# 0 $ **FLOATING
C261 m4_108676_66836# a_20000_21737# 0 $ **FLOATING
C262 m4_108500_66836# a_20000_21737# 0 $ **FLOATING
C263 m4_108324_66836# a_20000_21737# 0 $ **FLOATING
C264 m4_108148_66836# a_20000_21737# 0 $ **FLOATING
C265 m4_108816_67012# a_20000_21737# 0 $ **FLOATING
C266 m4_108640_67012# a_20000_21737# 0 $ **FLOATING
C267 m4_108464_67012# a_20000_21737# 0 $ **FLOATING
C268 m4_108288_67012# a_20000_21737# 0 $ **FLOATING
C269 m4_108780_67188# a_20000_21737# 0 $ **FLOATING
C270 m4_108604_67188# a_20000_21737# 0 $ **FLOATING
C271 m4_108428_67188# a_20000_21737# 0 $ **FLOATING
C272 m4_108252_67188# a_20000_21737# 0 $ **FLOATING
C273 m4_108744_67364# a_20000_21737# 0 $ **FLOATING
C274 m4_108568_67364# a_20000_21737# 0 $ **FLOATING
C275 m4_108392_67364# a_20000_21737# 0 $ **FLOATING
C276 m4_108216_67364# a_20000_21737# 0 $ **FLOATING
C277 m4_108708_67540# a_20000_21737# 0 $ **FLOATING
C278 m4_108532_67540# a_20000_21737# 0 $ **FLOATING
C279 m4_108356_67540# a_20000_21737# 0 $ **FLOATING
C280 m4_108180_67540# a_20000_21737# 0 $ **FLOATING
C281 m4_107982_65100# a_20000_21737# 2.46726e-16
C282 m4_107740_65100# a_20000_21737# 0 $ **FLOATING
C283 m4_107770_65250# a_20000_21737# 0 $ **FLOATING
C284 m4_107800_65410# a_20000_21737# 0 $ **FLOATING
C285 m4_107764_66132# a_20000_21737# 0 $ **FLOATING
C286 m4_107750_66850# a_20000_21737# 0 $ **FLOATING
C287 m4_107760_67012# a_20000_21737# 0 $ **FLOATING
C288 m4_107598_65100# a_20000_21737# 1.1617500000000001e-16
C289 m4_107380_65428# a_20000_21737# 0 $ **FLOATING
C290 m4_107380_65730# a_20000_21737# 0 $ **FLOATING
C291 m4_107214_65100# a_20000_21737# 5.1146899999999999e-16
C292 m3_23090_20000# a_20000_21737# 0 $ **FLOATING
C293 m3_22530_20000# a_20000_21737# 0 $ **FLOATING
C294 m3_21970_20000# a_20000_21737# 0 $ **FLOATING
C295 m3_21410_20000# a_20000_21737# 0 $ **FLOATING
C296 m3_20850_20000# a_20000_21737# 0 $ **FLOATING
C297 m3_20290_20000# a_20000_21737# 0 $ **FLOATING
C298 m3_20000_20000# a_20000_21737# 0 $ **FLOATING
C299 m3_23230_20450# a_20000_21737# 0 $ **FLOATING
C300 m3_22670_20450# a_20000_21737# 0 $ **FLOATING
C301 m3_22110_20450# a_20000_21737# 0 $ **FLOATING
C302 m3_21550_20450# a_20000_21737# 0 $ **FLOATING
C303 m3_20990_20450# a_20000_21737# 0 $ **FLOATING
C304 m3_20430_20450# a_20000_21737# 0 $ **FLOATING
C305 m3_20000_20450# a_20000_21737# 0 $ **FLOATING
C306 m3_22810_21010# a_20000_21737# 0 $ **FLOATING
C307 m3_22250_21010# a_20000_21737# 0 $ **FLOATING
C308 m3_21690_21010# a_20000_21737# 0 $ **FLOATING
C309 m3_21130_21010# a_20000_21737# 0 $ **FLOATING
C310 m3_20570_21010# a_20000_21737# 0 $ **FLOATING
C311 m3_20010_21010# a_20000_21737# 0 $ **FLOATING
C312 m3_22950_21570# a_20000_21737# 0 $ **FLOATING
C313 m3_22390_21570# a_20000_21737# 0 $ **FLOATING
C314 m3_21830_21570# a_20000_21737# 0 $ **FLOATING
C315 m3_21270_21570# a_20000_21737# 0 $ **FLOATING
C316 m3_20710_21570# a_20000_21737# 0 $ **FLOATING
C317 m3_20150_21570# a_20000_21737# 0 $ **FLOATING
C318 m3_23090_22130# a_20000_21737# 0 $ **FLOATING
C319 m3_22530_22130# a_20000_21737# 0 $ **FLOATING
C320 m3_21970_22130# a_20000_21737# 0 $ **FLOATING
C321 m3_21410_22130# a_20000_21737# 0 $ **FLOATING
C322 m3_20850_22130# a_20000_21737# 0 $ **FLOATING
C323 m3_20290_22130# a_20000_21737# 0 $ **FLOATING
C324 m3_20000_22130# a_20000_21737# 0 $ **FLOATING
C325 m3_23230_22690# a_20000_21737# 0 $ **FLOATING
C326 m3_22670_22690# a_20000_21737# 0 $ **FLOATING
C327 m3_22110_22690# a_20000_21737# 0 $ **FLOATING
C328 m3_21550_22690# a_20000_21737# 0 $ **FLOATING
C329 m3_20990_22690# a_20000_21737# 0 $ **FLOATING
C330 m3_20430_22690# a_20000_21737# 0 $ **FLOATING
C331 m3_20000_22690# a_20000_21737# 0 $ **FLOATING
C332 m3_109634_65146# a_20000_21737# 0 $ **FLOATING
C333 m3_109458_65146# a_20000_21737# 0 $ **FLOATING
C334 m3_109282_65146# a_20000_21737# 0 $ **FLOATING
C335 m3_109106_65146# a_20000_21737# 0 $ **FLOATING
C336 m3_108930_65146# a_20000_21737# 0 $ **FLOATING
C337 m3_108754_65146# a_20000_21737# 0 $ **FLOATING
C338 m3_108578_65146# a_20000_21737# 0 $ **FLOATING
C339 m3_108400_65110# a_20000_21737# 0 $ **FLOATING
C340 m3_108240_65110# a_20000_21737# 0 $ **FLOATING
C341 m3_107346_65146# a_20000_21737# 0 $ **FLOATING
C342 m3_107200_65146# a_20000_21737# 0 $ **FLOATING
C343 m3_109598_65322# a_20000_21737# 0 $ **FLOATING
C344 m3_109422_65322# a_20000_21737# 0 $ **FLOATING
C345 m3_109246_65322# a_20000_21737# 0 $ **FLOATING
C346 m3_109070_65322# a_20000_21737# 0 $ **FLOATING
C347 m3_108894_65322# a_20000_21737# 0 $ **FLOATING
C348 m3_108718_65322# a_20000_21737# 0 $ **FLOATING
C349 m3_108542_65322# a_20000_21737# 0 $ **FLOATING
C350 m3_109562_65498# a_20000_21737# 0 $ **FLOATING
C351 m3_109386_65498# a_20000_21737# 0 $ **FLOATING
C352 m3_109210_65498# a_20000_21737# 0 $ **FLOATING
C353 m3_109034_65498# a_20000_21737# 0 $ **FLOATING
C354 m3_108858_65498# a_20000_21737# 0 $ **FLOATING
C355 m3_108682_65498# a_20000_21737# 0 $ **FLOATING
C356 m3_108506_65498# a_20000_21737# 0 $ **FLOATING
C357 m3_108240_65310# a_20000_21737# 0 $ **FLOATING
C358 m3_108014_65322# a_20000_21737# 0 $ **FLOATING
C359 m3_107838_65322# a_20000_21737# 0 $ **FLOATING
C360 m3_107662_65322# a_20000_21737# 0 $ **FLOATING
C361 m3_107486_65322# a_20000_21737# 0 $ **FLOATING
C362 m3_107310_65322# a_20000_21737# 0 $ **FLOATING
C363 m3_107200_65322# a_20000_21737# 0 $ **FLOATING
C364 m3_108822_65674# a_20000_21737# 0 $ **FLOATING
C365 m3_108646_65674# a_20000_21737# 0 $ **FLOATING
C366 m3_108120_65570# a_20000_21737# 0 $ **FLOATING
C367 m3_107802_65498# a_20000_21737# 0 $ **FLOATING
C368 m3_107626_65498# a_20000_21737# 0 $ **FLOATING
C369 m3_107450_65498# a_20000_21737# 0 $ **FLOATING
C370 m3_107274_65498# a_20000_21737# 0 $ **FLOATING
C371 m3_107200_65498# a_20000_21737# 0 $ **FLOATING
C372 m3_107942_65674# a_20000_21737# 0 $ **FLOATING
C373 m3_107766_65674# a_20000_21737# 0 $ **FLOATING
C374 m3_107590_65674# a_20000_21737# 0 $ **FLOATING
C375 m3_107414_65674# a_20000_21737# 0 $ **FLOATING
C376 m3_107238_65674# a_20000_21737# 0 $ **FLOATING
C377 m3_109666_65850# a_20000_21737# 0 $ **FLOATING
C378 m3_108786_65850# a_20000_21737# 0 $ **FLOATING
C379 m3_108610_65850# a_20000_21737# 0 $ **FLOATING
C380 m3_109630_66026# a_20000_21737# 0 $ **FLOATING
C381 m3_109454_66026# a_20000_21737# 0 $ **FLOATING
C382 m3_109278_66026# a_20000_21737# 0 $ **FLOATING
C383 m3_109102_66026# a_20000_21737# 0 $ **FLOATING
C384 m3_108926_66026# a_20000_21737# 0 $ **FLOATING
C385 m3_108750_66026# a_20000_21737# 0 $ **FLOATING
C386 m3_108574_66026# a_20000_21737# 0 $ **FLOATING
C387 m3_108260_65830# a_20000_21737# 0 $ **FLOATING
C388 m3_108082_65850# a_20000_21737# 0 $ **FLOATING
C389 m3_107906_65850# a_20000_21737# 0 $ **FLOATING
C390 m3_107730_65850# a_20000_21737# 0 $ **FLOATING
C391 m3_109594_66202# a_20000_21737# 0 $ **FLOATING
C392 m3_109418_66202# a_20000_21737# 0 $ **FLOATING
C393 m3_109242_66202# a_20000_21737# 0 $ **FLOATING
C394 m3_109066_66202# a_20000_21737# 0 $ **FLOATING
C395 m3_108890_66202# a_20000_21737# 0 $ **FLOATING
C396 m3_108714_66202# a_20000_21737# 0 $ **FLOATING
C397 m3_108140_66090# a_20000_21737# 0 $ **FLOATING
C398 m3_107870_66026# a_20000_21737# 0 $ **FLOATING
C399 m3_107694_66026# a_20000_21737# 0 $ **FLOATING
C400 m3_107200_66002# a_20000_21737# 1.5996000000000004e-16
C401 m3_107834_66202# a_20000_21737# 0 $ **FLOATING
C402 m3_107658_66202# a_20000_21737# 0 $ **FLOATING
C403 m3_107482_66202# a_20000_21737# 0 $ **FLOATING
C404 m3_107306_66202# a_20000_21737# 0 $ **FLOATING
C405 m3_107200_66202# a_20000_21737# 0 $ **FLOATING
C406 m3_109558_66378# a_20000_21737# 0 $ **FLOATING
C407 m3_109382_66378# a_20000_21737# 0 $ **FLOATING
C408 m3_109206_66378# a_20000_21737# 0 $ **FLOATING
C409 m3_109030_66378# a_20000_21737# 0 $ **FLOATING
C410 m3_108854_66378# a_20000_21737# 0 $ **FLOATING
C411 m3_108678_66378# a_20000_21737# 0 $ **FLOATING
C412 m3_108280_66350# a_20000_21737# 0 $ **FLOATING
C413 m3_107974_66378# a_20000_21737# 0 $ **FLOATING
C414 m3_107798_66378# a_20000_21737# 0 $ **FLOATING
C415 m3_107622_66378# a_20000_21737# 0 $ **FLOATING
C416 m3_107446_66378# a_20000_21737# 0 $ **FLOATING
C417 m3_107270_66378# a_20000_21737# 0 $ **FLOATING
C418 m3_107200_66378# a_20000_21737# 0 $ **FLOATING
C419 m3_109522_66554# a_20000_21737# 0 $ **FLOATING
C420 m3_109346_66554# a_20000_21737# 0 $ **FLOATING
C421 m3_109170_66554# a_20000_21737# 0 $ **FLOATING
C422 m3_108994_66554# a_20000_21737# 0 $ **FLOATING
C423 m3_108818_66554# a_20000_21737# 0 $ **FLOATING
C424 m3_108642_66554# a_20000_21737# 0 $ **FLOATING
C425 m3_109662_66730# a_20000_21737# 0 $ **FLOATING
C426 m3_109486_66730# a_20000_21737# 0 $ **FLOATING
C427 m3_109310_66730# a_20000_21737# 0 $ **FLOATING
C428 m3_109134_66730# a_20000_21737# 0 $ **FLOATING
C429 m3_108958_66730# a_20000_21737# 0 $ **FLOATING
C430 m3_108782_66730# a_20000_21737# 0 $ **FLOATING
C431 m3_108606_66730# a_20000_21737# 0 $ **FLOATING
C432 m3_108430_66730# a_20000_21737# 0 $ **FLOATING
C433 m3_108160_66610# a_20000_21737# 0 $ **FLOATING
C434 m3_107938_66554# a_20000_21737# 0 $ **FLOATING
C435 m3_107762_66554# a_20000_21737# 0 $ **FLOATING
C436 m3_107586_66554# a_20000_21737# 0 $ **FLOATING
C437 m3_107410_66554# a_20000_21737# 0 $ **FLOATING
C438 m3_107234_66554# a_20000_21737# 0 $ **FLOATING
C439 m3_107902_66730# a_20000_21737# 0 $ **FLOATING
C440 m3_107726_66730# a_20000_21737# 0 $ **FLOATING
C441 m3_107550_66730# a_20000_21737# 0 $ **FLOATING
C442 m3_107374_66730# a_20000_21737# 0 $ **FLOATING
C443 m3_107200_66730# a_20000_21737# 0 $ **FLOATING
C444 m3_109626_66906# a_20000_21737# 0 $ **FLOATING
C445 m3_109450_66906# a_20000_21737# 0 $ **FLOATING
C446 m3_109274_66906# a_20000_21737# 0 $ **FLOATING
C447 m3_109098_66906# a_20000_21737# 0 $ **FLOATING
C448 m3_108922_66906# a_20000_21737# 0 $ **FLOATING
C449 m3_108746_66906# a_20000_21737# 0 $ **FLOATING
C450 m3_108570_66906# a_20000_21737# 0 $ **FLOATING
C451 m3_108394_66906# a_20000_21737# 0 $ **FLOATING
C452 m3_108218_66906# a_20000_21737# 0 $ **FLOATING
C453 m3_108710_67082# a_20000_21737# 0 $ **FLOATING
C454 m3_108534_67082# a_20000_21737# 0 $ **FLOATING
C455 m3_108850_67258# a_20000_21737# 0 $ **FLOATING
C456 m3_108674_67258# a_20000_21737# 0 $ **FLOATING
C457 m3_108498_67258# a_20000_21737# 0 $ **FLOATING
C458 m3_108180_67130# a_20000_21737# 0 $ **FLOATING
C459 m3_107650_66930# a_20000_21737# 0 $ **FLOATING
C460 m3_107338_66906# a_20000_21737# 0 $ **FLOATING
C461 m3_107200_66906# a_20000_21737# 0 $ **FLOATING
C462 m3_107302_67082# a_20000_21737# 0 $ **FLOATING
C463 m3_107200_67082# a_20000_21737# 0 $ **FLOATING
C464 m3_107442_67258# a_20000_21737# 0 $ **FLOATING
C465 m3_107266_67258# a_20000_21737# 0 $ **FLOATING
C466 m3_107200_67258# a_20000_21737# 0 $ **FLOATING
C467 m3_109694_67434# a_20000_21737# 0 $ **FLOATING
C468 m3_109518_67434# a_20000_21737# 0 $ **FLOATING
C469 m3_109342_67434# a_20000_21737# 0 $ **FLOATING
C470 m3_109166_67434# a_20000_21737# 0 $ **FLOATING
C471 m3_108990_67434# a_20000_21737# 0 $ **FLOATING
C472 m3_108814_67434# a_20000_21737# 0 $ **FLOATING
C473 m3_108638_67434# a_20000_21737# 0 $ **FLOATING
C474 m3_108462_67434# a_20000_21737# 0 $ **FLOATING
C475 m3_108286_67434# a_20000_21737# 0 $ **FLOATING
C476 m3_108110_67434# a_20000_21737# 0 $ **FLOATING
C477 m3_107934_67434# a_20000_21737# 0 $ **FLOATING
C478 m3_107758_67434# a_20000_21737# 0 $ **FLOATING
C479 m3_107582_67434# a_20000_21737# 0 $ **FLOATING
C480 m3_107406_67434# a_20000_21737# 0 $ **FLOATING
C481 m3_107230_67434# a_20000_21737# 0 $ **FLOATING
C482 m2_23090_20000# a_20000_21737# 0 $ **FLOATING
C483 m2_22980_20200# a_20000_21737# 0 $ **FLOATING
C484 m2_22530_20000# a_20000_21737# 0 $ **FLOATING
C485 m2_21970_20000# a_20000_21737# 0 $ **FLOATING
C486 m2_21860_20100# a_20000_21737# 0 $ **FLOATING
C487 m2_21410_20000# a_20000_21737# 0 $ **FLOATING
C488 m2_20850_20000# a_20000_21737# 0 $ **FLOATING
C489 m2_20740_20000# a_20000_21737# 0 $ **FLOATING
C490 m2_20290_20000# a_20000_21737# 0 $ **FLOATING
C491 m2_20180_20200# a_20000_21737# 0 $ **FLOATING
C492 m2_20000_20000# a_20000_21737# 0 $ **FLOATING
C493 m2_21300_20300# a_20000_21737# 0 $ **FLOATING
C494 m2_23230_20450# a_20000_21737# 0 $ **FLOATING
C495 m2_23120_20400# a_20000_21737# 0 $ **FLOATING
C496 m2_22670_20450# a_20000_21737# 0 $ **FLOATING
C497 m2_22560_20600# a_20000_21737# 0 $ **FLOATING
C498 m2_22110_20450# a_20000_21737# 0 $ **FLOATING
C499 m2_22000_20800# a_20000_21737# 0 $ **FLOATING
C500 m2_21550_20450# a_20000_21737# 0 $ **FLOATING
C501 m2_21440_20500# a_20000_21737# 0 $ **FLOATING
C502 m2_20990_20450# a_20000_21737# 0 $ **FLOATING
C503 m2_20880_20700# a_20000_21737# 0 $ **FLOATING
C504 m2_20430_20450# a_20000_21737# 0 $ **FLOATING
C505 m2_20320_20400# a_20000_21737# 0 $ **FLOATING
C506 m2_20000_20450# a_20000_21737# 0 $ **FLOATING
C507 m2_23220_20900# a_20000_21737# 0 $ **FLOATING
C508 m2_23120_20900# a_20000_21737# 0 $ **FLOATING
C509 m2_23020_20900# a_20000_21737# 0 $ **FLOATING
C510 m2_22920_20900# a_20000_21737# 0 $ **FLOATING
C511 m2_22820_20900# a_20000_21737# 0 $ **FLOATING
C512 m2_22720_20900# a_20000_21737# 0 $ **FLOATING
C513 m2_22620_20900# a_20000_21737# 0 $ **FLOATING
C514 m2_22520_20900# a_20000_21737# 0 $ **FLOATING
C515 m2_22420_20900# a_20000_21737# 0 $ **FLOATING
C516 m2_22320_20900# a_20000_21737# 0 $ **FLOATING
C517 m2_22220_20900# a_20000_21737# 0 $ **FLOATING
C518 m2_22120_20900# a_20000_21737# 0 $ **FLOATING
C519 m2_22020_20900# a_20000_21737# 0 $ **FLOATING
C520 m2_21920_20900# a_20000_21737# 0 $ **FLOATING
C521 m2_21820_20900# a_20000_21737# 0 $ **FLOATING
C522 m2_21720_20900# a_20000_21737# 0 $ **FLOATING
C523 m2_21620_20900# a_20000_21737# 0 $ **FLOATING
C524 m2_21520_20900# a_20000_21737# 0 $ **FLOATING
C525 m2_21420_20900# a_20000_21737# 0 $ **FLOATING
C526 m2_21320_20900# a_20000_21737# 0 $ **FLOATING
C527 m2_21220_20900# a_20000_21737# 0 $ **FLOATING
C528 m2_21120_20900# a_20000_21737# 0 $ **FLOATING
C529 m2_21020_20900# a_20000_21737# 0 $ **FLOATING
C530 m2_20920_20900# a_20000_21737# 0 $ **FLOATING
C531 m2_20820_20900# a_20000_21737# 0 $ **FLOATING
C532 m2_20720_20900# a_20000_21737# 0 $ **FLOATING
C533 m2_20620_20900# a_20000_21737# 0 $ **FLOATING
C534 m2_20520_20900# a_20000_21737# 0 $ **FLOATING
C535 m2_20420_20900# a_20000_21737# 0 $ **FLOATING
C536 m2_20320_20900# a_20000_21737# 0 $ **FLOATING
C537 m2_20220_20900# a_20000_21737# 0 $ **FLOATING
C538 m2_20120_20900# a_20000_21737# 0 $ **FLOATING
C539 m2_20020_20900# a_20000_21737# 0 $ **FLOATING
C540 m2_23260_21100# a_20000_21737# 0 $ **FLOATING
C541 m2_22810_21010# a_20000_21737# 0 $ **FLOATING
C542 m2_22700_21300# a_20000_21737# 0 $ **FLOATING
C543 m2_22250_21010# a_20000_21737# 0 $ **FLOATING
C544 m2_22140_21000# a_20000_21737# 0 $ **FLOATING
C545 m2_21690_21010# a_20000_21737# 0 $ **FLOATING
C546 m2_21580_21200# a_20000_21737# 0 $ **FLOATING
C547 m2_21130_21010# a_20000_21737# 0 $ **FLOATING
C548 m2_21020_21400# a_20000_21737# 0 $ **FLOATING
C549 m2_20570_21010# a_20000_21737# 0 $ **FLOATING
C550 m2_20460_21100# a_20000_21737# 0 $ **FLOATING
C551 m2_20010_21010# a_20000_21737# 0 $ **FLOATING
C552 m2_22840_21500# a_20000_21737# 0 $ **FLOATING
C553 m2_20040_21500# a_20000_21737# 0 $ **FLOATING
C554 m2_22950_21570# a_20000_21737# 0 $ **FLOATING
C555 m2_22390_21570# a_20000_21737# 0 $ **FLOATING
C556 m2_22280_21700# a_20000_21737# 0 $ **FLOATING
C557 m2_21830_21570# a_20000_21737# 0 $ **FLOATING
C558 m2_21720_21900# a_20000_21737# 0 $ **FLOATING
C559 m2_21270_21570# a_20000_21737# 0 $ **FLOATING
C560 m2_21160_21600# a_20000_21737# 0 $ **FLOATING
C561 m2_20710_21570# a_20000_21737# 0 $ **FLOATING
C562 m2_20600_21800# a_20000_21737# 0 $ **FLOATING
C563 m2_20150_21570# a_20000_21737# 0 $ **FLOATING
C564 m2_22840_22000# a_20000_21737# 0 $ **FLOATING
C565 m2_20040_22000# a_20000_21737# 0 $ **FLOATING
C566 m2_23090_22130# a_20000_21737# 0 $ **FLOATING
C567 m2_22980_22200# a_20000_21737# 0 $ **FLOATING
C568 m2_22530_22130# a_20000_21737# 0 $ **FLOATING
C569 m2_22420_22400# a_20000_21737# 0 $ **FLOATING
C570 m2_21970_22130# a_20000_21737# 0 $ **FLOATING
C571 m2_21860_22100# a_20000_21737# 0 $ **FLOATING
C572 m2_21410_22130# a_20000_21737# 0 $ **FLOATING
C573 m2_21300_22300# a_20000_21737# 0 $ **FLOATING
C574 m2_20850_22130# a_20000_21737# 0 $ **FLOATING
C575 m2_20740_22500# a_20000_21737# 0 $ **FLOATING
C576 m2_20290_22130# a_20000_21737# 0 $ **FLOATING
C577 m2_20180_22200# a_20000_21737# 0 $ **FLOATING
C578 m2_20000_22130# a_20000_21737# 0 $ **FLOATING
C579 m2_22560_22600# a_20000_21737# 0 $ **FLOATING
C580 m2_23230_22690# a_20000_21737# 0 $ **FLOATING
C581 m2_23120_22900# a_20000_21737# 0 $ **FLOATING
C582 m2_22670_22690# a_20000_21737# 0 $ **FLOATING
C583 m2_22110_22690# a_20000_21737# 0 $ **FLOATING
C584 m2_22000_22800# a_20000_21737# 0 $ **FLOATING
C585 m2_21550_22690# a_20000_21737# 0 $ **FLOATING
C586 m2_21440_23000# a_20000_21737# 0 $ **FLOATING
C587 m2_20990_22690# a_20000_21737# 0 $ **FLOATING
C588 m2_20880_22700# a_20000_21737# 0 $ **FLOATING
C589 m2_20430_22690# a_20000_21737# 0 $ **FLOATING
C590 m2_20320_22900# a_20000_21737# 0 $ **FLOATING
C591 m2_20000_22690# a_20000_21737# 0 $ **FLOATING
C592 m2_22560_23100# a_20000_21737# 0 $ **FLOATING
C593 m2_109660_65100# a_20000_21737# 0 $ **FLOATING
C594 m2_109504_65100# a_20000_21737# 0 $ **FLOATING
C595 m2_109348_65100# a_20000_21737# 0 $ **FLOATING
C596 m2_109192_65100# a_20000_21737# 0 $ **FLOATING
C597 m2_109036_65100# a_20000_21737# 0 $ **FLOATING
C598 m2_108880_65100# a_20000_21737# 0 $ **FLOATING
C599 m2_108724_65100# a_20000_21737# 0 $ **FLOATING
C600 m2_108568_65100# a_20000_21737# 0 $ **FLOATING
C601 m2_108412_65100# a_20000_21737# 0 $ **FLOATING
C602 m2_109644_65240# a_20000_21737# 0 $ **FLOATING
C603 m2_109488_65240# a_20000_21737# 0 $ **FLOATING
C604 m2_109332_65240# a_20000_21737# 0 $ **FLOATING
C605 m2_109176_65240# a_20000_21737# 0 $ **FLOATING
C606 m2_109020_65240# a_20000_21737# 0 $ **FLOATING
C607 m2_108864_65240# a_20000_21737# 0 $ **FLOATING
C608 m2_108708_65240# a_20000_21737# 0 $ **FLOATING
C609 m2_108552_65240# a_20000_21737# 0 $ **FLOATING
C610 m2_108396_65240# a_20000_21737# 0 $ **FLOATING
C611 m2_108280_65200# a_20000_21737# 0 $ **FLOATING
C612 m2_109628_65396# a_20000_21737# 0 $ **FLOATING
C613 m2_109472_65396# a_20000_21737# 0 $ **FLOATING
C614 m2_109316_65396# a_20000_21737# 0 $ **FLOATING
C615 m2_109160_65396# a_20000_21737# 0 $ **FLOATING
C616 m2_109004_65396# a_20000_21737# 0 $ **FLOATING
C617 m2_108848_65396# a_20000_21737# 0 $ **FLOATING
C618 m2_108692_65396# a_20000_21737# 0 $ **FLOATING
C619 m2_108536_65396# a_20000_21737# 0 $ **FLOATING
C620 m2_108380_65396# a_20000_21737# 0 $ **FLOATING
C621 m2_109612_65552# a_20000_21737# 0 $ **FLOATING
C622 m2_109456_65552# a_20000_21737# 0 $ **FLOATING
C623 m2_109300_65552# a_20000_21737# 0 $ **FLOATING
C624 m2_109144_65552# a_20000_21737# 0 $ **FLOATING
C625 m2_108988_65552# a_20000_21737# 0 $ **FLOATING
C626 m2_108832_65552# a_20000_21737# 0 $ **FLOATING
C627 m2_108676_65552# a_20000_21737# 0 $ **FLOATING
C628 m2_108520_65552# a_20000_21737# 0 $ **FLOATING
C629 m2_108364_65552# a_20000_21737# 0 $ **FLOATING
C630 m2_109596_65708# a_20000_21737# 0 $ **FLOATING
C631 m2_108816_65708# a_20000_21737# 0 $ **FLOATING
C632 m2_108660_65708# a_20000_21737# 0 $ **FLOATING
C633 m2_108504_65708# a_20000_21737# 0 $ **FLOATING
C634 m2_108348_65708# a_20000_21737# 0 $ **FLOATING
C635 m2_109580_65864# a_20000_21737# 0 $ **FLOATING
C636 m2_108800_65864# a_20000_21737# 0 $ **FLOATING
C637 m2_108644_65864# a_20000_21737# 0 $ **FLOATING
C638 m2_108488_65864# a_20000_21737# 0 $ **FLOATING
C639 m2_108332_65864# a_20000_21737# 0 $ **FLOATING
C640 m2_109564_66021# a_20000_21737# 0 $ **FLOATING
C641 m2_109408_66021# a_20000_21737# 0 $ **FLOATING
C642 m2_109252_66021# a_20000_21737# 0 $ **FLOATING
C643 m2_109096_66021# a_20000_21737# 0 $ **FLOATING
C644 m2_108940_66021# a_20000_21737# 0 $ **FLOATING
C645 m2_108784_66020# a_20000_21737# 0 $ **FLOATING
C646 m2_108628_66020# a_20000_21737# 0 $ **FLOATING
C647 m2_108472_66020# a_20000_21737# 0 $ **FLOATING
C648 m2_109548_66176# a_20000_21737# 0 $ **FLOATING
C649 m2_109392_66176# a_20000_21737# 0 $ **FLOATING
C650 m2_109236_66176# a_20000_21737# 0 $ **FLOATING
C651 m2_109080_66176# a_20000_21737# 0 $ **FLOATING
C652 m2_108924_66176# a_20000_21737# 0 $ **FLOATING
C653 m2_108768_66176# a_20000_21737# 0 $ **FLOATING
C654 m2_108612_66176# a_20000_21737# 0 $ **FLOATING
C655 m2_108456_66176# a_20000_21737# 0 $ **FLOATING
C656 m2_108280_66200# a_20000_21737# 0 $ **FLOATING
C657 m2_109532_66332# a_20000_21737# 0 $ **FLOATING
C658 m2_109376_66332# a_20000_21737# 0 $ **FLOATING
C659 m2_109220_66332# a_20000_21737# 0 $ **FLOATING
C660 m2_109064_66332# a_20000_21737# 0 $ **FLOATING
C661 m2_108908_66332# a_20000_21737# 0 $ **FLOATING
C662 m2_108752_66332# a_20000_21737# 0 $ **FLOATING
C663 m2_108596_66332# a_20000_21737# 0 $ **FLOATING
C664 m2_108440_66332# a_20000_21737# 0 $ **FLOATING
C665 m2_108300_66300# a_20000_21737# 0 $ **FLOATING
C666 m2_108320_66400# a_20000_21737# 0 $ **FLOATING
C667 m2_109672_66488# a_20000_21737# 0 $ **FLOATING
C668 m2_109516_66488# a_20000_21737# 0 $ **FLOATING
C669 m2_109360_66488# a_20000_21737# 0 $ **FLOATING
C670 m2_109204_66488# a_20000_21737# 0 $ **FLOATING
C671 m2_109048_66488# a_20000_21737# 0 $ **FLOATING
C672 m2_108892_66488# a_20000_21737# 0 $ **FLOATING
C673 m2_108736_66488# a_20000_21737# 0 $ **FLOATING
C674 m2_108580_66488# a_20000_21737# 0 $ **FLOATING
C675 m2_108424_66488# a_20000_21737# 0 $ **FLOATING
C676 m2_109656_66644# a_20000_21737# 0 $ **FLOATING
C677 m2_109500_66644# a_20000_21737# 0 $ **FLOATING
C678 m2_109344_66644# a_20000_21737# 0 $ **FLOATING
C679 m2_109188_66644# a_20000_21737# 0 $ **FLOATING
C680 m2_109032_66644# a_20000_21737# 0 $ **FLOATING
C681 m2_108876_66644# a_20000_21737# 0 $ **FLOATING
C682 m2_108720_66644# a_20000_21737# 0 $ **FLOATING
C683 m2_108564_66644# a_20000_21737# 0 $ **FLOATING
C684 m2_108408_66644# a_20000_21737# 0 $ **FLOATING
C685 m2_108280_66700# a_20000_21737# 0 $ **FLOATING
C686 m2_109640_66800# a_20000_21737# 0 $ **FLOATING
C687 m2_109484_66800# a_20000_21737# 0 $ **FLOATING
C688 m2_109328_66800# a_20000_21737# 0 $ **FLOATING
C689 m2_109172_66800# a_20000_21737# 0 $ **FLOATING
C690 m2_109016_66800# a_20000_21737# 0 $ **FLOATING
C691 m2_108860_66800# a_20000_21737# 0 $ **FLOATING
C692 m2_108704_66800# a_20000_21737# 0 $ **FLOATING
C693 m2_108548_66800# a_20000_21737# 0 $ **FLOATING
C694 m2_108392_66800# a_20000_21737# 0 $ **FLOATING
C695 m2_109624_66956# a_20000_21737# 0 $ **FLOATING
C696 m2_109468_66956# a_20000_21737# 0 $ **FLOATING
C697 m2_109312_66956# a_20000_21737# 0 $ **FLOATING
C698 m2_109156_66956# a_20000_21737# 0 $ **FLOATING
C699 m2_109000_66956# a_20000_21737# 0 $ **FLOATING
C700 m2_108844_66956# a_20000_21737# 0 $ **FLOATING
C701 m2_108688_66956# a_20000_21737# 0 $ **FLOATING
C702 m2_108532_66956# a_20000_21737# 0 $ **FLOATING
C703 m2_108376_66956# a_20000_21737# 0 $ **FLOATING
C704 m2_109608_67112# a_20000_21737# 0 $ **FLOATING
C705 m2_108828_67112# a_20000_21737# 0 $ **FLOATING
C706 m2_108672_67112# a_20000_21737# 0 $ **FLOATING
C707 m2_108516_67112# a_20000_21737# 0 $ **FLOATING
C708 m2_108360_67112# a_20000_21737# 0 $ **FLOATING
C709 m2_109592_67268# a_20000_21737# 0 $ **FLOATING
C710 m2_108812_67268# a_20000_21737# 0 $ **FLOATING
C711 m2_108700_67300# a_20000_21737# 0 $ **FLOATING
C712 m2_108344_67268# a_20000_21737# 0 $ **FLOATING
C713 m2_109576_67424# a_20000_21737# 0 $ **FLOATING
C714 m2_109420_67424# a_20000_21737# 0 $ **FLOATING
C715 m2_109264_67424# a_20000_21737# 0 $ **FLOATING
C716 m2_109108_67424# a_20000_21737# 0 $ **FLOATING
C717 m2_108952_67424# a_20000_21737# 0 $ **FLOATING
C718 m2_108796_67424# a_20000_21737# 0 $ **FLOATING
C719 m2_109560_67580# a_20000_21737# 0 $ **FLOATING
C720 m2_109404_67580# a_20000_21737# 0 $ **FLOATING
C721 m2_109248_67580# a_20000_21737# 0 $ **FLOATING
C722 m2_109092_67580# a_20000_21737# 0 $ **FLOATING
C723 m2_108936_67580# a_20000_21737# 0 $ **FLOATING
C724 m2_108780_67580# a_20000_21737# 0 $ **FLOATING
C725 m2_108328_67424# a_20000_21737# 0 $ **FLOATING
C726 m2_108190_65100# a_20000_21737# 3.5299200000000008e-16
C727 m2_107998_65100# a_20000_21737# 1.9860200000000002e-16
C728 m2_107860_65100# a_20000_21737# 0 $ **FLOATING
C729 m2_107632_65100# a_20000_21737# 0 $ **FLOATING
C730 m2_107476_65100# a_20000_21737# 0 $ **FLOATING
C731 m2_107772_65240# a_20000_21737# 0 $ **FLOATING
C732 m2_107616_65240# a_20000_21737# 0 $ **FLOATING
C733 m2_107460_65240# a_20000_21737# 0 $ **FLOATING
C734 m2_107756_65396# a_20000_21737# 0 $ **FLOATING
C735 m2_107600_65396# a_20000_21737# 0 $ **FLOATING
C736 m2_107420_65400# a_20000_21737# 0 $ **FLOATING
C737 m2_107740_65552# a_20000_21737# 0 $ **FLOATING
C738 m2_107584_65552# a_20000_21737# 0 $ **FLOATING
C739 m2_107440_65500# a_20000_21737# 0 $ **FLOATING
C740 m2_107460_65600# a_20000_21737# 0 $ **FLOATING
C741 m2_107724_65708# a_20000_21737# 0 $ **FLOATING
C742 m2_107568_65708# a_20000_21737# 0 $ **FLOATING
C743 m2_107708_65864# a_20000_21737# 0 $ **FLOATING
C744 m2_107552_65864# a_20000_21737# 0 $ **FLOATING
C745 m2_107420_65900# a_20000_21737# 0 $ **FLOATING
C746 m2_107860_66100# a_20000_21737# 0 $ **FLOATING
C747 m2_107692_66020# a_20000_21737# 0 $ **FLOATING
C748 m2_107536_66020# a_20000_21737# 0 $ **FLOATING
C749 m2_107676_66176# a_20000_21737# 0 $ **FLOATING
C750 m2_107480_66200# a_20000_21737# 0 $ **FLOATING
C751 m2_107820_66400# a_20000_21737# 0 $ **FLOATING
C752 m2_107660_66332# a_20000_21737# 0 $ **FLOATING
C753 m2_107840_66500# a_20000_21737# 0 $ **FLOATING
C754 m2_107740_66500# a_20000_21737# 0 $ **FLOATING
C755 m2_107640_66500# a_20000_21737# 0 $ **FLOATING
C756 m2_107860_66600# a_20000_21737# 0 $ **FLOATING
C757 m2_107760_66600# a_20000_21737# 0 $ **FLOATING
C758 m2_107660_66600# a_20000_21737# 0 $ **FLOATING
C759 m2_107780_66700# a_20000_21737# 0 $ **FLOATING
C760 m2_107680_66700# a_20000_21737# 0 $ **FLOATING
C761 m2_107768_66800# a_20000_21737# 0 $ **FLOATING
C762 m2_107752_66956# a_20000_21737# 0 $ **FLOATING
C763 m2_107620_66900# a_20000_21737# 0 $ **FLOATING
C764 m2_107640_67000# a_20000_21737# 0 $ **FLOATING
C765 m2_107736_67112# a_20000_21737# 0 $ **FLOATING
C766 m2_107720_67268# a_20000_21737# 0 $ **FLOATING
C767 m2_107704_67424# a_20000_21737# 0 $ **FLOATING
C768 m2_107688_67580# a_20000_21737# 0 $ **FLOATING
C769 m2_107326_65100# a_20000_21737# 5.6525900000000012e-16
C770 m2_107200_65100# a_20000_21737# 0 $ **FLOATING
C771 m2_107200_65200# a_20000_21737# 0 $ **FLOATING
C772 m2_107200_65300# a_20000_21737# 0 $ **FLOATING
C773 m2_107200_65600# a_20000_21737# 0 $ **FLOATING
C774 m2_107200_65700# a_20000_21737# 0 $ **FLOATING
C775 m2_107200_65800# a_20000_21737# 0 $ **FLOATING
C776 m2_107200_66100# a_20000_21737# 0 $ **FLOATING
C777 m2_107200_66200# a_20000_21737# 0 $ **FLOATING
C778 m2_107200_66300# a_20000_21737# 0 $ **FLOATING
C779 m2_107200_66600# a_20000_21737# 0 $ **FLOATING
C780 m2_107200_66700# a_20000_21737# 0 $ **FLOATING
C781 m2_107200_66800# a_20000_21737# 0 $ **FLOATING
C782 m2_107200_67100# a_20000_21737# 0 $ **FLOATING
C783 m2_107200_67200# a_20000_21737# 0 $ **FLOATING
C784 m2_107200_67300# a_20000_21737# 0 $ **FLOATING
C785 m1_23090_20000# a_20000_21737# 0 $ **FLOATING
C786 m1_22970_20110# a_20000_21737# 0 $ **FLOATING
C787 m1_22990_20210# a_20000_21737# 0 $ **FLOATING
C788 m1_22530_20000# a_20000_21737# 0 $ **FLOATING
C789 m1_21970_20000# a_20000_21737# 0 $ **FLOATING
C790 m1_21850_20010# a_20000_21737# 0 $ **FLOATING
C791 m1_21870_20110# a_20000_21737# 0 $ **FLOATING
C792 m1_21410_20000# a_20000_21737# 0 $ **FLOATING
C793 m1_21290_20210# a_20000_21737# 0 $ **FLOATING
C794 m1_20850_20000# a_20000_21737# 0 $ **FLOATING
C795 m1_20750_20010# a_20000_21737# 0 $ **FLOATING
C796 m1_20290_20000# a_20000_21737# 0 $ **FLOATING
C797 m1_20170_20110# a_20000_21737# 0 $ **FLOATING
C798 m1_20190_20210# a_20000_21737# 0 $ **FLOATING
C799 m1_20000_20000# a_20000_21737# 0 $ **FLOATING
C800 m1_23180_20340# a_20000_21737# 0 $ **FLOATING
C801 m1_22940_20340# a_20000_21737# 0 $ **FLOATING
C802 m1_22700_20340# a_20000_21737# 0 $ **FLOATING
C803 m1_22460_20340# a_20000_21737# 0 $ **FLOATING
C804 m1_22220_20340# a_20000_21737# 0 $ **FLOATING
C805 m1_21980_20340# a_20000_21737# 0 $ **FLOATING
C806 m1_21740_20340# a_20000_21737# 0 $ **FLOATING
C807 m1_21500_20340# a_20000_21737# 0 $ **FLOATING
C808 m1_21260_20340# a_20000_21737# 0 $ **FLOATING
C809 m1_21020_20340# a_20000_21737# 0 $ **FLOATING
C810 m1_20780_20340# a_20000_21737# 0 $ **FLOATING
C811 m1_20540_20340# a_20000_21737# 0 $ **FLOATING
C812 m1_20300_20340# a_20000_21737# 0 $ **FLOATING
C813 m1_20060_20340# a_20000_21737# 0 $ **FLOATING
C814 m1_20000_20340# a_20000_21737# 0 $ **FLOATING
C815 m1_23080_20580# a_20000_21737# 0 $ **FLOATING
C816 m1_22840_20580# a_20000_21737# 0 $ **FLOATING
C817 m1_22600_20580# a_20000_21737# 0 $ **FLOATING
C818 m1_22360_20580# a_20000_21737# 0 $ **FLOATING
C819 m1_22120_20580# a_20000_21737# 0 $ **FLOATING
C820 m1_21880_20580# a_20000_21737# 0 $ **FLOATING
C821 m1_21640_20580# a_20000_21737# 0 $ **FLOATING
C822 m1_21400_20580# a_20000_21737# 0 $ **FLOATING
C823 m1_21160_20580# a_20000_21737# 0 $ **FLOATING
C824 m1_20920_20580# a_20000_21737# 0 $ **FLOATING
C825 m1_20680_20580# a_20000_21737# 0 $ **FLOATING
C826 m1_20440_20580# a_20000_21737# 0 $ **FLOATING
C827 m1_20200_20580# a_20000_21737# 0 $ **FLOATING
C828 m1_20000_20580# a_20000_21737# 0 $ **FLOATING
C829 m1_23170_20850# a_20000_21737# 0 $ **FLOATING
C830 m1_23014_20850# a_20000_21737# 0 $ **FLOATING
C831 m1_22858_20850# a_20000_21737# 0 $ **FLOATING
C832 m1_22702_20850# a_20000_21737# 0 $ **FLOATING
C833 m1_22546_20850# a_20000_21737# 0 $ **FLOATING
C834 m1_22390_20850# a_20000_21737# 0 $ **FLOATING
C835 m1_22234_20850# a_20000_21737# 0 $ **FLOATING
C836 m1_22078_20850# a_20000_21737# 0 $ **FLOATING
C837 m1_21922_20850# a_20000_21737# 0 $ **FLOATING
C838 m1_21766_20850# a_20000_21737# 0 $ **FLOATING
C839 m1_21610_20850# a_20000_21737# 0 $ **FLOATING
C840 m1_21454_20850# a_20000_21737# 0 $ **FLOATING
C841 m1_21298_20850# a_20000_21737# 0 $ **FLOATING
C842 m1_21142_20850# a_20000_21737# 0 $ **FLOATING
C843 m1_20986_20850# a_20000_21737# 0 $ **FLOATING
C844 m1_20830_20850# a_20000_21737# 0 $ **FLOATING
C845 m1_20674_20850# a_20000_21737# 0 $ **FLOATING
C846 m1_20518_20850# a_20000_21737# 0 $ **FLOATING
C847 m1_20362_20850# a_20000_21737# 0 $ **FLOATING
C848 m1_20206_20850# a_20000_21737# 0 $ **FLOATING
C849 m1_20050_20850# a_20000_21737# 0 $ **FLOATING
C850 m1_20000_20850# a_20000_21737# 0 $ **FLOATING
C851 m1_23154_21006# a_20000_21737# 0 $ **FLOATING
C852 m1_22998_21006# a_20000_21737# 0 $ **FLOATING
C853 m1_22842_21006# a_20000_21737# 0 $ **FLOATING
C854 m1_22686_21006# a_20000_21737# 0 $ **FLOATING
C855 m1_22530_21006# a_20000_21737# 0 $ **FLOATING
C856 m1_22374_21006# a_20000_21737# 0 $ **FLOATING
C857 m1_22218_21006# a_20000_21737# 0 $ **FLOATING
C858 m1_22062_21006# a_20000_21737# 0 $ **FLOATING
C859 m1_21906_21006# a_20000_21737# 0 $ **FLOATING
C860 m1_21750_21006# a_20000_21737# 0 $ **FLOATING
C861 m1_21594_21006# a_20000_21737# 0 $ **FLOATING
C862 m1_21438_21006# a_20000_21737# 0 $ **FLOATING
C863 m1_21282_21006# a_20000_21737# 0 $ **FLOATING
C864 m1_21126_21006# a_20000_21737# 0 $ **FLOATING
C865 m1_20970_21006# a_20000_21737# 0 $ **FLOATING
C866 m1_20814_21006# a_20000_21737# 0 $ **FLOATING
C867 m1_20658_21006# a_20000_21737# 0 $ **FLOATING
C868 m1_20502_21006# a_20000_21737# 0 $ **FLOATING
C869 m1_20346_21006# a_20000_21737# 0 $ **FLOATING
C870 m1_20190_21006# a_20000_21737# 0 $ **FLOATING
C871 m1_20034_21006# a_20000_21737# 0 $ **FLOATING
C872 m1_23294_21162# a_20000_21737# 0 $ **FLOATING
C873 m1_23138_21162# a_20000_21737# 0 $ **FLOATING
C874 m1_22982_21162# a_20000_21737# 0 $ **FLOATING
C875 m1_22826_21162# a_20000_21737# 0 $ **FLOATING
C876 m1_22670_21162# a_20000_21737# 0 $ **FLOATING
C877 m1_22514_21162# a_20000_21737# 0 $ **FLOATING
C878 m1_22358_21162# a_20000_21737# 0 $ **FLOATING
C879 m1_22202_21162# a_20000_21737# 0 $ **FLOATING
C880 m1_22046_21162# a_20000_21737# 0 $ **FLOATING
C881 m1_21890_21162# a_20000_21737# 0 $ **FLOATING
C882 m1_21734_21162# a_20000_21737# 0 $ **FLOATING
C883 m1_21578_21162# a_20000_21737# 0 $ **FLOATING
C884 m1_21422_21162# a_20000_21737# 0 $ **FLOATING
C885 m1_21266_21162# a_20000_21737# 0 $ **FLOATING
C886 m1_21110_21162# a_20000_21737# 0 $ **FLOATING
C887 m1_20954_21162# a_20000_21737# 0 $ **FLOATING
C888 m1_20798_21162# a_20000_21737# 0 $ **FLOATING
C889 m1_20642_21162# a_20000_21737# 0 $ **FLOATING
C890 m1_20486_21162# a_20000_21737# 0 $ **FLOATING
C891 m1_20330_21162# a_20000_21737# 0 $ **FLOATING
C892 m1_20174_21162# a_20000_21737# 0 $ **FLOATING
C893 m1_20018_21162# a_20000_21737# 0 $ **FLOATING
C894 m1_23246_21630# a_20000_21737# 0 $ **FLOATING
C895 m1_23090_21630# a_20000_21737# 0 $ **FLOATING
C896 m1_22934_21630# a_20000_21737# 0 $ **FLOATING
C897 m1_22778_21630# a_20000_21737# 0 $ **FLOATING
C898 m1_22622_21630# a_20000_21737# 0 $ **FLOATING
C899 m1_22466_21630# a_20000_21737# 0 $ **FLOATING
C900 m1_22310_21630# a_20000_21737# 0 $ **FLOATING
C901 m1_22154_21630# a_20000_21737# 0 $ **FLOATING
C902 m1_21998_21630# a_20000_21737# 0 $ **FLOATING
C903 m1_21842_21630# a_20000_21737# 0 $ **FLOATING
C904 m1_21686_21630# a_20000_21737# 0 $ **FLOATING
C905 m1_21530_21630# a_20000_21737# 0 $ **FLOATING
C906 m1_21374_21630# a_20000_21737# 0 $ **FLOATING
C907 m1_21218_21630# a_20000_21737# 0 $ **FLOATING
C908 m1_21062_21630# a_20000_21737# 0 $ **FLOATING
C909 m1_20906_21630# a_20000_21737# 0 $ **FLOATING
C910 m1_20750_21630# a_20000_21737# 0 $ **FLOATING
C911 m1_20594_21630# a_20000_21737# 0 $ **FLOATING
C912 m1_20438_21630# a_20000_21737# 0 $ **FLOATING
C913 m1_20282_21630# a_20000_21737# 0 $ **FLOATING
C914 m1_20126_21630# a_20000_21737# 0 $ **FLOATING
C915 m1_20000_21630# a_20000_21737# 0 $ **FLOATING
C916 m1_23210_21810# a_20000_21737# 0 $ **FLOATING
C917 m1_23110_21810# a_20000_21737# 0 $ **FLOATING
C918 m1_23010_21810# a_20000_21737# 0 $ **FLOATING
C919 m1_22910_21810# a_20000_21737# 0 $ **FLOATING
C920 m1_22810_21810# a_20000_21737# 0 $ **FLOATING
C921 m1_22710_21810# a_20000_21737# 0 $ **FLOATING
C922 m1_22610_21810# a_20000_21737# 0 $ **FLOATING
C923 m1_22510_21810# a_20000_21737# 0 $ **FLOATING
C924 m1_22410_21810# a_20000_21737# 0 $ **FLOATING
C925 m1_22310_21810# a_20000_21737# 0 $ **FLOATING
C926 m1_22210_21810# a_20000_21737# 0 $ **FLOATING
C927 m1_22110_21810# a_20000_21737# 0 $ **FLOATING
C928 m1_22010_21810# a_20000_21737# 0 $ **FLOATING
C929 m1_21910_21810# a_20000_21737# 0 $ **FLOATING
C930 m1_21810_21810# a_20000_21737# 0 $ **FLOATING
C931 m1_21710_21810# a_20000_21737# 0 $ **FLOATING
C932 m1_21610_21810# a_20000_21737# 0 $ **FLOATING
C933 m1_21510_21810# a_20000_21737# 0 $ **FLOATING
C934 m1_21410_21810# a_20000_21737# 0 $ **FLOATING
C935 m1_21310_21810# a_20000_21737# 0 $ **FLOATING
C936 m1_21210_21810# a_20000_21737# 0 $ **FLOATING
C937 m1_21110_21810# a_20000_21737# 0 $ **FLOATING
C938 m1_21010_21810# a_20000_21737# 0 $ **FLOATING
C939 m1_20910_21810# a_20000_21737# 0 $ **FLOATING
C940 m1_20810_21810# a_20000_21737# 0 $ **FLOATING
C941 m1_20710_21810# a_20000_21737# 0 $ **FLOATING
C942 m1_20610_21810# a_20000_21737# 0 $ **FLOATING
C943 m1_20510_21810# a_20000_21737# 0 $ **FLOATING
C944 m1_20410_21810# a_20000_21737# 0 $ **FLOATING
C945 m1_20310_21810# a_20000_21737# 0 $ **FLOATING
C946 m1_20210_21810# a_20000_21737# 0 $ **FLOATING
C947 m1_20110_21810# a_20000_21737# 0 $ **FLOATING
C948 m1_20010_21810# a_20000_21737# 0 $ **FLOATING
C949 m1_23270_22110# a_20000_21737# 0 $ **FLOATING
C950 m1_23170_22110# a_20000_21737# 0 $ **FLOATING
C951 m1_23070_22110# a_20000_21737# 0 $ **FLOATING
C952 m1_22970_22110# a_20000_21737# 0 $ **FLOATING
C953 m1_22870_22110# a_20000_21737# 0 $ **FLOATING
C954 m1_22770_22110# a_20000_21737# 0 $ **FLOATING
C955 m1_22670_22110# a_20000_21737# 0 $ **FLOATING
C956 m1_22570_22110# a_20000_21737# 0 $ **FLOATING
C957 m1_22470_22110# a_20000_21737# 0 $ **FLOATING
C958 m1_22370_22110# a_20000_21737# 0 $ **FLOATING
C959 m1_22270_22110# a_20000_21737# 0 $ **FLOATING
C960 m1_22170_22110# a_20000_21737# 0 $ **FLOATING
C961 m1_22070_22110# a_20000_21737# 0 $ **FLOATING
C962 m1_21970_22110# a_20000_21737# 0 $ **FLOATING
C963 m1_21870_22110# a_20000_21737# 0 $ **FLOATING
C964 m1_21770_22110# a_20000_21737# 0 $ **FLOATING
C965 m1_21670_22110# a_20000_21737# 0 $ **FLOATING
C966 m1_21570_22110# a_20000_21737# 0 $ **FLOATING
C967 m1_21470_22110# a_20000_21737# 0 $ **FLOATING
C968 m1_21370_22110# a_20000_21737# 0 $ **FLOATING
C969 m1_21270_22110# a_20000_21737# 0 $ **FLOATING
C970 m1_21170_22110# a_20000_21737# 0 $ **FLOATING
C971 m1_21070_22110# a_20000_21737# 0 $ **FLOATING
C972 m1_20970_22110# a_20000_21737# 0 $ **FLOATING
C973 m1_20870_22110# a_20000_21737# 0 $ **FLOATING
C974 m1_20770_22110# a_20000_21737# 0 $ **FLOATING
C975 m1_20670_22110# a_20000_21737# 0 $ **FLOATING
C976 m1_20570_22110# a_20000_21737# 0 $ **FLOATING
C977 m1_20470_22110# a_20000_21737# 0 $ **FLOATING
C978 m1_20370_22110# a_20000_21737# 0 $ **FLOATING
C979 m1_20270_22110# a_20000_21737# 0 $ **FLOATING
C980 m1_20170_22110# a_20000_21737# 0 $ **FLOATING
C981 m1_20070_22110# a_20000_21737# 0 $ **FLOATING
C982 m1_20000_22110# a_20000_21737# 0 $ **FLOATING
C983 m1_23182_22254# a_20000_21737# 0 $ **FLOATING
C984 m1_23026_22254# a_20000_21737# 0 $ **FLOATING
C985 m1_22870_22254# a_20000_21737# 0 $ **FLOATING
C986 m1_22714_22254# a_20000_21737# 0 $ **FLOATING
C987 m1_22558_22254# a_20000_21737# 0 $ **FLOATING
C988 m1_22402_22254# a_20000_21737# 0 $ **FLOATING
C989 m1_22246_22254# a_20000_21737# 0 $ **FLOATING
C990 m1_22090_22254# a_20000_21737# 0 $ **FLOATING
C991 m1_21934_22254# a_20000_21737# 0 $ **FLOATING
C992 m1_21778_22254# a_20000_21737# 0 $ **FLOATING
C993 m1_21622_22254# a_20000_21737# 0 $ **FLOATING
C994 m1_21466_22254# a_20000_21737# 0 $ **FLOATING
C995 m1_21310_22254# a_20000_21737# 0 $ **FLOATING
C996 m1_21154_22254# a_20000_21737# 0 $ **FLOATING
C997 m1_20998_22254# a_20000_21737# 0 $ **FLOATING
C998 m1_20842_22254# a_20000_21737# 0 $ **FLOATING
C999 m1_20686_22254# a_20000_21737# 0 $ **FLOATING
C1000 m1_20530_22254# a_20000_21737# 0 $ **FLOATING
C1001 m1_20374_22254# a_20000_21737# 0 $ **FLOATING
C1002 m1_20218_22254# a_20000_21737# 0 $ **FLOATING
C1003 m1_20062_22254# a_20000_21737# 0 $ **FLOATING
C1004 m1_20000_22254# a_20000_21737# 0 $ **FLOATING
C1005 m1_23290_22722# a_20000_21737# 0 $ **FLOATING
C1006 m1_23134_22722# a_20000_21737# 0 $ **FLOATING
C1007 m1_22978_22722# a_20000_21737# 0 $ **FLOATING
C1008 m1_22822_22722# a_20000_21737# 0 $ **FLOATING
C1009 m1_22666_22722# a_20000_21737# 0 $ **FLOATING
C1010 m1_22510_22722# a_20000_21737# 0 $ **FLOATING
C1011 m1_22354_22722# a_20000_21737# 0 $ **FLOATING
C1012 m1_22198_22722# a_20000_21737# 0 $ **FLOATING
C1013 m1_22042_22722# a_20000_21737# 0 $ **FLOATING
C1014 m1_21886_22722# a_20000_21737# 0 $ **FLOATING
C1015 m1_21730_22722# a_20000_21737# 0 $ **FLOATING
C1016 m1_21574_22722# a_20000_21737# 0 $ **FLOATING
C1017 m1_21418_22722# a_20000_21737# 0 $ **FLOATING
C1018 m1_21262_22722# a_20000_21737# 0 $ **FLOATING
C1019 m1_21106_22722# a_20000_21737# 0 $ **FLOATING
C1020 m1_20950_22722# a_20000_21737# 0 $ **FLOATING
C1021 m1_20794_22722# a_20000_21737# 0 $ **FLOATING
C1022 m1_20638_22722# a_20000_21737# 0 $ **FLOATING
C1023 m1_20482_22722# a_20000_21737# 0 $ **FLOATING
C1024 m1_20326_22722# a_20000_21737# 0 $ **FLOATING
C1025 m1_20170_22722# a_20000_21737# 0 $ **FLOATING
C1026 m1_20014_22722# a_20000_21737# 0 $ **FLOATING
C1027 m1_109698_65466# a_20000_21737# 0 $ **FLOATING
C1028 m1_109542_65466# a_20000_21737# 0 $ **FLOATING
C1029 m1_109386_65466# a_20000_21737# 0 $ **FLOATING
C1030 m1_109230_65466# a_20000_21737# 0 $ **FLOATING
C1031 m1_109074_65466# a_20000_21737# 0 $ **FLOATING
C1032 m1_108918_65466# a_20000_21737# 0 $ **FLOATING
C1033 m1_108762_65466# a_20000_21737# 0 $ **FLOATING
C1034 m1_108606_65466# a_20000_21737# 0 $ **FLOATING
C1035 m1_108450_65466# a_20000_21737# 0 $ **FLOATING
C1036 m1_108294_65466# a_20000_21737# 0 $ **FLOATING
C1037 m1_108138_65466# a_20000_21737# 0 $ **FLOATING
C1038 m1_107982_65466# a_20000_21737# 0 $ **FLOATING
C1039 m1_107826_65466# a_20000_21737# 0 $ **FLOATING
C1040 m1_107670_65466# a_20000_21737# 0 $ **FLOATING
C1041 m1_107514_65466# a_20000_21737# 0 $ **FLOATING
C1042 m1_107358_65466# a_20000_21737# 0 $ **FLOATING
C1043 m1_107202_65466# a_20000_21737# 0 $ **FLOATING
C1044 m1_109682_65622# a_20000_21737# 0 $ **FLOATING
C1045 m1_109490_65710# a_20000_21737# 0 $ **FLOATING
C1046 m1_109390_65710# a_20000_21737# 0 $ **FLOATING
C1047 m1_109290_65710# a_20000_21737# 0 $ **FLOATING
C1048 m1_109190_65710# a_20000_21737# 0 $ **FLOATING
C1049 m1_109090_65710# a_20000_21737# 0 $ **FLOATING
C1050 m1_108990_65710# a_20000_21737# 0 $ **FLOATING
C1051 m1_108890_65710# a_20000_21737# 0 $ **FLOATING
C1052 m1_108790_65710# a_20000_21737# 0 $ **FLOATING
C1053 m1_108690_65710# a_20000_21737# 0 $ **FLOATING
C1054 m1_108590_65710# a_20000_21737# 0 $ **FLOATING
C1055 m1_108490_65710# a_20000_21737# 0 $ **FLOATING
C1056 m1_108390_65710# a_20000_21737# 0 $ **FLOATING
C1057 m1_108290_65710# a_20000_21737# 0 $ **FLOATING
C1058 m1_108190_65710# a_20000_21737# 0 $ **FLOATING
C1059 m1_108090_65710# a_20000_21737# 0 $ **FLOATING
C1060 m1_107990_65710# a_20000_21737# 0 $ **FLOATING
C1061 m1_107890_65710# a_20000_21737# 0 $ **FLOATING
C1062 m1_107790_65710# a_20000_21737# 0 $ **FLOATING
C1063 m1_107690_65710# a_20000_21737# 0 $ **FLOATING
C1064 m1_107590_65710# a_20000_21737# 0 $ **FLOATING
C1065 m1_107490_65710# a_20000_21737# 0 $ **FLOATING
C1066 m1_107390_65710# a_20000_21737# 0 $ **FLOATING
C1067 m1_107290_65710# a_20000_21737# 0 $ **FLOATING
C1068 m1_107200_65710# a_20000_21737# 0 $ **FLOATING
C1069 m1_109666_65778# a_20000_21737# 0 $ **FLOATING
C1070 m1_109650_65934# a_20000_21737# 0 $ **FLOATING
C1071 m1_109634_66090# a_20000_21737# 0 $ **FLOATING
C1072 m1_109478_66090# a_20000_21737# 0 $ **FLOATING
C1073 m1_109322_66090# a_20000_21737# 0 $ **FLOATING
C1074 m1_109166_66090# a_20000_21737# 0 $ **FLOATING
C1075 m1_109010_66090# a_20000_21737# 0 $ **FLOATING
C1076 m1_108854_66090# a_20000_21737# 0 $ **FLOATING
C1077 m1_108698_66090# a_20000_21737# 0 $ **FLOATING
C1078 m1_108542_66090# a_20000_21737# 0 $ **FLOATING
C1079 m1_108386_66090# a_20000_21737# 0 $ **FLOATING
C1080 m1_108230_66090# a_20000_21737# 0 $ **FLOATING
C1081 m1_108074_66090# a_20000_21737# 0 $ **FLOATING
C1082 m1_107918_66090# a_20000_21737# 0 $ **FLOATING
C1083 m1_107762_66090# a_20000_21737# 0 $ **FLOATING
C1084 m1_107606_66090# a_20000_21737# 0 $ **FLOATING
C1085 m1_107450_66090# a_20000_21737# 0 $ **FLOATING
C1086 m1_107294_66090# a_20000_21737# 0 $ **FLOATING
C1087 m1_107200_66090# a_20000_21737# 0 $ **FLOATING
C1088 m1_109618_66246# a_20000_21737# 0 $ **FLOATING
C1089 m1_109462_66246# a_20000_21737# 0 $ **FLOATING
C1090 m1_109306_66246# a_20000_21737# 0 $ **FLOATING
C1091 m1_109150_66246# a_20000_21737# 0 $ **FLOATING
C1092 m1_108994_66246# a_20000_21737# 0 $ **FLOATING
C1093 m1_108838_66246# a_20000_21737# 0 $ **FLOATING
C1094 m1_108682_66246# a_20000_21737# 0 $ **FLOATING
C1095 m1_108526_66246# a_20000_21737# 0 $ **FLOATING
C1096 m1_108370_66246# a_20000_21737# 0 $ **FLOATING
C1097 m1_108214_66246# a_20000_21737# 0 $ **FLOATING
C1098 m1_108058_66246# a_20000_21737# 0 $ **FLOATING
C1099 m1_107902_66246# a_20000_21737# 0 $ **FLOATING
C1100 m1_107746_66246# a_20000_21737# 0 $ **FLOATING
C1101 m1_107200_66388# a_20000_21737# 1.31212e-16
C1102 m1_109570_66714# a_20000_21737# 0 $ **FLOATING
C1103 m1_109414_66714# a_20000_21737# 0 $ **FLOATING
C1104 m1_109258_66714# a_20000_21737# 0 $ **FLOATING
C1105 m1_109102_66714# a_20000_21737# 0 $ **FLOATING
C1106 m1_108946_66714# a_20000_21737# 0 $ **FLOATING
C1107 m1_108790_66714# a_20000_21737# 0 $ **FLOATING
C1108 m1_108634_66714# a_20000_21737# 0 $ **FLOATING
C1109 m1_108478_66714# a_20000_21737# 0 $ **FLOATING
C1110 m1_108322_66714# a_20000_21737# 0 $ **FLOATING
C1111 m1_108166_66714# a_20000_21737# 0 $ **FLOATING
C1112 m1_108010_66714# a_20000_21737# 0 $ **FLOATING
C1113 m1_107854_66714# a_20000_21737# 0 $ **FLOATING
C1114 m1_107698_66714# a_20000_21737# 0 $ **FLOATING
C1115 m1_107542_66714# a_20000_21737# 0 $ **FLOATING
C1116 m1_107386_66714# a_20000_21737# 0 $ **FLOATING
C1117 m1_107230_66714# a_20000_21737# 0 $ **FLOATING
C1118 m1_109554_66870# a_20000_21737# 0 $ **FLOATING
C1119 m1_109398_66870# a_20000_21737# 0 $ **FLOATING
C1120 m1_109242_66870# a_20000_21737# 0 $ **FLOATING
C1121 m1_109086_66870# a_20000_21737# 0 $ **FLOATING
C1122 m1_108930_66870# a_20000_21737# 0 $ **FLOATING
C1123 m1_108774_66870# a_20000_21737# 0 $ **FLOATING
C1124 m1_108618_66870# a_20000_21737# 0 $ **FLOATING
C1125 m1_108462_66870# a_20000_21737# 0 $ **FLOATING
C1126 m1_108306_66870# a_20000_21737# 0 $ **FLOATING
C1127 m1_108150_66870# a_20000_21737# 0 $ **FLOATING
C1128 m1_107994_66870# a_20000_21737# 0 $ **FLOATING
C1129 m1_107838_66870# a_20000_21737# 0 $ **FLOATING
C1130 m1_107682_66870# a_20000_21737# 0 $ **FLOATING
C1131 m1_107526_66870# a_20000_21737# 0 $ **FLOATING
C1132 m1_107370_66870# a_20000_21737# 0 $ **FLOATING
C1133 m1_107214_66870# a_20000_21737# 0 $ **FLOATING
C1134 m1_109694_67026# a_20000_21737# 0 $ **FLOATING
C1135 m1_109570_67110# a_20000_21737# 0 $ **FLOATING
C1136 m1_109690_67210# a_20000_21737# 0 $ **FLOATING
C1137 m1_109590_67210# a_20000_21737# 0 $ **FLOATING
C1138 m1_107200_67350# a_20000_21737# 3.5300800000000001e-16
C1139 m1_107200_67424# a_20000_21737# 3.7989600000000005e-16
C1140 m1_109646_67494# a_20000_21737# 0 $ **FLOATING
C1141 m1_109490_67494# a_20000_21737# 0 $ **FLOATING
C1142 m1_109334_67494# a_20000_21737# 0 $ **FLOATING
C1143 m1_109178_67494# a_20000_21737# 0 $ **FLOATING
C1144 m1_109022_67494# a_20000_21737# 0 $ **FLOATING
C1145 m1_108866_67494# a_20000_21737# 0 $ **FLOATING
C1146 m1_108750_67510# a_20000_21737# 0 $ **FLOATING
C1147 li_23150_20140# a_20000_21737# 0 $ **FLOATING
C1148 li_22370_20140# a_20000_21737# 0 $ **FLOATING
C1149 li_21590_20140# a_20000_21737# 0 $ **FLOATING
C1150 li_20810_20140# a_20000_21737# 0 $ **FLOATING
C1151 li_20030_20140# a_20000_21737# 0 $ **FLOATING
C1152 li_23102_20850# a_20000_21737# 0 $ **FLOATING
C1153 li_22886_20850# a_20000_21737# 0 $ **FLOATING
C1154 li_22670_20850# a_20000_21737# 0 $ **FLOATING
C1155 li_22454_20850# a_20000_21737# 0 $ **FLOATING
C1156 li_22238_20850# a_20000_21737# 0 $ **FLOATING
C1157 li_22022_20850# a_20000_21737# 0 $ **FLOATING
C1158 li_21806_20850# a_20000_21737# 0 $ **FLOATING
C1159 li_21590_20850# a_20000_21737# 0 $ **FLOATING
C1160 li_21374_20850# a_20000_21737# 0 $ **FLOATING
C1161 li_21158_20850# a_20000_21737# 0 $ **FLOATING
C1162 li_20942_20850# a_20000_21737# 0 $ **FLOATING
C1163 li_20726_20850# a_20000_21737# 0 $ **FLOATING
C1164 li_20510_20850# a_20000_21737# 0 $ **FLOATING
C1165 li_20294_20850# a_20000_21737# 0 $ **FLOATING
C1166 li_20078_20850# a_20000_21737# 0 $ **FLOATING
C1167 li_23242_21066# a_20000_21737# 0 $ **FLOATING
C1168 li_23026_21066# a_20000_21737# 0 $ **FLOATING
C1169 li_22810_21066# a_20000_21737# 0 $ **FLOATING
C1170 li_22594_21066# a_20000_21737# 0 $ **FLOATING
C1171 li_22378_21066# a_20000_21737# 0 $ **FLOATING
C1172 li_22162_21066# a_20000_21737# 0 $ **FLOATING
C1173 li_21946_21066# a_20000_21737# 0 $ **FLOATING
C1174 li_21730_21066# a_20000_21737# 0 $ **FLOATING
C1175 li_21514_21066# a_20000_21737# 0 $ **FLOATING
C1176 li_21298_21066# a_20000_21737# 0 $ **FLOATING
C1177 li_21082_21066# a_20000_21737# 0 $ **FLOATING
C1178 li_20866_21066# a_20000_21737# 0 $ **FLOATING
C1179 li_20650_21066# a_20000_21737# 0 $ **FLOATING
C1180 li_20434_21066# a_20000_21737# 0 $ **FLOATING
C1181 li_20218_21066# a_20000_21737# 0 $ **FLOATING
C1182 li_20002_21066# a_20000_21737# 0 $ **FLOATING
C1183 li_109042_65130# a_20000_21737# 0 $ **FLOATING
C1184 li_108826_65130# a_20000_21737# 0 $ **FLOATING
C1185 li_109330_65250# a_20000_21737# 0 $ **FLOATING
C1186 li_108966_65346# a_20000_21737# 0 $ **FLOATING
C1187 li_108102_65346# a_20000_21737# 0 $ **FLOATING
C1188 li_107886_65346# a_20000_21737# 0 $ **FLOATING
C1189 li_107670_65346# a_20000_21737# 0 $ **FLOATING
C1190 li_107454_65346# a_20000_21737# 0 $ **FLOATING
C1191 li_107238_65346# a_20000_21737# 0 $ **FLOATING
C1192 li_109470_65650# a_20000_21737# 0 $ **FLOATING
C1193 li_109106_65562# a_20000_21737# 0 $ **FLOATING
C1194 li_108890_65562# a_20000_21737# 0 $ **FLOATING
C1195 li_108026_65562# a_20000_21737# 0 $ **FLOATING
C1196 li_107810_65562# a_20000_21737# 0 $ **FLOATING
C1197 li_107594_65562# a_20000_21737# 0 $ **FLOATING
C1198 li_107378_65562# a_20000_21737# 0 $ **FLOATING
C1199 li_107200_65562# a_20000_21737# 0 $ **FLOATING
C1200 li_109246_65778# a_20000_21737# 0 $ **FLOATING
C1201 li_109030_65778# a_20000_21737# 0 $ **FLOATING
C1202 li_108814_65778# a_20000_21737# 0 $ **FLOATING
C1203 li_109170_65994# a_20000_21737# 0 $ **FLOATING
C1204 li_108954_65994# a_20000_21737# 0 $ **FLOATING
C1205 li_109410_66160# a_20000_21737# 0 $ **FLOATING
C1206 li_109094_66210# a_20000_21737# 0 $ **FLOATING
C1207 li_108878_66210# a_20000_21737# 0 $ **FLOATING
C1208 li_109018_66426# a_20000_21737# 0 $ **FLOATING
C1209 li_108802_66426# a_20000_21737# 0 $ **FLOATING
C1210 li_108014_66210# a_20000_21737# 0 $ **FLOATING
C1211 li_107798_66210# a_20000_21737# 0 $ **FLOATING
C1212 li_107582_66210# a_20000_21737# 0 $ **FLOATING
C1213 li_107366_66210# a_20000_21737# 0 $ **FLOATING
C1214 li_107200_66210# a_20000_21737# 0 $ **FLOATING
C1215 li_109158_66642# a_20000_21737# 0 $ **FLOATING
C1216 li_108942_66642# a_20000_21737# 0 $ **FLOATING
C1217 li_109550_66940# a_20000_21737# 0 $ **FLOATING
C1218 li_109082_66858# a_20000_21737# 0 $ **FLOATING
C1219 li_108866_66858# a_20000_21737# 0 $ **FLOATING
C1220 li_108002_66858# a_20000_21737# 0 $ **FLOATING
C1221 li_107786_66858# a_20000_21737# 0 $ **FLOATING
C1222 li_107570_66858# a_20000_21737# 0 $ **FLOATING
C1223 li_107354_66858# a_20000_21737# 0 $ **FLOATING
C1224 li_107200_66858# a_20000_21737# 0 $ **FLOATING
C1225 li_109222_67074# a_20000_21737# 0 $ **FLOATING
C1226 li_109006_67074# a_20000_21737# 0 $ **FLOATING
C1227 li_108790_67074# a_20000_21737# 0 $ **FLOATING
C1228 li_109146_67290# a_20000_21737# 0 $ **FLOATING
C1229 li_108930_67290# a_20000_21737# 0 $ **FLOATING
C1230 li_109286_67506# a_20000_21737# 0 $ **FLOATING
C1231 li_109070_67506# a_20000_21737# 0 $ **FLOATING
C1232 li_108854_67506# a_20000_21737# 0 $ **FLOATING
C1233 li_107990_67506# a_20000_21737# 0 $ **FLOATING
C1234 li_107774_67506# a_20000_21737# 0 $ **FLOATING
C1235 li_107558_67506# a_20000_21737# 0 $ **FLOATING
C1236 li_107342_67506# a_20000_21737# 0 $ **FLOATING
C1237 li_107200_67506# a_20000_21737# 0 $ **FLOATING
C1238 a_22644_20000# a_20000_21737# 0 $ **FLOATING
C1239 a_22386_20000# a_20000_21737# 0 $ **FLOATING
C1240 a_22388_20188# a_20000_21737# 0 $ **FLOATING
C1241 a_22436_20404# a_20000_21737# 0 $ **FLOATING
C1242 a_22398_20636# a_20000_21737# 0 $ **FLOATING
C1243 a_21508_20000# a_20000_21737# 0 $ **FLOATING
C1244 a_21260_20000# a_20000_21737# 0 $ **FLOATING
C1245 a_21270_20456# a_20000_21737# 0 $ **FLOATING
C1246 a_21318_20636# a_20000_21737# 0 $ **FLOATING
C1247 a_20372_20000# a_20000_21737# 0 $ **FLOATING
C1248 a_20152_20100# a_20000_21737# 0 $ **FLOATING
C1249 a_20142_20276# a_20000_21737# 0 $ **FLOATING
C1250 a_20190_20456# a_20000_21737# 0 $ **FLOATING
C1251 a_20000_20000# a_20000_21737# 0 $ **FLOATING
C1252 a_23180_20836# a_20000_21737# 0 $ **FLOATING
C1253 a_22964_20836# a_20000_21737# 0 $ **FLOATING
C1254 a_22748_20836# a_20000_21737# 0 $ **FLOATING
C1255 a_22532_20836# a_20000_21737# 0 $ **FLOATING
C1256 a_22316_20836# a_20000_21737# 0 $ **FLOATING
C1257 a_22100_20836# a_20000_21737# 0 $ **FLOATING
C1258 a_21884_20836# a_20000_21737# 0 $ **FLOATING
C1259 a_21668_20836# a_20000_21737# 0 $ **FLOATING
C1260 a_21452_20836# a_20000_21737# 0 $ **FLOATING
C1261 a_21236_20836# a_20000_21737# 0 $ **FLOATING
C1262 a_21020_20836# a_20000_21737# 0 $ **FLOATING
C1263 a_20804_20836# a_20000_21737# 0 $ **FLOATING
C1264 a_20588_20836# a_20000_21737# 0 $ **FLOATING
C1265 a_20372_20836# a_20000_21737# 0 $ **FLOATING
C1266 a_20156_20836# a_20000_21737# 0 $ **FLOATING
C1267 a_20000_20836# a_20000_21737# 0 $ **FLOATING
C1268 a_23228_21052# a_20000_21737# 0 $ **FLOATING
C1269 a_23012_21052# a_20000_21737# 0 $ **FLOATING
C1270 a_22796_21052# a_20000_21737# 0 $ **FLOATING
C1271 a_22580_21052# a_20000_21737# 0 $ **FLOATING
C1272 a_22364_21052# a_20000_21737# 0 $ **FLOATING
C1273 a_22148_21052# a_20000_21737# 0 $ **FLOATING
C1274 a_21932_21052# a_20000_21737# 0 $ **FLOATING
C1275 a_21716_21052# a_20000_21737# 0 $ **FLOATING
C1276 a_21500_21052# a_20000_21737# 0 $ **FLOATING
C1277 a_21284_21052# a_20000_21737# 0 $ **FLOATING
C1278 a_21068_21052# a_20000_21737# 0 $ **FLOATING
C1279 a_20852_21052# a_20000_21737# 0 $ **FLOATING
C1280 a_20636_21052# a_20000_21737# 0 $ **FLOATING
C1281 a_20420_21052# a_20000_21737# 0 $ **FLOATING
C1282 a_20204_21052# a_20000_21737# 0 $ **FLOATING
C1283 a_20000_21052# a_20000_21737# 0 $ **FLOATING
C1284 a_22591_23093# a_20000_21737# 2.3011199999999999e-16 $ **FLOATING
C1285 a_22039_23093# a_20000_21737# 9.5162400000000014e-17 $ **FLOATING
C1286 a_20751_23093# a_20000_21737# 3.0544800000000003e-16 $ **FLOATING
C1287 a_20000_23093# a_20000_21737# 2.2618000000000006e-16 $ **FLOATING
C1288 a_109674_65100# a_20000_21737# 0 $ **FLOATING
C1289 a_109494_65100# a_20000_21737# 0 $ **FLOATING
C1290 a_109268_65116# a_20000_21737# 0 $ **FLOATING
C1291 a_109052_65116# a_20000_21737# 0 $ **FLOATING
C1292 a_108402_65100# a_20000_21737# 3.4029800000000001e-18 $ **FLOATING
C1293 a_109636_65288# a_20000_21737# 0 $ **FLOATING
C1294 a_109316_65332# a_20000_21737# 0 $ **FLOATING
C1295 a_109100_65332# a_20000_21737# 0 $ **FLOATING
C1296 a_108884_65332# a_20000_21737# 0 $ **FLOATING
C1297 a_109364_65548# a_20000_21737# 0 $ **FLOATING
C1298 a_109148_65548# a_20000_21737# 0 $ **FLOATING
C1299 a_108932_65548# a_20000_21737# 0 $ **FLOATING
C1300 a_109412_65764# a_20000_21737# 0 $ **FLOATING
C1301 a_109196_65764# a_20000_21737# 0 $ **FLOATING
C1302 a_108980_65764# a_20000_21737# 0 $ **FLOATING
C1303 a_108345_65100# a_20000_21737# 1.3333499999999999e-15 $ **FLOATING
C1304 a_109244_65980# a_20000_21737# 0 $ **FLOATING
C1305 a_109028_65980# a_20000_21737# 0 $ **FLOATING
C1306 a_109508_66196# a_20000_21737# 0 $ **FLOATING
C1307 a_109292_66196# a_20000_21737# 0 $ **FLOATING
C1308 a_109076_66196# a_20000_21737# 0 $ **FLOATING
C1309 a_108860_66196# a_20000_21737# 0 $ **FLOATING
C1310 a_109556_66412# a_20000_21737# 0 $ **FLOATING
C1311 a_109340_66412# a_20000_21737# 0 $ **FLOATING
C1312 a_109124_66412# a_20000_21737# 0 $ **FLOATING
C1313 a_108908_66412# a_20000_21737# 0 $ **FLOATING
C1314 a_109604_66628# a_20000_21737# 0 $ **FLOATING
C1315 a_109388_66628# a_20000_21737# 0 $ **FLOATING
C1316 a_109172_66628# a_20000_21737# 0 $ **FLOATING
C1317 a_108956_66628# a_20000_21737# 0 $ **FLOATING
C1318 a_109652_66844# a_20000_21737# 0 $ **FLOATING
C1319 a_109436_66844# a_20000_21737# 0 $ **FLOATING
C1320 a_109220_66844# a_20000_21737# 0 $ **FLOATING
C1321 a_109004_66844# a_20000_21737# 0 $ **FLOATING
C1322 a_109484_67060# a_20000_21737# 0 $ **FLOATING
C1323 a_109268_67060# a_20000_21737# 0 $ **FLOATING
C1324 a_109052_67060# a_20000_21737# 0 $ **FLOATING
C1325 a_108345_66276# a_20000_21737# 1.0766500000000002e-15 $ **FLOATING
C1326 a_109532_67276# a_20000_21737# 0 $ **FLOATING
C1327 a_109316_67276# a_20000_21737# 0 $ **FLOATING
C1328 a_109100_67276# a_20000_21737# 0 $ **FLOATING
C1329 a_108884_67276# a_20000_21737# 0 $ **FLOATING
C1330 a_109044_67560# a_20000_21737# 0 $ **FLOATING
C1331 a_108389_67263# a_20000_21737# 2.6014299999999998e-16 $ **FLOATING
C1332 a_108332_65715# a_20000_21737# 3.6434400000000007e-15 $ **FLOATING
C1333 w_19964_21727# a_20000_21737# 2.1808900000000003e-14 $ **FLOATING
C1334 w_19964_23083# a_20000_21737# 1.3847000000000001e-14 $ **FLOATING
C1335 w_107200_65100# a_20000_21737# 2.0932100000000003e-15 $ **FLOATING
C1336 w_107200_66216# a_20000_21737# 3.0500900000000002e-15 $ **FLOATING
C1337 w_107200_67548# a_20000_21737# 2.3743199999999998e-16
C1338 a_20000_21737# a_20000_21737# 0 $ **FLOATING
.ends
