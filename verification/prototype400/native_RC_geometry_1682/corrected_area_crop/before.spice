* NGSPICE file created from RC_Area_Crop.ext - technology: sky130A

.subckt RC_Area_Crop
* OPENPLL_ORIGIN X0 sky130_fd_pr__nfet_01v8 99003 81603 99004 81604
X0 a_97400_80515# w_97364_80959# a_97400_80515# a_97400_80515# sky130_fd_pr__nfet_01v8 ad=0.143 pd=1.62 as=0 ps=0 w=0.55 l=4.73
* OPENPLL_ORIGIN X1 sky130_fd_pr__pfet_01v8 12098 36724 12099 36725
X1 a_12043_36376# a_12058_35815# a_12043_36376# w_11978_36316# sky130_fd_pr__pfet_01v8 ad=0.275 pd=2.55 as=0 ps=0 w=1 l=1
* OPENPLL_ORIGIN X2 sky130_fd_pr__nfet_01v8 97400 80719 97401 80720
X2 a_97400_80515# w_97364_80959# a_97400_80515# a_97400_80515# sky130_fd_pr__nfet_01v8 ad=0.143 pd=1.62 as=0 ps=0 w=0.55 l=3.27
* OPENPLL_ORIGIN X3 sky130_fd_pr__pfet_01v8_hvt 98267 80995 98268 80996
X3 w_97364_80959# a_97400_80515# w_97364_80959# w_97364_80959# sky130_fd_pr__pfet_01v8_hvt ad=0.2262 pd=2.26 as=0 ps=0 w=0.87 l=1.97
* OPENPLL_ORIGIN X4 sky130_fd_pr__pfet_01v8_hvt 98635 80175 98636 80176
X4 w_97364_79964# a_97400_80515# w_97364_79964# w_97364_79964# sky130_fd_pr__pfet_01v8_hvt ad=0.2262 pd=2.26 as=0 ps=0 w=0.87 l=4.73
* OPENPLL_ORIGIN X5 sky130_fd_pr__nfet_01v8 98635 81603 98636 81604
X5 a_97400_80515# w_97364_80959# a_97400_80515# a_97400_80515# sky130_fd_pr__nfet_01v8 ad=0.143 pd=1.62 as=0 ps=0 w=0.55 l=0.59
* OPENPLL_ORIGIN X6 sky130_fd_pr__nfet_01v8 97531 80515 97532 80516
X6 a_97400_80515# w_97364_79964# a_97400_80515# a_97400_80515# sky130_fd_pr__nfet_01v8 ad=0.143 pd=1.62 as=0 ps=0 w=0.55 l=4.73
* OPENPLL_ORIGIN X7 sky130_fd_pr__pfet_01v8_hvt 100107 81263 100108 81264
X7 w_97364_80959# a_97400_80515# w_97364_80959# w_97364_80959# sky130_fd_pr__pfet_01v8_hvt ad=0.2262 pd=2.26 as=0 ps=0 w=0.87 l=2.53
* OPENPLL_ORIGIN X8 sky130_fd_pr__pfet_01v8_hvt 99003 81263 99004 81264
X8 w_97364_80959# a_97400_80515# w_97364_80959# w_97364_80959# sky130_fd_pr__pfet_01v8_hvt ad=0.2262 pd=2.26 as=0 ps=0 w=0.87 l=4.73
* OPENPLL_ORIGIN X9 sky130_fd_pr__nfet_01v8_lvt 12111 37147 12112 37148
X9 a_12058_35815# a_12043_36376# a_12058_35815# a_97400_80515# sky130_fd_pr__nfet_01v8_lvt ad=0.1113 pd=1.37 as=0 ps=0 w=0.42 l=1
* OPENPLL_ORIGIN X10 sky130_fd_pr__pfet_01v8_hvt 97400 80000 97401 80001
X10 w_97364_79964# a_97400_80000# w_97364_79964# w_97364_79964# sky130_fd_pr__pfet_01v8_hvt ad=0.1053 pd=1.33 as=0 ps=0 w=0.405 l=1.57
* OPENPLL_ORIGIN X11 sky130_fd_pr__pfet_01v8_hvt 98635 81263 98636 81264
X11 w_97364_80959# a_97400_80515# w_97364_80959# w_97364_80959# sky130_fd_pr__pfet_01v8_hvt ad=0.2262 pd=2.26 as=0 ps=0 w=0.87 l=0.59
* OPENPLL_ORIGIN X12 sky130_fd_pr__pfet_01v8 12098 36376 12099 36377
X12 a_12043_36376# a_12058_35815# a_12043_36376# w_11978_36316# sky130_fd_pr__pfet_01v8 ad=0.275 pd=2.55 as=0 ps=0 w=1 l=1
* OPENPLL_ORIGIN X13 sky130_fd_pr__nfet_01v8 100107 80719 100108 80720
X13 a_97400_80515# w_97364_80959# a_97400_80515# a_97400_80515# sky130_fd_pr__nfet_01v8 ad=0.143 pd=1.62 as=0 ps=0 w=0.55 l=2.69
* OPENPLL_ORIGIN X14 sky130_fd_pr__pfet_01v8_hvt 97531 80175 97532 80176
X14 w_97364_79964# a_97400_80515# w_97364_79964# w_97364_79964# sky130_fd_pr__pfet_01v8_hvt ad=0.2262 pd=2.26 as=0 ps=0 w=0.87 l=4.73
* OPENPLL_ORIGIN X15 sky130_fd_pr__nfet_01v8_lvt 12111 35815 12112 35816
X15 a_12058_35815# a_12111_35775# a_12058_35815# a_97400_80515# sky130_fd_pr__nfet_01v8_lvt ad=0.1113 pd=1.37 as=0 ps=0 w=0.42 l=1
* OPENPLL_ORIGIN X16 sky130_fd_pr__nfet_01v8 97531 81603 97532 81604
X16 a_97400_80515# w_97364_80959# a_97400_80515# a_97400_80515# sky130_fd_pr__nfet_01v8 ad=0.143 pd=1.62 as=0 ps=0 w=0.55 l=4.73
* OPENPLL_ORIGIN X17 sky130_fd_pr__pfet_01v8_hvt 97400 80995 97401 80996
X17 w_97364_80959# a_97400_80515# w_97364_80959# w_97364_80959# sky130_fd_pr__pfet_01v8_hvt ad=0.2262 pd=2.26 as=0 ps=0 w=0.87 l=3.11
* OPENPLL_ORIGIN X18 sky130_fd_pr__nfet_01v8 99003 80719 99004 80720
X18 a_97400_80515# w_97364_80959# a_97400_80515# a_97400_80515# sky130_fd_pr__nfet_01v8 ad=0.143 pd=1.62 as=0 ps=0 w=0.55 l=4.73
* OPENPLL_ORIGIN X19 sky130_fd_pr__nfet_01v8 99739 80515 99740 80516
X19 a_97400_80515# w_97364_79964# a_97400_80515# a_97400_80515# sky130_fd_pr__nfet_01v8 ad=0.143 pd=1.62 as=0 ps=0 w=0.55 l=4.73
* OPENPLL_ORIGIN X20 sky130_fd_pr__nfet_01v8_lvt 12111 37401 12112 37402
X20 a_12058_35815# a_12043_37708# a_12058_35815# a_97400_80515# sky130_fd_pr__nfet_01v8_lvt ad=0.1113 pd=1.37 as=0 ps=0 w=0.42 l=1
* OPENPLL_ORIGIN X21 sky130_fd_pr__nfet_01v8 98267 80719 98268 80720
X21 a_97400_80515# w_97364_80959# a_97400_80515# a_97400_80515# sky130_fd_pr__nfet_01v8 ad=0.143 pd=1.62 as=0 ps=0 w=0.55 l=1.97
* OPENPLL_ORIGIN X22 sky130_fd_pr__pfet_01v8_hvt 97531 81263 97532 81264
X22 w_97364_80959# a_97400_80515# w_97364_80959# w_97364_80959# sky130_fd_pr__pfet_01v8_hvt ad=0.2262 pd=2.26 as=0 ps=0 w=0.87 l=4.73
* OPENPLL_ORIGIN X23 sky130_fd_pr__pfet_01v8_hvt 100107 80000 100108 80001
X23 w_97364_79964# a_100107_80000# w_97364_79964# w_97364_79964# sky130_fd_pr__pfet_01v8_hvt ad=0.1053 pd=1.33 as=0 ps=0 w=0.405 l=1.28
* OPENPLL_ORIGIN X24 sky130_fd_pr__nfet_01v8_lvt 12111 36069 12112 36070
X24 a_12058_35815# a_12043_36376# a_12058_35815# a_97400_80515# sky130_fd_pr__nfet_01v8_lvt ad=0.1113 pd=1.37 as=0 ps=0 w=0.42 l=1
* OPENPLL_ORIGIN X25 sky130_fd_pr__pfet_01v8_hvt 99003 80000 99004 80001
X25 w_97364_79964# a_99003_80000# w_97364_79964# w_97364_79964# sky130_fd_pr__pfet_01v8_hvt ad=0.1053 pd=1.33 as=0 ps=0 w=0.405 l=4.73
* OPENPLL_ORIGIN X26 sky130_fd_pr__pfet_01v8_hvt 99739 80175 99740 80176
X26 w_97364_79964# a_97400_80515# w_97364_79964# w_97364_79964# sky130_fd_pr__pfet_01v8_hvt ad=0.2262 pd=2.26 as=0 ps=0 w=0.87 l=4.73
* OPENPLL_ORIGIN X27 sky130_fd_pr__pfet_01v8_hvt 100107 80995 100108 80996
X27 w_97364_80959# a_97400_80515# w_97364_80959# w_97364_80959# sky130_fd_pr__pfet_01v8_hvt ad=0.2262 pd=2.26 as=0 ps=0 w=0.87 l=2.53
* OPENPLL_ORIGIN X28 sky130_fd_pr__nfet_01v8 98635 80515 98636 80516
X28 a_97400_80515# w_97364_79964# a_97400_80515# a_97400_80515# sky130_fd_pr__nfet_01v8 ad=0.143 pd=1.62 as=0 ps=0 w=0.55 l=4.73
* OPENPLL_ORIGIN X29 sky130_fd_pr__pfet_01v8 12098 38056 12099 38057
X29 a_12043_37708# a_12098_38030# a_12043_37708# w_11978_37648# sky130_fd_pr__pfet_01v8 ad=0.0605 pd=0.99 as=0 ps=0 w=0.22 l=1
* OPENPLL_ORIGIN X30 sky130_fd_pr__pfet_01v8_hvt 99003 80995 99004 80996
X30 w_97364_80959# a_97400_80515# w_97364_80959# w_97364_80959# sky130_fd_pr__pfet_01v8_hvt ad=0.2262 pd=2.26 as=0 ps=0 w=0.87 l=4.73
* OPENPLL_ORIGIN X31 sky130_fd_pr__pfet_01v8_hvt 98267 80000 98268 80001
X31 w_97364_79964# a_98267_80000# w_97364_79964# w_97364_79964# sky130_fd_pr__pfet_01v8_hvt ad=0.1053 pd=1.33 as=0 ps=0 w=0.405 l=1.97
* OPENPLL_ORIGIN X32 sky130_fd_pr__pfet_01v8 12098 37708 12099 37709
X32 a_12043_37708# a_12058_35815# a_12043_37708# w_11978_37648# sky130_fd_pr__pfet_01v8 ad=0.275 pd=2.55 as=0 ps=0 w=1 l=1
* OPENPLL_ORIGIN X33 sky130_fd_pr__nfet_01v8 100107 81603 100108 81604
X33 a_97400_80515# w_97364_80959# a_97400_80515# a_97400_80515# sky130_fd_pr__nfet_01v8 ad=0.143 pd=1.62 as=0 ps=0 w=0.55 l=2.69
C0 m2_12674_35600# m1_11000_35822# 2.3884200000000004e-17
C1 a_98267_80000# w_97364_80959# 4.3139900000000006e-18
C2 a_12111_35775# m1_13136_36772# 1.6522900000000002e-19
C3 a_12111_35775# m4_12658_35600# 1.9722600000000002e-18
C4 a_12058_35815# a_12098_38030# 3.35961e-17
C5 w_11978_37648# a_12058_35815# 2.0189100000000001e-16
C6 m2_12482_35600# m5_11000_36464# 1.3326700000000002e-17
C7 m1_13136_36772# m1_11000_35822# 2.3896500000000002e-17
C8 m1_11000_35822# m4_12658_35600# 3.8046000000000005e-18
C9 a_12043_37708# m3_13226_37136# 1.61041e-18
C10 a_12058_35815# m4_13426_35600# 1.4939600000000003e-17
C11 m2_12482_35600# w_11978_35600# 3.3428399999999998e-18
C12 m3_13226_37136# m2_12674_35600# 1.63333e-18
C13 a_12043_37708# a_12043_36376# 4.1432899999999998e-17
C14 m2_12674_35600# m1_12080_35736# 2.49988e-17
C15 a_12043_36376# m2_12674_35600# 7.9094400000000003e-17
C16 m1_13136_36772# m3_13226_37136# 1.9391000000000001e-17
C17 m3_13226_37136# m4_12658_35600# 2.0485600000000002e-19
C18 m2_12674_35600# w_11978_36316# 4.7392200000000009e-17
C19 w_11978_35600# m5_11000_36464# 1.5137900000000001e-18
C20 m1_13136_36772# m1_12080_35736# 2.4991099999999999e-17
C21 a_12043_36376# m1_13136_36772# 2.0253100000000003e-16
C22 m4_12658_35600# m1_12080_35736# 2.9948400000000002e-18
C23 m2_12482_35600# a_12058_35815# 2.31152e-16
C24 a_12043_36376# m4_12658_35600# 1.6397200000000001e-17
C25 a_12043_37708# m2_13346_35600# 7.3327300000000006e-17
C26 a_12043_37708# m4_13042_35600# 9.049500000000001e-18
C27 m2_12674_35600# m2_13346_35600# 9.1264200000000011e-17
C28 m1_13136_36772# w_11978_36316# 8.1488200000000022e-17
C29 w_11978_36316# m4_12658_35600# 1.1378399999999999e-17
C30 m2_12674_35600# m4_13042_35600# 1.0179600000000001e-17
C31 w_97364_79964# a_98267_80000# 2.1416300000000004e-16
C32 a_12111_35775# m1_11000_35822# 1.7539699999999999e-17
C33 a_12058_35815# m5_11000_36464# 7.4302000000000009e-16
C34 a_12043_37708# a_12098_38030# 5.9348399999999998e-17
C35 w_11978_37648# a_12043_37708# 5.3274900000000011e-16
C36 m1_13136_36772# m2_13346_35600# 3.00859e-16
C37 m2_13346_35600# m4_12658_35600# 8.7285199999999993e-19
C38 m1_13136_36772# m4_13042_35600# 1.4423900000000002e-17
C39 a_12098_38030# m2_12674_35600# 3.1880400000000006e-20
C40 m4_13042_35600# m4_12658_35600# 5.3652999999999996e-16
C41 w_11978_37648# m2_12674_35600# 3.3636200000000009e-17
C42 w_11978_35600# a_12058_35815# 6.0162100000000004e-17
C43 a_12043_37708# m4_13426_35600# 4.5276800000000007e-18
C44 a_12111_35775# m3_13226_37136# 9.1782600000000015e-20
C45 a_12098_38030# m4_12658_35600# 2.8074700000000005e-19
C46 w_11978_37648# m1_13136_36772# 3.8351200000000004e-19
C47 w_11978_37648# m4_12658_35600# 8.1896100000000012e-18
C48 a_12111_35775# m1_12080_35736# 4.1616900000000002e-17
C49 a_12043_36376# a_12111_35775# 3.4042600000000001e-17
C50 m3_13226_37136# m1_11000_35822# 1.5272800000000001e-18
C51 m1_13136_36772# m4_13426_35600# 2.3672700000000001e-18
C52 a_99003_80000# w_97364_80959# 4.3139900000000006e-18
C53 m1_11000_35822# m1_12080_35736# 6.5872900000000004e-16
C54 a_12043_36376# m1_11000_35822# 1.1850400000000001e-17
C55 m2_12482_35600# a_12043_37708# 1.01416e-16
C56 m2_12482_35600# m2_12674_35600# 5.5803600000000002e-16
C57 a_12111_35775# m2_13346_35600# 1.10534e-19
C58 a_12111_35775# m4_13042_35600# 1.2061800000000001e-19
C59 a_12043_37708# m5_11000_36464# 5.1755800000000002e-18
C60 m2_12482_35600# m1_13136_36772# 4.0203900000000004e-20
C61 m1_11000_35822# m2_13346_35600# 2.1664900000000002e-17
C62 m2_12482_35600# m4_12658_35600# 1.4945500000000001e-17
C63 m3_13226_37136# m1_12080_35736# 1.6020600000000002e-18
C64 a_12043_36376# m3_13226_37136# 1.24753e-17
C65 m1_11000_35822# m4_13042_35600# 2.5642200000000004e-18
C66 m2_12674_35600# m5_11000_36464# 8.1286e-18
C67 a_12043_36376# m1_12080_35736# 4.434400000000001e-19
C68 m3_13226_37136# w_11978_36316# 1.6701200000000002e-17
C69 w_97364_80959# a_100107_80000# 4.0955600000000003e-19
C70 w_11978_35600# m2_12674_35600# 2.9277600000000006e-18
C71 w_11978_36316# m1_12080_35736# 8.5384699999999998e-20
C72 a_12043_36376# w_11978_36316# 7.2327600000000002e-16
C73 m1_13136_36772# m5_11000_36464# 1.1621500000000001e-17
C74 m5_11000_36464# m4_12658_35600# 2.4036099999999999e-16
C75 a_12111_35775# m4_13426_35600# 1.0530900000000002e-19
C76 m3_13226_37136# m2_13346_35600# 5.1122700000000006e-17
C77 m3_13226_37136# m4_13042_35600# 6.140160000000001e-16
C78 w_97364_79964# a_99003_80000# 4.4880300000000007e-16
C79 w_11978_35600# m1_13136_36772# 3.2119600000000002e-18
C80 m2_13346_35600# m1_12080_35736# 2.2759100000000004e-17
C81 w_11978_35600# m4_12658_35600# 2.5581000000000003e-18
C82 a_12043_36376# m2_13346_35600# 6.8070499999999998e-17
C83 m1_11000_35822# m4_13426_35600# 9.9906400000000019e-19
C84 a_12043_37708# a_12058_35815# 6.3762400000000006e-16
C85 m4_13042_35600# m1_12080_35736# 1.6285e-18
C86 a_12043_36376# m4_13042_35600# 8.8562999999999996e-18
C87 a_98267_80000# a_99003_80000# 1.2163700000000001e-18
C88 w_11978_36316# m2_13346_35600# 3.2141400000000004e-17
C89 a_12058_35815# m2_12674_35600# 1.5544400000000001e-16
C90 w_11978_36316# m4_13042_35600# 9.0080500000000004e-18
C91 w_11978_37648# m3_13226_37136# 4.9466100000000001e-18
C92 m2_12482_35600# a_12111_35775# 1.1578200000000001e-17
C93 m3_13226_37136# m4_13426_35600# 6.5634300000000008e-16
C94 a_12058_35815# m1_13136_36772# 1.08716e-16
C95 a_12058_35815# m4_12658_35600# 2.27618e-16
C96 m2_13346_35600# m4_13042_35600# 1.0591400000000002e-17
C97 m2_12482_35600# m1_11000_35822# 2.4562000000000002e-17
C98 m4_13426_35600# m1_12080_35736# 1.3892400000000002e-18
C99 a_12043_36376# m4_13426_35600# 5.7916999999999998e-18
C100 a_12111_35775# m5_11000_36464# 3.5281500000000001e-19
C101 w_97364_79964# a_100107_80000# 2.63403e-16
C102 w_11978_36316# m4_13426_35600# 4.9793700000000006e-18
C103 a_97400_80000# w_97364_80959# 3.5767900000000004e-18
C104 a_12098_38030# m2_13346_35600# 7.8486300000000013e-21
C105 w_11978_37648# m2_13346_35600# 3.1349100000000002e-17
C106 a_12098_38030# m4_13042_35600# 1.0612000000000001e-20
C107 m1_11000_35822# m5_11000_36464# 2.3707300000000004e-18
C108 w_11978_37648# m4_13042_35600# 6.5861000000000007e-18
C109 w_11978_35600# a_12111_35775# 2.2428400000000003e-17
C110 m2_12482_35600# m3_13226_37136# 8.4636000000000015e-20
C111 m2_13346_35600# m4_13426_35600# 2.5023100000000001e-17
C112 w_11978_35600# m1_11000_35822# 1.4063000000000002e-18
C113 m2_12482_35600# m1_12080_35736# 4.8298300000000001e-17
C114 m4_13042_35600# m4_13426_35600# 1.9293600000000002e-16
C115 m2_12482_35600# a_12043_36376# 1.1764e-16
C116 w_11978_37648# a_12098_38030# 5.2726700000000005e-17
C117 m2_12482_35600# w_11978_36316# 3.0487600000000004e-17
C118 a_12043_37708# m2_12674_35600# 7.6047300000000016e-17
C119 m3_13226_37136# m5_11000_36464# 1.7783400000000002e-16
C120 a_12098_38030# m4_13426_35600# 9.3524300000000013e-22
C121 a_12058_35815# a_12111_35775# 2.1590700000000004e-16
C122 w_11978_37648# m4_13426_35600# 4.0374999999999995e-18
C123 m5_11000_36464# m1_12080_35736# 1.4143500000000001e-18
C124 a_12043_36376# m5_11000_36464# 2.8862400000000001e-17
C125 w_11978_35600# m3_13226_37136# 8.4649000000000005e-19
C126 a_12058_35815# m1_11000_35822# 8.5240000000000001e-16
C127 a_12043_37708# m1_13136_36772# 6.1075300000000006e-20
C128 a_12043_37708# m4_12658_35600# 1.6507000000000003e-17
C129 w_11978_36316# m5_11000_36464# 2.0536599999999999e-17
C130 w_11978_35600# m1_12080_35736# 1.4178000000000003e-17
C131 m1_13136_36772# m2_12674_35600# 1.1905800000000002e-16
C132 m2_12674_35600# m4_12658_35600# 2.66712e-17
C133 w_97364_79964# a_97400_80000# 3.3554199999999996e-16
C134 m2_12482_35600# a_12098_38030# 2.0855700000000003e-18
C135 m2_13346_35600# m5_11000_36464# 8.1952200000000019e-18
C136 w_11978_37648# m2_12482_35600# 1.8931300000000003e-17
C137 m5_11000_36464# m4_13042_35600# 1.98648e-16
C138 a_98267_80000# a_97400_80000# 2.6329100000000002e-18
C139 m1_13136_36772# m4_12658_35600# 4.7e-19
C140 a_12058_35815# m3_13226_37136# 2.8119599999999999e-17
C141 w_11978_35600# m2_13346_35600# 1.8978e-18
C142 a_12058_35815# m1_12080_35736# 7.302050000000001e-17
C143 a_12058_35815# a_12043_36376# 1.2381600000000002e-15
C144 w_11978_35600# m4_13042_35600# 1.08472e-18
C145 w_11978_37648# m5_11000_36464# 4.8700000000000003e-18
C146 a_12058_35815# w_11978_36316# 4.0230400000000002e-16
C147 m5_11000_36464# m4_13426_35600# 1.3577300000000001e-16
C148 a_12058_35815# m2_13346_35600# 1.4475200000000002e-16
C149 a_12111_35775# m2_12674_35600# 5.5591599999999995e-19
C150 a_12058_35815# m4_13042_35600# 1.6941400000000004e-17
C151 w_11978_35600# m4_13426_35600# 5.92231e-19
C152 a_99003_80000# a_100107_80000# 2.6329100000000002e-18
C153 w_97364_79964# w_97364_80959# 8.8069700000000004e-16
C154 m5_12500_35600# a_97400_80515# 0 $ **FLOATING
C155 m5_11000_35600# a_97400_80515# 0 $ **FLOATING
C156 m5_11000_36464# a_97400_80515# 8.8871e-16
C157 m5_12500_37184# a_97400_80515# 0 $ **FLOATING
C158 m5_11000_37184# a_97400_80515# 0 $ **FLOATING
C159 m5_100500_80000# a_97400_80515# 0 $ **FLOATING
C160 m5_98500_80000# a_97400_80515# 0 $ **FLOATING
C161 m5_97400_80000# a_97400_80515# 0 $ **FLOATING
C162 m5_100500_80500# a_97400_80515# 0 $ **FLOATING
C163 m5_98500_80500# a_97400_80515# 0 $ **FLOATING
C164 m5_97400_80500# a_97400_80515# 0 $ **FLOATING
C165 m5_100500_82500# a_97400_80515# 0 $ **FLOATING
C166 m5_98500_82500# a_97400_80515# 0 $ **FLOATING
C167 m5_97400_82500# a_97400_80515# 0 $ **FLOATING
C168 m4_13426_35600# a_97400_80515# 5.1146899999999999e-16
C169 m4_13220_37370# a_97400_80515# 0 $ **FLOATING
C170 m4_13204_37656# a_97400_80515# 0 $ **FLOATING
C171 m4_13042_35600# a_97400_80515# 1.1617500000000001e-16
C172 m4_12824_36072# a_97400_80515# 0 $ **FLOATING
C173 m4_12850_36250# a_97400_80515# 0 $ **FLOATING
C174 m4_12820_36952# a_97400_80515# 0 $ **FLOATING
C175 m4_12800_37690# a_97400_80515# 0 $ **FLOATING
C176 m4_12830_37850# a_97400_80515# 0 $ **FLOATING
C177 m4_12860_38010# a_97400_80515# 0 $ **FLOATING
C178 m4_12658_35600# a_97400_80515# 2.46726e-16
C179 m4_12404_35600# a_97400_80515# 0 $ **FLOATING
C180 m4_12228_35600# a_97400_80515# 0 $ **FLOATING
C181 m4_12052_35600# a_97400_80515# 0 $ **FLOATING
C182 m4_11876_35600# a_97400_80515# 0 $ **FLOATING
C183 m4_12368_35720# a_97400_80515# 0 $ **FLOATING
C184 m4_12192_35720# a_97400_80515# 0 $ **FLOATING
C185 m4_12016_35720# a_97400_80515# 0 $ **FLOATING
C186 m4_11840_35720# a_97400_80515# 0 $ **FLOATING
C187 m4_12332_35896# a_97400_80515# 0 $ **FLOATING
C188 m4_12156_35896# a_97400_80515# 0 $ **FLOATING
C189 m4_11980_35896# a_97400_80515# 0 $ **FLOATING
C190 m4_11804_35896# a_97400_80515# 0 $ **FLOATING
C191 m4_12296_36072# a_97400_80515# 0 $ **FLOATING
C192 m4_12120_36072# a_97400_80515# 0 $ **FLOATING
C193 m4_11944_36072# a_97400_80515# 0 $ **FLOATING
C194 m4_11768_36072# a_97400_80515# 0 $ **FLOATING
C195 m4_12436_36248# a_97400_80515# 0 $ **FLOATING
C196 m4_12260_36248# a_97400_80515# 0 $ **FLOATING
C197 m4_12084_36248# a_97400_80515# 0 $ **FLOATING
C198 m4_11908_36248# a_97400_80515# 0 $ **FLOATING
C199 m4_11732_36248# a_97400_80515# 0 $ **FLOATING
C200 m4_12400_36424# a_97400_80515# 0 $ **FLOATING
C201 m4_12224_36424# a_97400_80515# 0 $ **FLOATING
C202 m4_12048_36424# a_97400_80515# 0 $ **FLOATING
C203 m4_11872_36424# a_97400_80515# 0 $ **FLOATING
C204 m4_12364_36600# a_97400_80515# 0 $ **FLOATING
C205 m4_12188_36600# a_97400_80515# 0 $ **FLOATING
C206 m4_12012_36600# a_97400_80515# 0 $ **FLOATING
C207 m4_11836_36600# a_97400_80515# 0 $ **FLOATING
C208 m4_12328_36776# a_97400_80515# 0 $ **FLOATING
C209 m4_12152_36776# a_97400_80515# 0 $ **FLOATING
C210 m4_11976_36776# a_97400_80515# 0 $ **FLOATING
C211 m4_11800_36776# a_97400_80515# 0 $ **FLOATING
C212 m4_12292_36952# a_97400_80515# 0 $ **FLOATING
C213 m4_12116_36952# a_97400_80515# 0 $ **FLOATING
C214 m4_11940_36952# a_97400_80515# 0 $ **FLOATING
C215 m4_11764_36952# a_97400_80515# 0 $ **FLOATING
C216 m4_12432_37128# a_97400_80515# 0 $ **FLOATING
C217 m4_12256_37128# a_97400_80515# 0 $ **FLOATING
C218 m4_12080_37128# a_97400_80515# 0 $ **FLOATING
C219 m4_11904_37128# a_97400_80515# 0 $ **FLOATING
C220 m4_11728_37128# a_97400_80515# 0 $ **FLOATING
C221 m4_11000_36250# a_97400_80515# 0 $ **FLOATING
C222 m4_11000_36424# a_97400_80515# 0 $ **FLOATING
C223 m4_11000_36600# a_97400_80515# 0 $ **FLOATING
C224 m4_11000_36776# a_97400_80515# 0 $ **FLOATING
C225 m4_11000_37050# a_97400_80515# 0 $ **FLOATING
C226 m4_12396_37304# a_97400_80515# 0 $ **FLOATING
C227 m4_12220_37304# a_97400_80515# 0 $ **FLOATING
C228 m4_12044_37304# a_97400_80515# 0 $ **FLOATING
C229 m4_11868_37304# a_97400_80515# 0 $ **FLOATING
C230 m4_12360_37480# a_97400_80515# 0 $ **FLOATING
C231 m4_12184_37480# a_97400_80515# 0 $ **FLOATING
C232 m4_12008_37480# a_97400_80515# 0 $ **FLOATING
C233 m4_11832_37480# a_97400_80515# 0 $ **FLOATING
C234 m4_12324_37656# a_97400_80515# 0 $ **FLOATING
C235 m4_12148_37656# a_97400_80515# 0 $ **FLOATING
C236 m4_11972_37656# a_97400_80515# 0 $ **FLOATING
C237 m4_11796_37656# a_97400_80515# 0 $ **FLOATING
C238 m4_12288_37832# a_97400_80515# 0 $ **FLOATING
C239 m4_12112_37832# a_97400_80515# 0 $ **FLOATING
C240 m4_11936_37832# a_97400_80515# 0 $ **FLOATING
C241 m4_11760_37832# a_97400_80515# 0 $ **FLOATING
C242 m4_12428_38008# a_97400_80515# 0 $ **FLOATING
C243 m4_12252_38008# a_97400_80515# 0 $ **FLOATING
C244 m4_12076_38008# a_97400_80515# 0 $ **FLOATING
C245 m4_11900_38008# a_97400_80515# 0 $ **FLOATING
C246 m4_11724_38008# a_97400_80515# 0 $ **FLOATING
C247 m4_11000_37304# a_97400_80515# 0 $ **FLOATING
C248 m4_11000_37480# a_97400_80515# 0 $ **FLOATING
C249 m4_11000_37656# a_97400_80515# 0 $ **FLOATING
C250 m4_11000_37850# a_97400_80515# 0 $ **FLOATING
C251 m4_11000_38010# a_97400_80515# 0 $ **FLOATING
C252 m4_100430_80110# a_97400_80515# 0 $ **FLOATING
C253 m4_99870_80110# a_97400_80515# 0 $ **FLOATING
C254 m4_99310_80110# a_97400_80515# 0 $ **FLOATING
C255 m4_98750_80110# a_97400_80515# 0 $ **FLOATING
C256 m4_98190_80110# a_97400_80515# 0 $ **FLOATING
C257 m4_97630_80110# a_97400_80515# 0 $ **FLOATING
C258 m4_97400_80110# a_97400_80515# 0 $ **FLOATING
C259 m4_100570_80670# a_97400_80515# 0 $ **FLOATING
C260 m4_100010_80670# a_97400_80515# 0 $ **FLOATING
C261 m4_99450_80670# a_97400_80515# 0 $ **FLOATING
C262 m4_98890_80670# a_97400_80515# 0 $ **FLOATING
C263 m4_98330_80670# a_97400_80515# 0 $ **FLOATING
C264 m4_97770_80670# a_97400_80515# 0 $ **FLOATING
C265 m4_97400_80670# a_97400_80515# 0 $ **FLOATING
C266 m4_100150_81230# a_97400_80515# 0 $ **FLOATING
C267 m4_99590_81230# a_97400_80515# 0 $ **FLOATING
C268 m4_99030_81230# a_97400_80515# 0 $ **FLOATING
C269 m4_98470_81230# a_97400_80515# 0 $ **FLOATING
C270 m4_97910_81230# a_97400_80515# 0 $ **FLOATING
C271 m4_97400_81230# a_97400_80515# 0 $ **FLOATING
C272 m4_100290_81790# a_97400_80515# 0 $ **FLOATING
C273 m4_99730_81790# a_97400_80515# 0 $ **FLOATING
C274 m4_99170_81790# a_97400_80515# 0 $ **FLOATING
C275 m4_98610_81790# a_97400_80515# 0 $ **FLOATING
C276 m4_98050_81790# a_97400_80515# 0 $ **FLOATING
C277 m4_97490_81790# a_97400_80515# 0 $ **FLOATING
C278 m4_100430_82350# a_97400_80515# 0 $ **FLOATING
C279 m4_99870_82350# a_97400_80515# 0 $ **FLOATING
C280 m4_99310_82350# a_97400_80515# 0 $ **FLOATING
C281 m4_98750_82350# a_97400_80515# 0 $ **FLOATING
C282 m4_98190_82350# a_97400_80515# 0 $ **FLOATING
C283 m4_97630_82350# a_97400_80515# 0 $ **FLOATING
C284 m4_97400_82350# a_97400_80515# 0 $ **FLOATING
C285 m4_100570_82910# a_97400_80515# 0 $ **FLOATING
C286 m4_100010_82910# a_97400_80515# 0 $ **FLOATING
C287 m4_99450_82910# a_97400_80515# 0 $ **FLOATING
C288 m4_98890_82910# a_97400_80515# 0 $ **FLOATING
C289 m4_98330_82910# a_97400_80515# 0 $ **FLOATING
C290 m4_97770_82910# a_97400_80515# 0 $ **FLOATING
C291 m4_97400_82910# a_97400_80515# 0 $ **FLOATING
C292 m3_13354_35650# a_97400_80515# 0 $ **FLOATING
C293 m3_13178_35650# a_97400_80515# 0 $ **FLOATING
C294 m3_13002_35650# a_97400_80515# 0 $ **FLOATING
C295 m3_12826_35650# a_97400_80515# 0 $ **FLOATING
C296 m3_12650_35650# a_97400_80515# 0 $ **FLOATING
C297 m3_12474_35650# a_97400_80515# 0 $ **FLOATING
C298 m3_12298_35650# a_97400_80515# 0 $ **FLOATING
C299 m3_12122_35650# a_97400_80515# 0 $ **FLOATING
C300 m3_11946_35650# a_97400_80515# 0 $ **FLOATING
C301 m3_11770_35650# a_97400_80515# 0 $ **FLOATING
C302 m3_11594_35650# a_97400_80515# 0 $ **FLOATING
C303 m3_11418_35650# a_97400_80515# 0 $ **FLOATING
C304 m3_11242_35650# a_97400_80515# 0 $ **FLOATING
C305 m3_11066_35650# a_97400_80515# 0 $ **FLOATING
C306 m3_11000_35650# a_97400_80515# 0 $ **FLOATING
C307 m3_13494_35826# a_97400_80515# 0 $ **FLOATING
C308 m3_13318_35826# a_97400_80515# 0 $ **FLOATING
C309 m3_13142_35826# a_97400_80515# 0 $ **FLOATING
C310 m3_13458_36002# a_97400_80515# 0 $ **FLOATING
C311 m3_13282_36002# a_97400_80515# 0 $ **FLOATING
C312 m3_13422_36178# a_97400_80515# 0 $ **FLOATING
C313 m3_13246_36178# a_97400_80515# 0 $ **FLOATING
C314 m3_12650_35870# a_97400_80515# 0 $ **FLOATING
C315 m3_12320_35870# a_97400_80515# 0 $ **FLOATING
C316 m3_12086_35826# a_97400_80515# 0 $ **FLOATING
C317 m3_11910_35826# a_97400_80515# 0 $ **FLOATING
C318 m3_11734_35826# a_97400_80515# 0 $ **FLOATING
C319 m3_12050_36002# a_97400_80515# 0 $ **FLOATING
C320 m3_11874_36002# a_97400_80515# 0 $ **FLOATING
C321 m3_12366_36178# a_97400_80515# 0 $ **FLOATING
C322 m3_12190_36178# a_97400_80515# 0 $ **FLOATING
C323 m3_12014_36178# a_97400_80515# 0 $ **FLOATING
C324 m3_11838_36178# a_97400_80515# 0 $ **FLOATING
C325 m3_11662_36178# a_97400_80515# 0 $ **FLOATING
C326 m3_11486_36178# a_97400_80515# 0 $ **FLOATING
C327 m3_11310_36178# a_97400_80515# 0 $ **FLOATING
C328 m3_11134_36178# a_97400_80515# 0 $ **FLOATING
C329 m3_11000_36178# a_97400_80515# 0 $ **FLOATING
C330 m3_13386_36354# a_97400_80515# 0 $ **FLOATING
C331 m3_13210_36354# a_97400_80515# 0 $ **FLOATING
C332 m3_13034_36354# a_97400_80515# 0 $ **FLOATING
C333 m3_12858_36354# a_97400_80515# 0 $ **FLOATING
C334 m3_12682_36354# a_97400_80515# 0 $ **FLOATING
C335 m3_13350_36530# a_97400_80515# 0 $ **FLOATING
C336 m3_13174_36530# a_97400_80515# 0 $ **FLOATING
C337 m3_12998_36530# a_97400_80515# 0 $ **FLOATING
C338 m3_12822_36530# a_97400_80515# 0 $ **FLOATING
C339 m3_12646_36530# a_97400_80515# 0 $ **FLOATING
C340 m3_12340_36390# a_97400_80515# 0 $ **FLOATING
C341 m3_12154_36354# a_97400_80515# 0 $ **FLOATING
C342 m3_11978_36354# a_97400_80515# 0 $ **FLOATING
C343 m3_11802_36354# a_97400_80515# 0 $ **FLOATING
C344 m3_11626_36354# a_97400_80515# 0 $ **FLOATING
C345 m3_11450_36354# a_97400_80515# 0 $ **FLOATING
C346 m3_11274_36354# a_97400_80515# 0 $ **FLOATING
C347 m3_11098_36354# a_97400_80515# 0 $ **FLOATING
C348 m3_11000_36354# a_97400_80515# 0 $ **FLOATING
C349 m3_11942_36530# a_97400_80515# 0 $ **FLOATING
C350 m3_11766_36530# a_97400_80515# 0 $ **FLOATING
C351 m3_11590_36530# a_97400_80515# 0 $ **FLOATING
C352 m3_11414_36530# a_97400_80515# 0 $ **FLOATING
C353 m3_11238_36530# a_97400_80515# 0 $ **FLOATING
C354 m3_11062_36530# a_97400_80515# 0 $ **FLOATING
C355 m3_13490_36706# a_97400_80515# 0 $ **FLOATING
C356 m3_13314_36706# a_97400_80515# 0 $ **FLOATING
C357 m3_13138_36706# a_97400_80515# 0 $ **FLOATING
C358 m3_12962_36706# a_97400_80515# 0 $ **FLOATING
C359 m3_12786_36706# a_97400_80515# 0 $ **FLOATING
C360 m3_12610_36706# a_97400_80515# 0 $ **FLOATING
C361 m3_12220_36650# a_97400_80515# 0 $ **FLOATING
C362 m3_11906_36706# a_97400_80515# 0 $ **FLOATING
C363 m3_11730_36706# a_97400_80515# 0 $ **FLOATING
C364 m3_11554_36706# a_97400_80515# 0 $ **FLOATING
C365 m3_11378_36706# a_97400_80515# 0 $ **FLOATING
C366 m3_11202_36706# a_97400_80515# 0 $ **FLOATING
C367 m3_11026_36706# a_97400_80515# 0 $ **FLOATING
C368 m3_13454_36882# a_97400_80515# 0 $ **FLOATING
C369 m3_13278_36882# a_97400_80515# 0 $ **FLOATING
C370 m3_13102_36882# a_97400_80515# 0 $ **FLOATING
C371 m3_12926_36882# a_97400_80515# 0 $ **FLOATING
C372 m3_12750_36882# a_97400_80515# 0 $ **FLOATING
C373 m3_13226_37136# a_97400_80515# 1.5996000000000004e-16
C374 m3_12890_37058# a_97400_80515# 0 $ **FLOATING
C375 m3_12714_37058# a_97400_80515# 0 $ **FLOATING
C376 m3_12360_36910# a_97400_80515# 0 $ **FLOATING
C377 m3_11870_36882# a_97400_80515# 0 $ **FLOATING
C378 m3_11694_36882# a_97400_80515# 0 $ **FLOATING
C379 m3_11518_36882# a_97400_80515# 0 $ **FLOATING
C380 m3_11342_36882# a_97400_80515# 0 $ **FLOATING
C381 m3_11166_36882# a_97400_80515# 0 $ **FLOATING
C382 m3_11000_36882# a_97400_80515# 0 $ **FLOATING
C383 m3_12854_37234# a_97400_80515# 0 $ **FLOATING
C384 m3_12678_37234# a_97400_80515# 0 $ **FLOATING
C385 m3_12502_37234# a_97400_80515# 0 $ **FLOATING
C386 m3_12240_37170# a_97400_80515# 0 $ **FLOATING
C387 m3_12010_37058# a_97400_80515# 0 $ **FLOATING
C388 m3_11834_37058# a_97400_80515# 0 $ **FLOATING
C389 m3_11658_37058# a_97400_80515# 0 $ **FLOATING
C390 m3_11482_37058# a_97400_80515# 0 $ **FLOATING
C391 m3_11306_37058# a_97400_80515# 0 $ **FLOATING
C392 m3_11130_37058# a_97400_80515# 0 $ **FLOATING
C393 m3_11000_37058# a_97400_80515# 0 $ **FLOATING
C394 m3_11974_37234# a_97400_80515# 0 $ **FLOATING
C395 m3_11798_37234# a_97400_80515# 0 $ **FLOATING
C396 m3_11000_37234# a_97400_80515# 0 $ **FLOATING
C397 m3_13346_37410# a_97400_80515# 0 $ **FLOATING
C398 m3_13170_37410# a_97400_80515# 0 $ **FLOATING
C399 m3_12994_37410# a_97400_80515# 0 $ **FLOATING
C400 m3_12818_37410# a_97400_80515# 0 $ **FLOATING
C401 m3_12642_37410# a_97400_80515# 0 $ **FLOATING
C402 m3_13486_37586# a_97400_80515# 0 $ **FLOATING
C403 m3_13310_37586# a_97400_80515# 0 $ **FLOATING
C404 m3_13134_37586# a_97400_80515# 0 $ **FLOATING
C405 m3_12958_37586# a_97400_80515# 0 $ **FLOATING
C406 m3_12782_37586# a_97400_80515# 0 $ **FLOATING
C407 m3_12380_37430# a_97400_80515# 0 $ **FLOATING
C408 m3_11938_37410# a_97400_80515# 0 $ **FLOATING
C409 m3_11762_37410# a_97400_80515# 0 $ **FLOATING
C410 m3_13450_37762# a_97400_80515# 0 $ **FLOATING
C411 m3_13274_37762# a_97400_80515# 0 $ **FLOATING
C412 m3_13098_37762# a_97400_80515# 0 $ **FLOATING
C413 m3_12922_37762# a_97400_80515# 0 $ **FLOATING
C414 m3_12746_37762# a_97400_80515# 0 $ **FLOATING
C415 m3_12570_37762# a_97400_80515# 0 $ **FLOATING
C416 m3_12260_37690# a_97400_80515# 0 $ **FLOATING
C417 m3_12078_37586# a_97400_80515# 0 $ **FLOATING
C418 m3_11902_37586# a_97400_80515# 0 $ **FLOATING
C419 m3_11726_37586# a_97400_80515# 0 $ **FLOATING
C420 m3_11550_37586# a_97400_80515# 0 $ **FLOATING
C421 m3_11374_37586# a_97400_80515# 0 $ **FLOATING
C422 m3_11198_37586# a_97400_80515# 0 $ **FLOATING
C423 m3_11022_37586# a_97400_80515# 0 $ **FLOATING
C424 m3_12042_37762# a_97400_80515# 0 $ **FLOATING
C425 m3_11866_37762# a_97400_80515# 0 $ **FLOATING
C426 m3_11690_37762# a_97400_80515# 0 $ **FLOATING
C427 m3_11514_37762# a_97400_80515# 0 $ **FLOATING
C428 m3_11338_37762# a_97400_80515# 0 $ **FLOATING
C429 m3_11162_37762# a_97400_80515# 0 $ **FLOATING
C430 m3_11000_37762# a_97400_80515# 0 $ **FLOATING
C431 m3_13414_37938# a_97400_80515# 0 $ **FLOATING
C432 m3_13238_37938# a_97400_80515# 0 $ **FLOATING
C433 m3_12360_37990# a_97400_80515# 0 $ **FLOATING
C434 m3_12200_37990# a_97400_80515# 0 $ **FLOATING
C435 m3_12006_37938# a_97400_80515# 0 $ **FLOATING
C436 m3_11830_37938# a_97400_80515# 0 $ **FLOATING
C437 m3_11654_37938# a_97400_80515# 0 $ **FLOATING
C438 m3_11478_37938# a_97400_80515# 0 $ **FLOATING
C439 m3_11302_37938# a_97400_80515# 0 $ **FLOATING
C440 m3_11126_37938# a_97400_80515# 0 $ **FLOATING
C441 m3_11000_37938# a_97400_80515# 0 $ **FLOATING
C442 m3_100430_80110# a_97400_80515# 0 $ **FLOATING
C443 m3_99870_80110# a_97400_80515# 0 $ **FLOATING
C444 m3_99310_80110# a_97400_80515# 0 $ **FLOATING
C445 m3_98750_80110# a_97400_80515# 0 $ **FLOATING
C446 m3_98190_80110# a_97400_80515# 0 $ **FLOATING
C447 m3_97630_80110# a_97400_80515# 0 $ **FLOATING
C448 m3_97400_80110# a_97400_80515# 0 $ **FLOATING
C449 m3_100570_80670# a_97400_80515# 0 $ **FLOATING
C450 m3_100010_80670# a_97400_80515# 0 $ **FLOATING
C451 m3_99450_80670# a_97400_80515# 0 $ **FLOATING
C452 m3_98890_80670# a_97400_80515# 0 $ **FLOATING
C453 m3_98330_80670# a_97400_80515# 0 $ **FLOATING
C454 m3_97770_80670# a_97400_80515# 0 $ **FLOATING
C455 m3_97400_80670# a_97400_80515# 0 $ **FLOATING
C456 m3_100150_81230# a_97400_80515# 0 $ **FLOATING
C457 m3_99590_81230# a_97400_80515# 0 $ **FLOATING
C458 m3_99030_81230# a_97400_80515# 0 $ **FLOATING
C459 m3_98470_81230# a_97400_80515# 0 $ **FLOATING
C460 m3_97910_81230# a_97400_80515# 0 $ **FLOATING
C461 m3_97400_81230# a_97400_80515# 0 $ **FLOATING
C462 m3_100290_81790# a_97400_80515# 0 $ **FLOATING
C463 m3_99730_81790# a_97400_80515# 0 $ **FLOATING
C464 m3_99170_81790# a_97400_80515# 0 $ **FLOATING
C465 m3_98610_81790# a_97400_80515# 0 $ **FLOATING
C466 m3_98050_81790# a_97400_80515# 0 $ **FLOATING
C467 m3_97490_81790# a_97400_80515# 0 $ **FLOATING
C468 m3_100430_82350# a_97400_80515# 0 $ **FLOATING
C469 m3_99870_82350# a_97400_80515# 0 $ **FLOATING
C470 m3_99310_82350# a_97400_80515# 0 $ **FLOATING
C471 m3_98750_82350# a_97400_80515# 0 $ **FLOATING
C472 m3_98190_82350# a_97400_80515# 0 $ **FLOATING
C473 m3_97630_82350# a_97400_80515# 0 $ **FLOATING
C474 m3_97400_82350# a_97400_80515# 0 $ **FLOATING
C475 m3_100570_82910# a_97400_80515# 0 $ **FLOATING
C476 m3_100010_82910# a_97400_80515# 0 $ **FLOATING
C477 m3_99450_82910# a_97400_80515# 0 $ **FLOATING
C478 m3_98890_82910# a_97400_80515# 0 $ **FLOATING
C479 m3_98330_82910# a_97400_80515# 0 $ **FLOATING
C480 m3_97770_82910# a_97400_80515# 0 $ **FLOATING
C481 m3_97400_82910# a_97400_80515# 0 $ **FLOATING
C482 m2_13440_35840# a_97400_80515# 0 $ **FLOATING
C483 m2_13460_35940# a_97400_80515# 0 $ **FLOATING
C484 m2_13480_36040# a_97400_80515# 0 $ **FLOATING
C485 m2_13440_36340# a_97400_80515# 0 $ **FLOATING
C486 m2_13460_36440# a_97400_80515# 0 $ **FLOATING
C487 m2_13480_36540# a_97400_80515# 0 $ **FLOATING
C488 m2_13440_36840# a_97400_80515# 0 $ **FLOATING
C489 m2_13460_36940# a_97400_80515# 0 $ **FLOATING
C490 m2_13480_37040# a_97400_80515# 0 $ **FLOATING
C491 m2_13440_37340# a_97400_80515# 0 $ **FLOATING
C492 m2_13460_37440# a_97400_80515# 0 $ **FLOATING
C493 m2_13480_37540# a_97400_80515# 0 $ **FLOATING
C494 m2_13440_37840# a_97400_80515# 0 $ **FLOATING
C495 m2_13460_37940# a_97400_80515# 0 $ **FLOATING
C496 m2_13480_38040# a_97400_80515# 0 $ **FLOATING
C497 m2_13346_35600# a_97400_80515# 5.6525900000000012e-16
C498 m2_12896_35600# a_97400_80515# 0 $ **FLOATING
C499 m2_12880_35660# a_97400_80515# 0 $ **FLOATING
C500 m2_12864_35816# a_97400_80515# 0 $ **FLOATING
C501 m2_12848_35972# a_97400_80515# 0 $ **FLOATING
C502 m2_13000_36140# a_97400_80515# 0 $ **FLOATING
C503 m2_13020_36240# a_97400_80515# 0 $ **FLOATING
C504 m2_12832_36128# a_97400_80515# 0 $ **FLOATING
C505 m2_12816_36284# a_97400_80515# 0 $ **FLOATING
C506 m2_12960_36440# a_97400_80515# 0 $ **FLOATING
C507 m2_12860_36440# a_97400_80515# 0 $ **FLOATING
C508 m2_12980_36540# a_97400_80515# 0 $ **FLOATING
C509 m2_12880_36540# a_97400_80515# 0 $ **FLOATING
C510 m2_12780_36540# a_97400_80515# 0 $ **FLOATING
C511 m2_13000_36640# a_97400_80515# 0 $ **FLOATING
C512 m2_12900_36640# a_97400_80515# 0 $ **FLOATING
C513 m2_12800_36640# a_97400_80515# 0 $ **FLOATING
C514 m2_12924_36752# a_97400_80515# 0 $ **FLOATING
C515 m2_12820_36740# a_97400_80515# 0 $ **FLOATING
C516 m2_13160_36940# a_97400_80515# 0 $ **FLOATING
C517 m2_12908_36908# a_97400_80515# 0 $ **FLOATING
C518 m2_13048_37064# a_97400_80515# 0 $ **FLOATING
C519 m2_12892_37064# a_97400_80515# 0 $ **FLOATING
C520 m2_12780_37040# a_97400_80515# 0 $ **FLOATING
C521 m2_13220_37240# a_97400_80515# 0 $ **FLOATING
C522 m2_13032_37220# a_97400_80515# 0 $ **FLOATING
C523 m2_12876_37220# a_97400_80515# 0 $ **FLOATING
C524 m2_13016_37376# a_97400_80515# 0 $ **FLOATING
C525 m2_12860_37376# a_97400_80515# 0 $ **FLOATING
C526 m2_13180_37540# a_97400_80515# 0 $ **FLOATING
C527 m2_13200_37640# a_97400_80515# 0 $ **FLOATING
C528 m2_13000_37532# a_97400_80515# 0 $ **FLOATING
C529 m2_12844_37532# a_97400_80515# 0 $ **FLOATING
C530 m2_13220_37740# a_97400_80515# 0 $ **FLOATING
C531 m2_12984_37688# a_97400_80515# 0 $ **FLOATING
C532 m2_12828_37688# a_97400_80515# 0 $ **FLOATING
C533 m2_13124_37844# a_97400_80515# 0 $ **FLOATING
C534 m2_12968_37844# a_97400_80515# 0 $ **FLOATING
C535 m2_12812_37844# a_97400_80515# 0 $ **FLOATING
C536 m2_13108_38000# a_97400_80515# 0 $ **FLOATING
C537 m2_12952_38000# a_97400_80515# 0 $ **FLOATING
C538 m2_12780_38040# a_97400_80515# 0 $ **FLOATING
C539 m2_12674_35600# a_97400_80515# 1.9860200000000002e-16
C540 m2_12482_35600# a_97400_80515# 3.5299200000000008e-16
C541 m2_12256_35660# a_97400_80515# 0 $ **FLOATING
C542 m2_11804_35600# a_97400_80515# 0 $ **FLOATING
C543 m2_11648_35600# a_97400_80515# 0 $ **FLOATING
C544 m2_11492_35600# a_97400_80515# 0 $ **FLOATING
C545 m2_11336_35600# a_97400_80515# 0 $ **FLOATING
C546 m2_11180_35600# a_97400_80515# 0 $ **FLOATING
C547 m2_11024_35600# a_97400_80515# 0 $ **FLOATING
C548 m2_11788_35660# a_97400_80515# 0 $ **FLOATING
C549 m2_11632_35660# a_97400_80515# 0 $ **FLOATING
C550 m2_11476_35660# a_97400_80515# 0 $ **FLOATING
C551 m2_11320_35660# a_97400_80515# 0 $ **FLOATING
C552 m2_11164_35660# a_97400_80515# 0 $ **FLOATING
C553 m2_11008_35660# a_97400_80515# 0 $ **FLOATING
C554 m2_12240_35816# a_97400_80515# 0 $ **FLOATING
C555 m2_11940_35840# a_97400_80515# 0 $ **FLOATING
C556 m2_11772_35816# a_97400_80515# 0 $ **FLOATING
C557 m2_11000_35816# a_97400_80515# 0 $ **FLOATING
C558 m2_12224_35972# a_97400_80515# 0 $ **FLOATING
C559 m2_12068_35972# a_97400_80515# 0 $ **FLOATING
C560 m2_11912_35972# a_97400_80515# 0 $ **FLOATING
C561 m2_11756_35972# a_97400_80515# 0 $ **FLOATING
C562 m2_11000_35972# a_97400_80515# 0 $ **FLOATING
C563 m2_12208_36128# a_97400_80515# 0 $ **FLOATING
C564 m2_12052_36128# a_97400_80515# 0 $ **FLOATING
C565 m2_11896_36128# a_97400_80515# 0 $ **FLOATING
C566 m2_11740_36128# a_97400_80515# 0 $ **FLOATING
C567 m2_11584_36128# a_97400_80515# 0 $ **FLOATING
C568 m2_11428_36128# a_97400_80515# 0 $ **FLOATING
C569 m2_11272_36128# a_97400_80515# 0 $ **FLOATING
C570 m2_11116_36128# a_97400_80515# 0 $ **FLOATING
C571 m2_11000_36128# a_97400_80515# 0 $ **FLOATING
C572 m2_12192_36284# a_97400_80515# 0 $ **FLOATING
C573 m2_12036_36284# a_97400_80515# 0 $ **FLOATING
C574 m2_11880_36284# a_97400_80515# 0 $ **FLOATING
C575 m2_11724_36284# a_97400_80515# 0 $ **FLOATING
C576 m2_11568_36284# a_97400_80515# 0 $ **FLOATING
C577 m2_11412_36284# a_97400_80515# 0 $ **FLOATING
C578 m2_11256_36284# a_97400_80515# 0 $ **FLOATING
C579 m2_11100_36284# a_97400_80515# 0 $ **FLOATING
C580 m2_11000_36284# a_97400_80515# 0 $ **FLOATING
C581 m2_12360_36440# a_97400_80515# 0 $ **FLOATING
C582 m2_12176_36440# a_97400_80515# 0 $ **FLOATING
C583 m2_12020_36440# a_97400_80515# 0 $ **FLOATING
C584 m2_11864_36440# a_97400_80515# 0 $ **FLOATING
C585 m2_11708_36440# a_97400_80515# 0 $ **FLOATING
C586 m2_11552_36440# a_97400_80515# 0 $ **FLOATING
C587 m2_11396_36440# a_97400_80515# 0 $ **FLOATING
C588 m2_11240_36440# a_97400_80515# 0 $ **FLOATING
C589 m2_11084_36440# a_97400_80515# 0 $ **FLOATING
C590 m2_11000_36440# a_97400_80515# 0 $ **FLOATING
C591 m2_12160_36596# a_97400_80515# 0 $ **FLOATING
C592 m2_12004_36596# a_97400_80515# 0 $ **FLOATING
C593 m2_11848_36596# a_97400_80515# 0 $ **FLOATING
C594 m2_11692_36596# a_97400_80515# 0 $ **FLOATING
C595 m2_11536_36596# a_97400_80515# 0 $ **FLOATING
C596 m2_11380_36596# a_97400_80515# 0 $ **FLOATING
C597 m2_11224_36596# a_97400_80515# 0 $ **FLOATING
C598 m2_11068_36596# a_97400_80515# 0 $ **FLOATING
C599 m2_11000_36596# a_97400_80515# 0 $ **FLOATING
C600 m2_12320_36740# a_97400_80515# 0 $ **FLOATING
C601 m2_12340_36840# a_97400_80515# 0 $ **FLOATING
C602 m2_12144_36752# a_97400_80515# 0 $ **FLOATING
C603 m2_11988_36752# a_97400_80515# 0 $ **FLOATING
C604 m2_11832_36752# a_97400_80515# 0 $ **FLOATING
C605 m2_11676_36752# a_97400_80515# 0 $ **FLOATING
C606 m2_11520_36752# a_97400_80515# 0 $ **FLOATING
C607 m2_11364_36752# a_97400_80515# 0 $ **FLOATING
C608 m2_11208_36752# a_97400_80515# 0 $ **FLOATING
C609 m2_11052_36752# a_97400_80515# 0 $ **FLOATING
C610 m2_12360_36940# a_97400_80515# 0 $ **FLOATING
C611 m2_12128_36908# a_97400_80515# 0 $ **FLOATING
C612 m2_11972_36908# a_97400_80515# 0 $ **FLOATING
C613 m2_11816_36908# a_97400_80515# 0 $ **FLOATING
C614 m2_11660_36908# a_97400_80515# 0 $ **FLOATING
C615 m2_11504_36908# a_97400_80515# 0 $ **FLOATING
C616 m2_11348_36908# a_97400_80515# 0 $ **FLOATING
C617 m2_11192_36908# a_97400_80515# 0 $ **FLOATING
C618 m2_11036_36908# a_97400_80515# 0 $ **FLOATING
C619 m2_12112_37064# a_97400_80515# 0 $ **FLOATING
C620 m2_11956_37064# a_97400_80515# 0 $ **FLOATING
C621 m2_11800_37064# a_97400_80515# 0 $ **FLOATING
C622 m2_11644_37064# a_97400_80515# 0 $ **FLOATING
C623 m2_11488_37064# a_97400_80515# 0 $ **FLOATING
C624 m2_11332_37064# a_97400_80515# 0 $ **FLOATING
C625 m2_11176_37064# a_97400_80515# 0 $ **FLOATING
C626 m2_11020_37064# a_97400_80515# 0 $ **FLOATING
C627 m2_12252_37220# a_97400_80515# 0 $ **FLOATING
C628 m2_12096_37220# a_97400_80515# 0 $ **FLOATING
C629 m2_11940_37220# a_97400_80515# 0 $ **FLOATING
C630 m2_11784_37220# a_97400_80515# 0 $ **FLOATING
C631 m2_11004_37220# a_97400_80515# 0 $ **FLOATING
C632 m2_12236_37376# a_97400_80515# 0 $ **FLOATING
C633 m2_12080_37376# a_97400_80515# 0 $ **FLOATING
C634 m2_11924_37376# a_97400_80515# 0 $ **FLOATING
C635 m2_11768_37376# a_97400_80515# 0 $ **FLOATING
C636 m2_11000_37376# a_97400_80515# 0 $ **FLOATING
C637 m2_12220_37532# a_97400_80515# 0 $ **FLOATING
C638 m2_12064_37532# a_97400_80515# 0 $ **FLOATING
C639 m2_11908_37532# a_97400_80515# 0 $ **FLOATING
C640 m2_11752_37532# a_97400_80515# 0 $ **FLOATING
C641 m2_11596_37532# a_97400_80515# 0 $ **FLOATING
C642 m2_11440_37532# a_97400_80515# 0 $ **FLOATING
C643 m2_11284_37532# a_97400_80515# 0 $ **FLOATING
C644 m2_11128_37532# a_97400_80515# 0 $ **FLOATING
C645 m2_11000_37532# a_97400_80515# 0 $ **FLOATING
C646 m2_12204_37688# a_97400_80515# 0 $ **FLOATING
C647 m2_12048_37688# a_97400_80515# 0 $ **FLOATING
C648 m2_11892_37688# a_97400_80515# 0 $ **FLOATING
C649 m2_11736_37688# a_97400_80515# 0 $ **FLOATING
C650 m2_11580_37688# a_97400_80515# 0 $ **FLOATING
C651 m2_11424_37688# a_97400_80515# 0 $ **FLOATING
C652 m2_11268_37688# a_97400_80515# 0 $ **FLOATING
C653 m2_11112_37688# a_97400_80515# 0 $ **FLOATING
C654 m2_11000_37688# a_97400_80515# 0 $ **FLOATING
C655 m2_12360_37940# a_97400_80515# 0 $ **FLOATING
C656 m2_12188_37844# a_97400_80515# 0 $ **FLOATING
C657 m2_12032_37844# a_97400_80515# 0 $ **FLOATING
C658 m2_11876_37844# a_97400_80515# 0 $ **FLOATING
C659 m2_11720_37844# a_97400_80515# 0 $ **FLOATING
C660 m2_11564_37844# a_97400_80515# 0 $ **FLOATING
C661 m2_11408_37844# a_97400_80515# 0 $ **FLOATING
C662 m2_11252_37844# a_97400_80515# 0 $ **FLOATING
C663 m2_11096_37844# a_97400_80515# 0 $ **FLOATING
C664 m2_11000_37844# a_97400_80515# 0 $ **FLOATING
C665 m2_12172_38000# a_97400_80515# 0 $ **FLOATING
C666 m2_12016_38000# a_97400_80515# 0 $ **FLOATING
C667 m2_11860_38000# a_97400_80515# 0 $ **FLOATING
C668 m2_11704_38000# a_97400_80515# 0 $ **FLOATING
C669 m2_11548_38000# a_97400_80515# 0 $ **FLOATING
C670 m2_11392_38000# a_97400_80515# 0 $ **FLOATING
C671 m2_11236_38000# a_97400_80515# 0 $ **FLOATING
C672 m2_11080_38000# a_97400_80515# 0 $ **FLOATING
C673 m2_11000_38000# a_97400_80515# 0 $ **FLOATING
C674 m2_98080_80040# a_97400_80515# 0 $ **FLOATING
C675 m2_100430_80110# a_97400_80515# 0 $ **FLOATING
C676 m2_100320_80240# a_97400_80515# 0 $ **FLOATING
C677 m2_99870_80110# a_97400_80515# 0 $ **FLOATING
C678 m2_99760_80440# a_97400_80515# 0 $ **FLOATING
C679 m2_99310_80110# a_97400_80515# 0 $ **FLOATING
C680 m2_99200_80140# a_97400_80515# 0 $ **FLOATING
C681 m2_98750_80110# a_97400_80515# 0 $ **FLOATING
C682 m2_98640_80340# a_97400_80515# 0 $ **FLOATING
C683 m2_98190_80110# a_97400_80515# 0 $ **FLOATING
C684 m2_97630_80110# a_97400_80515# 0 $ **FLOATING
C685 m2_97520_80240# a_97400_80515# 0 $ **FLOATING
C686 m2_97400_80110# a_97400_80515# 0 $ **FLOATING
C687 m2_98080_80540# a_97400_80515# 0 $ **FLOATING
C688 m2_100570_80670# a_97400_80515# 0 $ **FLOATING
C689 m2_100460_80940# a_97400_80515# 0 $ **FLOATING
C690 m2_100010_80670# a_97400_80515# 0 $ **FLOATING
C691 m2_99900_80640# a_97400_80515# 0 $ **FLOATING
C692 m2_99450_80670# a_97400_80515# 0 $ **FLOATING
C693 m2_99340_80840# a_97400_80515# 0 $ **FLOATING
C694 m2_98890_80670# a_97400_80515# 0 $ **FLOATING
C695 m2_98780_81040# a_97400_80515# 0 $ **FLOATING
C696 m2_98330_80670# a_97400_80515# 0 $ **FLOATING
C697 m2_98220_80740# a_97400_80515# 0 $ **FLOATING
C698 m2_97770_80670# a_97400_80515# 0 $ **FLOATING
C699 m2_97660_80940# a_97400_80515# 0 $ **FLOATING
C700 m2_97400_80670# a_97400_80515# 0 $ **FLOATING
C701 m2_100600_81140# a_97400_80515# 0 $ **FLOATING
C702 m2_97800_81140# a_97400_80515# 0 $ **FLOATING
C703 m2_100150_81230# a_97400_80515# 0 $ **FLOATING
C704 m2_100040_81340# a_97400_80515# 0 $ **FLOATING
C705 m2_99590_81230# a_97400_80515# 0 $ **FLOATING
C706 m2_99480_81540# a_97400_80515# 0 $ **FLOATING
C707 m2_99030_81230# a_97400_80515# 0 $ **FLOATING
C708 m2_98920_81240# a_97400_80515# 0 $ **FLOATING
C709 m2_98470_81230# a_97400_80515# 0 $ **FLOATING
C710 m2_98360_81440# a_97400_80515# 0 $ **FLOATING
C711 m2_97910_81230# a_97400_80515# 0 $ **FLOATING
C712 m2_97400_81230# a_97400_80515# 0 $ **FLOATING
C713 m2_100600_81640# a_97400_80515# 0 $ **FLOATING
C714 m2_97800_81640# a_97400_80515# 0 $ **FLOATING
C715 m2_100290_81790# a_97400_80515# 0 $ **FLOATING
C716 m2_100180_82040# a_97400_80515# 0 $ **FLOATING
C717 m2_99730_81790# a_97400_80515# 0 $ **FLOATING
C718 m2_99620_81740# a_97400_80515# 0 $ **FLOATING
C719 m2_99170_81790# a_97400_80515# 0 $ **FLOATING
C720 m2_99060_81940# a_97400_80515# 0 $ **FLOATING
C721 m2_98610_81790# a_97400_80515# 0 $ **FLOATING
C722 m2_98500_82140# a_97400_80515# 0 $ **FLOATING
C723 m2_98050_81790# a_97400_80515# 0 $ **FLOATING
C724 m2_97940_81840# a_97400_80515# 0 $ **FLOATING
C725 m2_97490_81790# a_97400_80515# 0 $ **FLOATING
C726 m2_97400_82040# a_97400_80515# 0 $ **FLOATING
C727 m2_100620_82240# a_97400_80515# 0 $ **FLOATING
C728 m2_100520_82240# a_97400_80515# 0 $ **FLOATING
C729 m2_100420_82240# a_97400_80515# 0 $ **FLOATING
C730 m2_100320_82240# a_97400_80515# 0 $ **FLOATING
C731 m2_100220_82240# a_97400_80515# 0 $ **FLOATING
C732 m2_100120_82240# a_97400_80515# 0 $ **FLOATING
C733 m2_100020_82240# a_97400_80515# 0 $ **FLOATING
C734 m2_99920_82240# a_97400_80515# 0 $ **FLOATING
C735 m2_99820_82240# a_97400_80515# 0 $ **FLOATING
C736 m2_99720_82240# a_97400_80515# 0 $ **FLOATING
C737 m2_99620_82240# a_97400_80515# 0 $ **FLOATING
C738 m2_99520_82240# a_97400_80515# 0 $ **FLOATING
C739 m2_99420_82240# a_97400_80515# 0 $ **FLOATING
C740 m2_99320_82240# a_97400_80515# 0 $ **FLOATING
C741 m2_99220_82240# a_97400_80515# 0 $ **FLOATING
C742 m2_99120_82240# a_97400_80515# 0 $ **FLOATING
C743 m2_99020_82240# a_97400_80515# 0 $ **FLOATING
C744 m2_98920_82240# a_97400_80515# 0 $ **FLOATING
C745 m2_98820_82240# a_97400_80515# 0 $ **FLOATING
C746 m2_98720_82240# a_97400_80515# 0 $ **FLOATING
C747 m2_98620_82240# a_97400_80515# 0 $ **FLOATING
C748 m2_98520_82240# a_97400_80515# 0 $ **FLOATING
C749 m2_98420_82240# a_97400_80515# 0 $ **FLOATING
C750 m2_98320_82240# a_97400_80515# 0 $ **FLOATING
C751 m2_98220_82240# a_97400_80515# 0 $ **FLOATING
C752 m2_98120_82240# a_97400_80515# 0 $ **FLOATING
C753 m2_98020_82240# a_97400_80515# 0 $ **FLOATING
C754 m2_97920_82240# a_97400_80515# 0 $ **FLOATING
C755 m2_97820_82240# a_97400_80515# 0 $ **FLOATING
C756 m2_97720_82240# a_97400_80515# 0 $ **FLOATING
C757 m2_97620_82240# a_97400_80515# 0 $ **FLOATING
C758 m2_97520_82240# a_97400_80515# 0 $ **FLOATING
C759 m2_97420_82240# a_97400_80515# 0 $ **FLOATING
C760 m2_100430_82350# a_97400_80515# 0 $ **FLOATING
C761 m2_100320_82740# a_97400_80515# 0 $ **FLOATING
C762 m2_99870_82350# a_97400_80515# 0 $ **FLOATING
C763 m2_99760_82440# a_97400_80515# 0 $ **FLOATING
C764 m2_99310_82350# a_97400_80515# 0 $ **FLOATING
C765 m2_99200_82640# a_97400_80515# 0 $ **FLOATING
C766 m2_98750_82350# a_97400_80515# 0 $ **FLOATING
C767 m2_98640_82340# a_97400_80515# 0 $ **FLOATING
C768 m2_98190_82350# a_97400_80515# 0 $ **FLOATING
C769 m2_98080_82540# a_97400_80515# 0 $ **FLOATING
C770 m2_97630_82350# a_97400_80515# 0 $ **FLOATING
C771 m2_97520_82740# a_97400_80515# 0 $ **FLOATING
C772 m2_97400_82350# a_97400_80515# 0 $ **FLOATING
C773 m2_99340_82840# a_97400_80515# 0 $ **FLOATING
C774 m2_100570_82910# a_97400_80515# 0 $ **FLOATING
C775 m2_100460_82940# a_97400_80515# 0 $ **FLOATING
C776 m2_100010_82910# a_97400_80515# 0 $ **FLOATING
C777 m2_99900_83140# a_97400_80515# 0 $ **FLOATING
C778 m2_99450_82910# a_97400_80515# 0 $ **FLOATING
C779 m2_98890_82910# a_97400_80515# 0 $ **FLOATING
C780 m2_98780_83040# a_97400_80515# 0 $ **FLOATING
C781 m2_98330_82910# a_97400_80515# 0 $ **FLOATING
C782 m2_97770_82910# a_97400_80515# 0 $ **FLOATING
C783 m2_97660_82940# a_97400_80515# 0 $ **FLOATING
C784 m2_97400_82910# a_97400_80515# 0 $ **FLOATING
C785 m1_11890_35630# a_97400_80515# 0 $ **FLOATING
C786 m1_11718_35600# a_97400_80515# 0 $ **FLOATING
C787 m1_11562_35600# a_97400_80515# 0 $ **FLOATING
C788 m1_11406_35600# a_97400_80515# 0 $ **FLOATING
C789 m1_11250_35600# a_97400_80515# 0 $ **FLOATING
C790 m1_11094_35600# a_97400_80515# 0 $ **FLOATING
C791 m1_11000_35600# a_97400_80515# 0 $ **FLOATING
C792 m1_12080_35736# a_97400_80515# 3.7989600000000005e-16
C793 m1_11000_35822# a_97400_80515# 3.5300800000000001e-16
C794 m1_11050_35930# a_97400_80515# 0 $ **FLOATING
C795 m1_11000_35930# a_97400_80515# 0 $ **FLOATING
C796 m1_11070_36030# a_97400_80515# 0 $ **FLOATING
C797 m1_11000_36058# a_97400_80515# 0 $ **FLOATING
C798 m1_13370_36214# a_97400_80515# 0 $ **FLOATING
C799 m1_13214_36214# a_97400_80515# 0 $ **FLOATING
C800 m1_13058_36214# a_97400_80515# 0 $ **FLOATING
C801 m1_12902_36214# a_97400_80515# 0 $ **FLOATING
C802 m1_12746_36214# a_97400_80515# 0 $ **FLOATING
C803 m1_12590_36214# a_97400_80515# 0 $ **FLOATING
C804 m1_12434_36214# a_97400_80515# 0 $ **FLOATING
C805 m1_12278_36214# a_97400_80515# 0 $ **FLOATING
C806 m1_12122_36214# a_97400_80515# 0 $ **FLOATING
C807 m1_11966_36214# a_97400_80515# 0 $ **FLOATING
C808 m1_11810_36214# a_97400_80515# 0 $ **FLOATING
C809 m1_11654_36214# a_97400_80515# 0 $ **FLOATING
C810 m1_11498_36214# a_97400_80515# 0 $ **FLOATING
C811 m1_11342_36214# a_97400_80515# 0 $ **FLOATING
C812 m1_11186_36214# a_97400_80515# 0 $ **FLOATING
C813 m1_11030_36214# a_97400_80515# 0 $ **FLOATING
C814 m1_13354_36370# a_97400_80515# 0 $ **FLOATING
C815 m1_13198_36370# a_97400_80515# 0 $ **FLOATING
C816 m1_13042_36370# a_97400_80515# 0 $ **FLOATING
C817 m1_12886_36370# a_97400_80515# 0 $ **FLOATING
C818 m1_12730_36370# a_97400_80515# 0 $ **FLOATING
C819 m1_12574_36370# a_97400_80515# 0 $ **FLOATING
C820 m1_12418_36370# a_97400_80515# 0 $ **FLOATING
C821 m1_12262_36370# a_97400_80515# 0 $ **FLOATING
C822 m1_12106_36370# a_97400_80515# 0 $ **FLOATING
C823 m1_11950_36370# a_97400_80515# 0 $ **FLOATING
C824 m1_11794_36370# a_97400_80515# 0 $ **FLOATING
C825 m1_11638_36370# a_97400_80515# 0 $ **FLOATING
C826 m1_11482_36370# a_97400_80515# 0 $ **FLOATING
C827 m1_11326_36370# a_97400_80515# 0 $ **FLOATING
C828 m1_11170_36370# a_97400_80515# 0 $ **FLOATING
C829 m1_11014_36370# a_97400_80515# 0 $ **FLOATING
C830 m1_13136_36772# a_97400_80515# 1.31212e-16
C831 m1_12838_36838# a_97400_80515# 0 $ **FLOATING
C832 m1_12682_36838# a_97400_80515# 0 $ **FLOATING
C833 m1_12526_36838# a_97400_80515# 0 $ **FLOATING
C834 m1_12370_36838# a_97400_80515# 0 $ **FLOATING
C835 m1_12214_36838# a_97400_80515# 0 $ **FLOATING
C836 m1_12058_36838# a_97400_80515# 0 $ **FLOATING
C837 m1_11902_36838# a_97400_80515# 0 $ **FLOATING
C838 m1_11746_36838# a_97400_80515# 0 $ **FLOATING
C839 m1_11590_36838# a_97400_80515# 0 $ **FLOATING
C840 m1_11434_36838# a_97400_80515# 0 $ **FLOATING
C841 m1_11278_36838# a_97400_80515# 0 $ **FLOATING
C842 m1_11122_36838# a_97400_80515# 0 $ **FLOATING
C843 m1_11000_36838# a_97400_80515# 0 $ **FLOATING
C844 m1_13446_36994# a_97400_80515# 0 $ **FLOATING
C845 m1_13290_36994# a_97400_80515# 0 $ **FLOATING
C846 m1_13134_36994# a_97400_80515# 0 $ **FLOATING
C847 m1_12978_36994# a_97400_80515# 0 $ **FLOATING
C848 m1_12822_36994# a_97400_80515# 0 $ **FLOATING
C849 m1_12666_36994# a_97400_80515# 0 $ **FLOATING
C850 m1_12510_36994# a_97400_80515# 0 $ **FLOATING
C851 m1_12354_36994# a_97400_80515# 0 $ **FLOATING
C852 m1_12198_36994# a_97400_80515# 0 $ **FLOATING
C853 m1_12042_36994# a_97400_80515# 0 $ **FLOATING
C854 m1_11886_36994# a_97400_80515# 0 $ **FLOATING
C855 m1_11730_36994# a_97400_80515# 0 $ **FLOATING
C856 m1_11574_36994# a_97400_80515# 0 $ **FLOATING
C857 m1_11418_36994# a_97400_80515# 0 $ **FLOATING
C858 m1_11262_36994# a_97400_80515# 0 $ **FLOATING
C859 m1_11106_36994# a_97400_80515# 0 $ **FLOATING
C860 m1_11000_36994# a_97400_80515# 0 $ **FLOATING
C861 m1_11000_37150# a_97400_80515# 0 $ **FLOATING
C862 m1_11000_37306# a_97400_80515# 0 $ **FLOATING
C863 m1_13450_37430# a_97400_80515# 0 $ **FLOATING
C864 m1_13350_37430# a_97400_80515# 0 $ **FLOATING
C865 m1_13250_37430# a_97400_80515# 0 $ **FLOATING
C866 m1_13150_37430# a_97400_80515# 0 $ **FLOATING
C867 m1_13050_37430# a_97400_80515# 0 $ **FLOATING
C868 m1_12950_37430# a_97400_80515# 0 $ **FLOATING
C869 m1_12850_37430# a_97400_80515# 0 $ **FLOATING
C870 m1_12750_37430# a_97400_80515# 0 $ **FLOATING
C871 m1_12650_37430# a_97400_80515# 0 $ **FLOATING
C872 m1_12550_37430# a_97400_80515# 0 $ **FLOATING
C873 m1_12450_37430# a_97400_80515# 0 $ **FLOATING
C874 m1_12350_37430# a_97400_80515# 0 $ **FLOATING
C875 m1_12250_37430# a_97400_80515# 0 $ **FLOATING
C876 m1_12150_37430# a_97400_80515# 0 $ **FLOATING
C877 m1_12050_37430# a_97400_80515# 0 $ **FLOATING
C878 m1_11950_37430# a_97400_80515# 0 $ **FLOATING
C879 m1_11850_37430# a_97400_80515# 0 $ **FLOATING
C880 m1_11750_37430# a_97400_80515# 0 $ **FLOATING
C881 m1_11650_37430# a_97400_80515# 0 $ **FLOATING
C882 m1_11550_37430# a_97400_80515# 0 $ **FLOATING
C883 m1_11450_37430# a_97400_80515# 0 $ **FLOATING
C884 m1_11350_37430# a_97400_80515# 0 $ **FLOATING
C885 m1_11250_37430# a_97400_80515# 0 $ **FLOATING
C886 m1_11150_37430# a_97400_80515# 0 $ **FLOATING
C887 m1_11000_37462# a_97400_80515# 0 $ **FLOATING
C888 m1_13382_37618# a_97400_80515# 0 $ **FLOATING
C889 m1_13226_37618# a_97400_80515# 0 $ **FLOATING
C890 m1_13070_37618# a_97400_80515# 0 $ **FLOATING
C891 m1_12914_37618# a_97400_80515# 0 $ **FLOATING
C892 m1_12758_37618# a_97400_80515# 0 $ **FLOATING
C893 m1_12602_37618# a_97400_80515# 0 $ **FLOATING
C894 m1_12446_37618# a_97400_80515# 0 $ **FLOATING
C895 m1_12290_37618# a_97400_80515# 0 $ **FLOATING
C896 m1_12134_37618# a_97400_80515# 0 $ **FLOATING
C897 m1_11978_37618# a_97400_80515# 0 $ **FLOATING
C898 m1_11822_37618# a_97400_80515# 0 $ **FLOATING
C899 m1_11666_37618# a_97400_80515# 0 $ **FLOATING
C900 m1_11510_37618# a_97400_80515# 0 $ **FLOATING
C901 m1_11354_37618# a_97400_80515# 0 $ **FLOATING
C902 m1_11198_37618# a_97400_80515# 0 $ **FLOATING
C903 m1_11042_37618# a_97400_80515# 0 $ **FLOATING
C904 m1_11000_37618# a_97400_80515# 0 $ **FLOATING
C905 m1_100570_80362# a_97400_80515# 0 $ **FLOATING
C906 m1_100414_80362# a_97400_80515# 0 $ **FLOATING
C907 m1_100258_80362# a_97400_80515# 0 $ **FLOATING
C908 m1_100102_80362# a_97400_80515# 0 $ **FLOATING
C909 m1_99946_80362# a_97400_80515# 0 $ **FLOATING
C910 m1_99790_80362# a_97400_80515# 0 $ **FLOATING
C911 m1_99634_80362# a_97400_80515# 0 $ **FLOATING
C912 m1_99478_80362# a_97400_80515# 0 $ **FLOATING
C913 m1_99322_80362# a_97400_80515# 0 $ **FLOATING
C914 m1_99166_80362# a_97400_80515# 0 $ **FLOATING
C915 m1_99010_80362# a_97400_80515# 0 $ **FLOATING
C916 m1_98854_80362# a_97400_80515# 0 $ **FLOATING
C917 m1_98698_80362# a_97400_80515# 0 $ **FLOATING
C918 m1_98542_80362# a_97400_80515# 0 $ **FLOATING
C919 m1_98386_80362# a_97400_80515# 0 $ **FLOATING
C920 m1_98230_80362# a_97400_80515# 0 $ **FLOATING
C921 m1_98074_80362# a_97400_80515# 0 $ **FLOATING
C922 m1_97918_80362# a_97400_80515# 0 $ **FLOATING
C923 m1_97762_80362# a_97400_80515# 0 $ **FLOATING
C924 m1_97606_80362# a_97400_80515# 0 $ **FLOATING
C925 m1_97450_80362# a_97400_80515# 0 $ **FLOATING
C926 m1_97400_80362# a_97400_80515# 0 $ **FLOATING
C927 m1_100678_80830# a_97400_80515# 0 $ **FLOATING
C928 m1_100522_80830# a_97400_80515# 0 $ **FLOATING
C929 m1_100366_80830# a_97400_80515# 0 $ **FLOATING
C930 m1_100210_80830# a_97400_80515# 0 $ **FLOATING
C931 m1_100054_80830# a_97400_80515# 0 $ **FLOATING
C932 m1_99898_80830# a_97400_80515# 0 $ **FLOATING
C933 m1_99742_80830# a_97400_80515# 0 $ **FLOATING
C934 m1_99586_80830# a_97400_80515# 0 $ **FLOATING
C935 m1_99430_80830# a_97400_80515# 0 $ **FLOATING
C936 m1_99274_80830# a_97400_80515# 0 $ **FLOATING
C937 m1_99118_80830# a_97400_80515# 0 $ **FLOATING
C938 m1_98962_80830# a_97400_80515# 0 $ **FLOATING
C939 m1_98806_80830# a_97400_80515# 0 $ **FLOATING
C940 m1_98650_80830# a_97400_80515# 0 $ **FLOATING
C941 m1_98494_80830# a_97400_80515# 0 $ **FLOATING
C942 m1_98338_80830# a_97400_80515# 0 $ **FLOATING
C943 m1_98182_80830# a_97400_80515# 0 $ **FLOATING
C944 m1_98026_80830# a_97400_80515# 0 $ **FLOATING
C945 m1_97870_80830# a_97400_80515# 0 $ **FLOATING
C946 m1_97714_80830# a_97400_80515# 0 $ **FLOATING
C947 m1_97558_80830# a_97400_80515# 0 $ **FLOATING
C948 m1_97402_80830# a_97400_80515# 0 $ **FLOATING
C949 m1_100670_81030# a_97400_80515# 0 $ **FLOATING
C950 m1_100570_81030# a_97400_80515# 0 $ **FLOATING
C951 m1_100470_81030# a_97400_80515# 0 $ **FLOATING
C952 m1_100370_81030# a_97400_80515# 0 $ **FLOATING
C953 m1_100270_81030# a_97400_80515# 0 $ **FLOATING
C954 m1_100170_81030# a_97400_80515# 0 $ **FLOATING
C955 m1_100070_81030# a_97400_80515# 0 $ **FLOATING
C956 m1_99970_81030# a_97400_80515# 0 $ **FLOATING
C957 m1_99870_81030# a_97400_80515# 0 $ **FLOATING
C958 m1_99770_81030# a_97400_80515# 0 $ **FLOATING
C959 m1_99670_81030# a_97400_80515# 0 $ **FLOATING
C960 m1_99570_81030# a_97400_80515# 0 $ **FLOATING
C961 m1_99470_81030# a_97400_80515# 0 $ **FLOATING
C962 m1_99370_81030# a_97400_80515# 0 $ **FLOATING
C963 m1_99270_81030# a_97400_80515# 0 $ **FLOATING
C964 m1_99170_81030# a_97400_80515# 0 $ **FLOATING
C965 m1_99070_81030# a_97400_80515# 0 $ **FLOATING
C966 m1_98970_81030# a_97400_80515# 0 $ **FLOATING
C967 m1_98870_81030# a_97400_80515# 0 $ **FLOATING
C968 m1_98770_81030# a_97400_80515# 0 $ **FLOATING
C969 m1_98670_81030# a_97400_80515# 0 $ **FLOATING
C970 m1_98570_81030# a_97400_80515# 0 $ **FLOATING
C971 m1_98470_81030# a_97400_80515# 0 $ **FLOATING
C972 m1_98370_81030# a_97400_80515# 0 $ **FLOATING
C973 m1_98270_81030# a_97400_80515# 0 $ **FLOATING
C974 m1_98170_81030# a_97400_80515# 0 $ **FLOATING
C975 m1_98070_81030# a_97400_80515# 0 $ **FLOATING
C976 m1_97970_81030# a_97400_80515# 0 $ **FLOATING
C977 m1_97870_81030# a_97400_80515# 0 $ **FLOATING
C978 m1_97770_81030# a_97400_80515# 0 $ **FLOATING
C979 m1_97670_81030# a_97400_80515# 0 $ **FLOATING
C980 m1_97570_81030# a_97400_80515# 0 $ **FLOATING
C981 m1_97470_81030# a_97400_80515# 0 $ **FLOATING
C982 m1_97400_81030# a_97400_80515# 0 $ **FLOATING
C983 m1_100630_81330# a_97400_80515# 0 $ **FLOATING
C984 m1_100530_81330# a_97400_80515# 0 $ **FLOATING
C985 m1_100430_81330# a_97400_80515# 0 $ **FLOATING
C986 m1_100330_81330# a_97400_80515# 0 $ **FLOATING
C987 m1_100230_81330# a_97400_80515# 0 $ **FLOATING
C988 m1_100130_81330# a_97400_80515# 0 $ **FLOATING
C989 m1_100030_81330# a_97400_80515# 0 $ **FLOATING
C990 m1_99930_81330# a_97400_80515# 0 $ **FLOATING
C991 m1_99830_81330# a_97400_80515# 0 $ **FLOATING
C992 m1_99730_81330# a_97400_80515# 0 $ **FLOATING
C993 m1_99630_81330# a_97400_80515# 0 $ **FLOATING
C994 m1_99530_81330# a_97400_80515# 0 $ **FLOATING
C995 m1_99430_81330# a_97400_80515# 0 $ **FLOATING
C996 m1_99330_81330# a_97400_80515# 0 $ **FLOATING
C997 m1_99230_81330# a_97400_80515# 0 $ **FLOATING
C998 m1_99130_81330# a_97400_80515# 0 $ **FLOATING
C999 m1_99030_81330# a_97400_80515# 0 $ **FLOATING
C1000 m1_98930_81330# a_97400_80515# 0 $ **FLOATING
C1001 m1_98830_81330# a_97400_80515# 0 $ **FLOATING
C1002 m1_98730_81330# a_97400_80515# 0 $ **FLOATING
C1003 m1_98630_81330# a_97400_80515# 0 $ **FLOATING
C1004 m1_98530_81330# a_97400_80515# 0 $ **FLOATING
C1005 m1_98430_81330# a_97400_80515# 0 $ **FLOATING
C1006 m1_98330_81330# a_97400_80515# 0 $ **FLOATING
C1007 m1_98230_81330# a_97400_80515# 0 $ **FLOATING
C1008 m1_98130_81330# a_97400_80515# 0 $ **FLOATING
C1009 m1_98030_81330# a_97400_80515# 0 $ **FLOATING
C1010 m1_97930_81330# a_97400_80515# 0 $ **FLOATING
C1011 m1_97830_81330# a_97400_80515# 0 $ **FLOATING
C1012 m1_97730_81330# a_97400_80515# 0 $ **FLOATING
C1013 m1_97630_81330# a_97400_80515# 0 $ **FLOATING
C1014 m1_97530_81330# a_97400_80515# 0 $ **FLOATING
C1015 m1_97430_81330# a_97400_80515# 0 $ **FLOATING
C1016 m1_100614_81454# a_97400_80515# 0 $ **FLOATING
C1017 m1_100458_81454# a_97400_80515# 0 $ **FLOATING
C1018 m1_100302_81454# a_97400_80515# 0 $ **FLOATING
C1019 m1_100146_81454# a_97400_80515# 0 $ **FLOATING
C1020 m1_99990_81454# a_97400_80515# 0 $ **FLOATING
C1021 m1_99834_81454# a_97400_80515# 0 $ **FLOATING
C1022 m1_99678_81454# a_97400_80515# 0 $ **FLOATING
C1023 m1_99522_81454# a_97400_80515# 0 $ **FLOATING
C1024 m1_99366_81454# a_97400_80515# 0 $ **FLOATING
C1025 m1_99210_81454# a_97400_80515# 0 $ **FLOATING
C1026 m1_99054_81454# a_97400_80515# 0 $ **FLOATING
C1027 m1_98898_81454# a_97400_80515# 0 $ **FLOATING
C1028 m1_98742_81454# a_97400_80515# 0 $ **FLOATING
C1029 m1_98586_81454# a_97400_80515# 0 $ **FLOATING
C1030 m1_98430_81454# a_97400_80515# 0 $ **FLOATING
C1031 m1_98274_81454# a_97400_80515# 0 $ **FLOATING
C1032 m1_98118_81454# a_97400_80515# 0 $ **FLOATING
C1033 m1_97962_81454# a_97400_80515# 0 $ **FLOATING
C1034 m1_97806_81454# a_97400_80515# 0 $ **FLOATING
C1035 m1_97650_81454# a_97400_80515# 0 $ **FLOATING
C1036 m1_97494_81454# a_97400_80515# 0 $ **FLOATING
C1037 m1_97400_81454# a_97400_80515# 0 $ **FLOATING
C1038 m1_100566_81922# a_97400_80515# 0 $ **FLOATING
C1039 m1_100410_81922# a_97400_80515# 0 $ **FLOATING
C1040 m1_100254_81922# a_97400_80515# 0 $ **FLOATING
C1041 m1_100098_81922# a_97400_80515# 0 $ **FLOATING
C1042 m1_99942_81922# a_97400_80515# 0 $ **FLOATING
C1043 m1_99786_81922# a_97400_80515# 0 $ **FLOATING
C1044 m1_99630_81922# a_97400_80515# 0 $ **FLOATING
C1045 m1_99474_81922# a_97400_80515# 0 $ **FLOATING
C1046 m1_99318_81922# a_97400_80515# 0 $ **FLOATING
C1047 m1_99162_81922# a_97400_80515# 0 $ **FLOATING
C1048 m1_99006_81922# a_97400_80515# 0 $ **FLOATING
C1049 m1_98850_81922# a_97400_80515# 0 $ **FLOATING
C1050 m1_98694_81922# a_97400_80515# 0 $ **FLOATING
C1051 m1_98538_81922# a_97400_80515# 0 $ **FLOATING
C1052 m1_98382_81922# a_97400_80515# 0 $ **FLOATING
C1053 m1_98226_81922# a_97400_80515# 0 $ **FLOATING
C1054 m1_98070_81922# a_97400_80515# 0 $ **FLOATING
C1055 m1_97914_81922# a_97400_80515# 0 $ **FLOATING
C1056 m1_97758_81922# a_97400_80515# 0 $ **FLOATING
C1057 m1_97602_81922# a_97400_80515# 0 $ **FLOATING
C1058 m1_97446_81922# a_97400_80515# 0 $ **FLOATING
C1059 m1_97400_81922# a_97400_80515# 0 $ **FLOATING
C1060 m1_100550_82078# a_97400_80515# 0 $ **FLOATING
C1061 m1_100394_82078# a_97400_80515# 0 $ **FLOATING
C1062 m1_100238_82078# a_97400_80515# 0 $ **FLOATING
C1063 m1_100082_82078# a_97400_80515# 0 $ **FLOATING
C1064 m1_99926_82078# a_97400_80515# 0 $ **FLOATING
C1065 m1_99770_82078# a_97400_80515# 0 $ **FLOATING
C1066 m1_99614_82078# a_97400_80515# 0 $ **FLOATING
C1067 m1_99458_82078# a_97400_80515# 0 $ **FLOATING
C1068 m1_99302_82078# a_97400_80515# 0 $ **FLOATING
C1069 m1_99146_82078# a_97400_80515# 0 $ **FLOATING
C1070 m1_98990_82078# a_97400_80515# 0 $ **FLOATING
C1071 m1_98834_82078# a_97400_80515# 0 $ **FLOATING
C1072 m1_98678_82078# a_97400_80515# 0 $ **FLOATING
C1073 m1_98522_82078# a_97400_80515# 0 $ **FLOATING
C1074 m1_98366_82078# a_97400_80515# 0 $ **FLOATING
C1075 m1_98210_82078# a_97400_80515# 0 $ **FLOATING
C1076 m1_98054_82078# a_97400_80515# 0 $ **FLOATING
C1077 m1_97898_82078# a_97400_80515# 0 $ **FLOATING
C1078 m1_97742_82078# a_97400_80515# 0 $ **FLOATING
C1079 m1_97586_82078# a_97400_80515# 0 $ **FLOATING
C1080 m1_97430_82078# a_97400_80515# 0 $ **FLOATING
C1081 m1_100690_82234# a_97400_80515# 0 $ **FLOATING
C1082 m1_100534_82234# a_97400_80515# 0 $ **FLOATING
C1083 m1_100378_82234# a_97400_80515# 0 $ **FLOATING
C1084 m1_100222_82234# a_97400_80515# 0 $ **FLOATING
C1085 m1_100066_82234# a_97400_80515# 0 $ **FLOATING
C1086 m1_99910_82234# a_97400_80515# 0 $ **FLOATING
C1087 m1_99754_82234# a_97400_80515# 0 $ **FLOATING
C1088 m1_99598_82234# a_97400_80515# 0 $ **FLOATING
C1089 m1_99442_82234# a_97400_80515# 0 $ **FLOATING
C1090 m1_99286_82234# a_97400_80515# 0 $ **FLOATING
C1091 m1_99130_82234# a_97400_80515# 0 $ **FLOATING
C1092 m1_98974_82234# a_97400_80515# 0 $ **FLOATING
C1093 m1_98818_82234# a_97400_80515# 0 $ **FLOATING
C1094 m1_98662_82234# a_97400_80515# 0 $ **FLOATING
C1095 m1_98506_82234# a_97400_80515# 0 $ **FLOATING
C1096 m1_98350_82234# a_97400_80515# 0 $ **FLOATING
C1097 m1_98194_82234# a_97400_80515# 0 $ **FLOATING
C1098 m1_98038_82234# a_97400_80515# 0 $ **FLOATING
C1099 m1_97882_82234# a_97400_80515# 0 $ **FLOATING
C1100 m1_97726_82234# a_97400_80515# 0 $ **FLOATING
C1101 m1_97570_82234# a_97400_80515# 0 $ **FLOATING
C1102 m1_97414_82234# a_97400_80515# 0 $ **FLOATING
C1103 m1_100540_82420# a_97400_80515# 0 $ **FLOATING
C1104 m1_100300_82420# a_97400_80515# 0 $ **FLOATING
C1105 m1_100060_82420# a_97400_80515# 0 $ **FLOATING
C1106 m1_99820_82420# a_97400_80515# 0 $ **FLOATING
C1107 m1_99580_82420# a_97400_80515# 0 $ **FLOATING
C1108 m1_99340_82420# a_97400_80515# 0 $ **FLOATING
C1109 m1_99100_82420# a_97400_80515# 0 $ **FLOATING
C1110 m1_98860_82420# a_97400_80515# 0 $ **FLOATING
C1111 m1_98620_82420# a_97400_80515# 0 $ **FLOATING
C1112 m1_98380_82420# a_97400_80515# 0 $ **FLOATING
C1113 m1_98140_82420# a_97400_80515# 0 $ **FLOATING
C1114 m1_97900_82420# a_97400_80515# 0 $ **FLOATING
C1115 m1_97660_82420# a_97400_80515# 0 $ **FLOATING
C1116 m1_97420_82420# a_97400_80515# 0 $ **FLOATING
C1117 m1_100680_82660# a_97400_80515# 0 $ **FLOATING
C1118 m1_100440_82660# a_97400_80515# 0 $ **FLOATING
C1119 m1_100200_82660# a_97400_80515# 0 $ **FLOATING
C1120 m1_99960_82660# a_97400_80515# 0 $ **FLOATING
C1121 m1_99720_82660# a_97400_80515# 0 $ **FLOATING
C1122 m1_99480_82660# a_97400_80515# 0 $ **FLOATING
C1123 m1_99240_82660# a_97400_80515# 0 $ **FLOATING
C1124 m1_99000_82660# a_97400_80515# 0 $ **FLOATING
C1125 m1_98760_82660# a_97400_80515# 0 $ **FLOATING
C1126 m1_98520_82660# a_97400_80515# 0 $ **FLOATING
C1127 m1_98280_82660# a_97400_80515# 0 $ **FLOATING
C1128 m1_98040_82660# a_97400_80515# 0 $ **FLOATING
C1129 m1_97800_82660# a_97400_80515# 0 $ **FLOATING
C1130 m1_97560_82660# a_97400_80515# 0 $ **FLOATING
C1131 m1_97400_82660# a_97400_80515# 0 $ **FLOATING
C1132 m1_100570_82910# a_97400_80515# 0 $ **FLOATING
C1133 m1_100450_82930# a_97400_80515# 0 $ **FLOATING
C1134 m1_100470_83030# a_97400_80515# 0 $ **FLOATING
C1135 m1_100010_82910# a_97400_80515# 0 $ **FLOATING
C1136 m1_99890_83130# a_97400_80515# 0 $ **FLOATING
C1137 m1_99450_82910# a_97400_80515# 0 $ **FLOATING
C1138 m1_99350_82930# a_97400_80515# 0 $ **FLOATING
C1139 m1_98890_82910# a_97400_80515# 0 $ **FLOATING
C1140 m1_98770_83030# a_97400_80515# 0 $ **FLOATING
C1141 m1_98790_83130# a_97400_80515# 0 $ **FLOATING
C1142 m1_98330_82910# a_97400_80515# 0 $ **FLOATING
C1143 m1_97770_82910# a_97400_80515# 0 $ **FLOATING
C1144 m1_97650_82930# a_97400_80515# 0 $ **FLOATING
C1145 m1_97670_83030# a_97400_80515# 0 $ **FLOATING
C1146 m1_97400_82910# a_97400_80515# 0 $ **FLOATING
C1147 li_13458_35600# a_97400_80515# 0 $ **FLOATING
C1148 li_13242_35600# a_97400_80515# 0 $ **FLOATING
C1149 li_13026_35600# a_97400_80515# 0 $ **FLOATING
C1150 li_12810_35600# a_97400_80515# 0 $ **FLOATING
C1151 li_12594_35600# a_97400_80515# 0 $ **FLOATING
C1152 li_11730_35600# a_97400_80515# 0 $ **FLOATING
C1153 li_11514_35600# a_97400_80515# 0 $ **FLOATING
C1154 li_11298_35600# a_97400_80515# 0 $ **FLOATING
C1155 li_11654_35794# a_97400_80515# 0 $ **FLOATING
C1156 li_11438_35794# a_97400_80515# 0 $ **FLOATING
C1157 li_11794_36010# a_97400_80515# 0 $ **FLOATING
C1158 li_11578_36010# a_97400_80515# 0 $ **FLOATING
C1159 li_11362_36010# a_97400_80515# 0 $ **FLOATING
C1160 li_13446_36226# a_97400_80515# 0 $ **FLOATING
C1161 li_13230_36226# a_97400_80515# 0 $ **FLOATING
C1162 li_13014_36226# a_97400_80515# 0 $ **FLOATING
C1163 li_12798_36226# a_97400_80515# 0 $ **FLOATING
C1164 li_12582_36226# a_97400_80515# 0 $ **FLOATING
C1165 li_11718_36226# a_97400_80515# 0 $ **FLOATING
C1166 li_11502_36226# a_97400_80515# 0 $ **FLOATING
C1167 li_11000_35660# a_97400_80515# 0 $ **FLOATING
C1168 li_11642_36442# a_97400_80515# 0 $ **FLOATING
C1169 li_11426_36442# a_97400_80515# 0 $ **FLOATING
C1170 li_13434_36874# a_97400_80515# 0 $ **FLOATING
C1171 li_13218_36874# a_97400_80515# 0 $ **FLOATING
C1172 li_13002_36874# a_97400_80515# 0 $ **FLOATING
C1173 li_12786_36874# a_97400_80515# 0 $ **FLOATING
C1174 li_12570_36874# a_97400_80515# 0 $ **FLOATING
C1175 li_11782_36658# a_97400_80515# 0 $ **FLOATING
C1176 li_11566_36658# a_97400_80515# 0 $ **FLOATING
C1177 li_11706_36874# a_97400_80515# 0 $ **FLOATING
C1178 li_11490_36874# a_97400_80515# 0 $ **FLOATING
C1179 li_11000_36440# a_97400_80515# 0 $ **FLOATING
C1180 li_11630_37090# a_97400_80515# 0 $ **FLOATING
C1181 li_11414_37090# a_97400_80515# 0 $ **FLOATING
C1182 li_11770_37306# a_97400_80515# 0 $ **FLOATING
C1183 li_11554_37306# a_97400_80515# 0 $ **FLOATING
C1184 li_11338_37306# a_97400_80515# 0 $ **FLOATING
C1185 li_13422_37522# a_97400_80515# 0 $ **FLOATING
C1186 li_13206_37522# a_97400_80515# 0 $ **FLOATING
C1187 li_12990_37522# a_97400_80515# 0 $ **FLOATING
C1188 li_12774_37522# a_97400_80515# 0 $ **FLOATING
C1189 li_12558_37522# a_97400_80515# 0 $ **FLOATING
C1190 li_11694_37522# a_97400_80515# 0 $ **FLOATING
C1191 li_11478_37522# a_97400_80515# 0 $ **FLOATING
C1192 li_11000_37250# a_97400_80515# 0 $ **FLOATING
C1193 li_13346_37738# a_97400_80515# 0 $ **FLOATING
C1194 li_13130_37738# a_97400_80515# 0 $ **FLOATING
C1195 li_12914_37738# a_97400_80515# 0 $ **FLOATING
C1196 li_12698_37738# a_97400_80515# 0 $ **FLOATING
C1197 li_12482_37738# a_97400_80515# 0 $ **FLOATING
C1198 li_11618_37738# a_97400_80515# 0 $ **FLOATING
C1199 li_11070_37650# a_97400_80515# 0 $ **FLOATING
C1200 li_11758_37954# a_97400_80515# 0 $ **FLOATING
C1201 li_11542_37954# a_97400_80515# 0 $ **FLOATING
C1202 li_100582_82018# a_97400_80515# 0 $ **FLOATING
C1203 li_100366_82018# a_97400_80515# 0 $ **FLOATING
C1204 li_100150_82018# a_97400_80515# 0 $ **FLOATING
C1205 li_99934_82018# a_97400_80515# 0 $ **FLOATING
C1206 li_99718_82018# a_97400_80515# 0 $ **FLOATING
C1207 li_99502_82018# a_97400_80515# 0 $ **FLOATING
C1208 li_99286_82018# a_97400_80515# 0 $ **FLOATING
C1209 li_99070_82018# a_97400_80515# 0 $ **FLOATING
C1210 li_98854_82018# a_97400_80515# 0 $ **FLOATING
C1211 li_98638_82018# a_97400_80515# 0 $ **FLOATING
C1212 li_98422_82018# a_97400_80515# 0 $ **FLOATING
C1213 li_98206_82018# a_97400_80515# 0 $ **FLOATING
C1214 li_97990_82018# a_97400_80515# 0 $ **FLOATING
C1215 li_97774_82018# a_97400_80515# 0 $ **FLOATING
C1216 li_97558_82018# a_97400_80515# 0 $ **FLOATING
C1217 li_97400_82018# a_97400_80515# 0 $ **FLOATING
C1218 li_100506_82234# a_97400_80515# 0 $ **FLOATING
C1219 li_100290_82234# a_97400_80515# 0 $ **FLOATING
C1220 li_100074_82234# a_97400_80515# 0 $ **FLOATING
C1221 li_99858_82234# a_97400_80515# 0 $ **FLOATING
C1222 li_99642_82234# a_97400_80515# 0 $ **FLOATING
C1223 li_99426_82234# a_97400_80515# 0 $ **FLOATING
C1224 li_99210_82234# a_97400_80515# 0 $ **FLOATING
C1225 li_98994_82234# a_97400_80515# 0 $ **FLOATING
C1226 li_98778_82234# a_97400_80515# 0 $ **FLOATING
C1227 li_98562_82234# a_97400_80515# 0 $ **FLOATING
C1228 li_98346_82234# a_97400_80515# 0 $ **FLOATING
C1229 li_98130_82234# a_97400_80515# 0 $ **FLOATING
C1230 li_97914_82234# a_97400_80515# 0 $ **FLOATING
C1231 li_97698_82234# a_97400_80515# 0 $ **FLOATING
C1232 li_97482_82234# a_97400_80515# 0 $ **FLOATING
C1233 li_100070_82460# a_97400_80515# 0 $ **FLOATING
C1234 li_99290_82460# a_97400_80515# 0 $ **FLOATING
C1235 li_98510_82460# a_97400_80515# 0 $ **FLOATING
C1236 li_97730_82460# a_97400_80515# 0 $ **FLOATING
C1237 li_97400_82460# a_97400_80515# 0 $ **FLOATING
C1238 a_11000_35600# a_97400_80515# 0 $ **FLOATING
C1239 a_12111_35775# a_97400_80515# 2.6014299999999998e-16 $ **FLOATING
C1240 a_11672_35780# a_97400_80515# 0 $ **FLOATING
C1241 a_11456_35780# a_97400_80515# 0 $ **FLOATING
C1242 a_11240_35780# a_97400_80515# 0 $ **FLOATING
C1243 a_11024_35780# a_97400_80515# 0 $ **FLOATING
C1244 a_11504_35996# a_97400_80515# 0 $ **FLOATING
C1245 a_11288_35996# a_97400_80515# 0 $ **FLOATING
C1246 a_11072_35996# a_97400_80515# 0 $ **FLOATING
C1247 a_11552_36212# a_97400_80515# 0 $ **FLOATING
C1248 a_11336_36212# a_97400_80515# 0 $ **FLOATING
C1249 a_11120_36212# a_97400_80515# 0 $ **FLOATING
C1250 a_11000_36212# a_97400_80515# 0 $ **FLOATING
C1251 a_11600_36428# a_97400_80515# 0 $ **FLOATING
C1252 a_11384_36428# a_97400_80515# 0 $ **FLOATING
C1253 a_11168_36428# a_97400_80515# 0 $ **FLOATING
C1254 a_11000_36428# a_97400_80515# 0 $ **FLOATING
C1255 a_11648_36644# a_97400_80515# 0 $ **FLOATING
C1256 a_11432_36644# a_97400_80515# 0 $ **FLOATING
C1257 a_11216_36644# a_97400_80515# 0 $ **FLOATING
C1258 a_11000_36644# a_97400_80515# 0 $ **FLOATING
C1259 a_11696_36860# a_97400_80515# 0 $ **FLOATING
C1260 a_11480_36860# a_97400_80515# 0 $ **FLOATING
C1261 a_11264_36860# a_97400_80515# 0 $ **FLOATING
C1262 a_11048_36860# a_97400_80515# 0 $ **FLOATING
C1263 a_11528_37076# a_97400_80515# 0 $ **FLOATING
C1264 a_11312_37076# a_97400_80515# 0 $ **FLOATING
C1265 a_12043_36376# a_97400_80515# 1.0766500000000002e-15 $ **FLOATING
C1266 a_11576_37292# a_97400_80515# 0 $ **FLOATING
C1267 a_11360_37292# a_97400_80515# 0 $ **FLOATING
C1268 a_11144_37292# a_97400_80515# 0 $ **FLOATING
C1269 a_11624_37508# a_97400_80515# 0 $ **FLOATING
C1270 a_11408_37508# a_97400_80515# 0 $ **FLOATING
C1271 a_11192_37508# a_97400_80515# 0 $ **FLOATING
C1272 a_11672_37724# a_97400_80515# 0 $ **FLOATING
C1273 a_11456_37724# a_97400_80515# 0 $ **FLOATING
C1274 a_11240_37724# a_97400_80515# 0 $ **FLOATING
C1275 a_12058_35815# a_97400_80515# 3.6434400000000007e-15 $ **FLOATING
C1276 a_11000_37096# a_97400_80515# 0 $ **FLOATING
C1277 a_12098_38030# a_97400_80515# 3.4029800000000001e-18 $ **FLOATING
C1278 a_12043_37708# a_97400_80515# 1.3333499999999999e-15 $ **FLOATING
C1279 a_11504_37940# a_97400_80515# 0 $ **FLOATING
C1280 a_11288_37940# a_97400_80515# 0 $ **FLOATING
C1281 a_11098_37996# a_97400_80515# 0 $ **FLOATING
C1282 a_11000_37996# a_97400_80515# 0 $ **FLOATING
C1283 a_100107_80000# a_97400_80515# 2.2618000000000006e-16 $ **FLOATING
C1284 a_99003_80000# a_97400_80515# 3.0544800000000003e-16 $ **FLOATING
C1285 a_98267_80000# a_97400_80515# 9.5162400000000014e-17 $ **FLOATING
C1286 a_97400_80000# a_97400_80515# 2.3011199999999999e-16 $ **FLOATING
C1287 a_100568_82004# a_97400_80515# 0 $ **FLOATING
C1288 a_100352_82004# a_97400_80515# 0 $ **FLOATING
C1289 a_100136_82004# a_97400_80515# 0 $ **FLOATING
C1290 a_99920_82004# a_97400_80515# 0 $ **FLOATING
C1291 a_99704_82004# a_97400_80515# 0 $ **FLOATING
C1292 a_99488_82004# a_97400_80515# 0 $ **FLOATING
C1293 a_99272_82004# a_97400_80515# 0 $ **FLOATING
C1294 a_99056_82004# a_97400_80515# 0 $ **FLOATING
C1295 a_98840_82004# a_97400_80515# 0 $ **FLOATING
C1296 a_98624_82004# a_97400_80515# 0 $ **FLOATING
C1297 a_98408_82004# a_97400_80515# 0 $ **FLOATING
C1298 a_98192_82004# a_97400_80515# 0 $ **FLOATING
C1299 a_97976_82004# a_97400_80515# 0 $ **FLOATING
C1300 a_97760_82004# a_97400_80515# 0 $ **FLOATING
C1301 a_97544_82004# a_97400_80515# 0 $ **FLOATING
C1302 a_97400_82004# a_97400_80515# 0 $ **FLOATING
C1303 a_100616_82220# a_97400_80515# 0 $ **FLOATING
C1304 a_100400_82220# a_97400_80515# 0 $ **FLOATING
C1305 a_100184_82220# a_97400_80515# 0 $ **FLOATING
C1306 a_99968_82220# a_97400_80515# 0 $ **FLOATING
C1307 a_99752_82220# a_97400_80515# 0 $ **FLOATING
C1308 a_99536_82220# a_97400_80515# 0 $ **FLOATING
C1309 a_99320_82220# a_97400_80515# 0 $ **FLOATING
C1310 a_99104_82220# a_97400_80515# 0 $ **FLOATING
C1311 a_98888_82220# a_97400_80515# 0 $ **FLOATING
C1312 a_98672_82220# a_97400_80515# 0 $ **FLOATING
C1313 a_98456_82220# a_97400_80515# 0 $ **FLOATING
C1314 a_98240_82220# a_97400_80515# 0 $ **FLOATING
C1315 a_98024_82220# a_97400_80515# 0 $ **FLOATING
C1316 a_97808_82220# a_97400_80515# 0 $ **FLOATING
C1317 a_97592_82220# a_97400_80515# 0 $ **FLOATING
C1318 a_97400_82220# a_97400_80515# 0 $ **FLOATING
C1319 a_100648_82536# a_97400_80515# 0 $ **FLOATING
C1320 a_100402_82636# a_97400_80515# 0 $ **FLOATING
C1321 a_100450_82816# a_97400_80515# 0 $ **FLOATING
C1322 a_100452_83004# a_97400_80515# 0 $ **FLOATING
C1323 a_99512_82536# a_97400_80515# 0 $ **FLOATING
C1324 a_99274_82456# a_97400_80515# 0 $ **FLOATING
C1325 a_99322_82636# a_97400_80515# 0 $ **FLOATING
C1326 a_99296_83084# a_97400_80515# 0 $ **FLOATING
C1327 a_98376_82536# a_97400_80515# 0 $ **FLOATING
C1328 a_98194_82456# a_97400_80515# 0 $ **FLOATING
C1329 a_98120_82652# a_97400_80515# 0 $ **FLOATING
C1330 a_98168_82868# a_97400_80515# 0 $ **FLOATING
C1331 a_98206_83176# a_97400_80515# 0 $ **FLOATING
C1332 a_97400_82536# a_97400_80515# 0 $ **FLOATING
C1333 w_11978_35600# a_97400_80515# 2.3743199999999998e-16
C1334 w_11978_36316# a_97400_80515# 3.0500900000000002e-15 $ **FLOATING
C1335 w_11978_37648# a_97400_80515# 2.0932100000000003e-15 $ **FLOATING
C1336 w_97364_79964# a_97400_80515# 1.3847000000000001e-14 $ **FLOATING
C1337 w_97364_80959# a_97400_80515# 2.1808900000000003e-14 $ **FLOATING
C1338 a_97400_80515# a_97400_80515# 0 $ **FLOATING
.ends
