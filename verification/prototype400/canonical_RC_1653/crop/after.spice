* NGSPICE file created from RC_Area_Crop.ext - technology: sky130A

.subckt RC_Area_Crop
X0 a_65606_57680# a_65471_57390# a_65284_57370.t0 w_64971_58015# sky130_fd_pr__pfet_01v8 ad=0.135 pd=1.27 as=0.165 ps=1.33 w=1 l=0.15
X1 w_64971_58015# a_65371_58010# a_65303_58036# w_64971_58015# sky130_fd_pr__pfet_01v8 ad=0.096 pd=1.24 as=0.1088 ps=1.32 w=0.32 l=0.15
X2 w_64971_58015# a_65284_57370.t6 a_65227_57396# w_64971_58015# sky130_fd_pr__pfet_01v8 ad=0.1934 pd=1.475 as=0.3304 ps=2.83 w=1.12 l=0.15
X3 a_65323_57074# a_65509_57000# a_65135_57360# a_65135_57360# sky130_fd_pr__nfet_01v8_lvt ad=0.1036 pd=1.02 as=0.3361 ps=1.68 w=0.74 l=0.15
X4 a_65890_58036# a_65860_58010# w_64971_58015# w_64971_58015# sky130_fd_pr__pfet_01v8 ad=0.048 pd=0.62 as=0.0912 ps=1.21 w=0.32 l=0.15
X5 a_65795_57432# a_65393_57318# a_65135_57360# a_65135_57360# sky130_fd_pr__nfet_01v8_lvt ad=0.0864 pd=0.91 as=0.1344 ps=1.06 w=0.64 l=0.15
X6 w_64971_58015# a_65950_58010# a_65890_58036# w_64971_58015# sky130_fd_pr__pfet_01v8 ad=0.0912 pd=1.21 as=0.048 ps=0.62 w=0.32 l=0.15
X7 a_65135_57360# a_65341_57000# a_65323_57074# a_65135_57360# sky130_fd_pr__nfet_01v8_lvt ad=0.3361 pd=1.68 as=0.2109 ps=2.05 w=0.74 l=0.15
X8 a_65135_57360# a_65284_57370.t7 a_65227_57396# a_65135_57360# sky130_fd_pr__nfet_01v8_lvt ad=0.1389 pd=1.135 as=0.2081 ps=2.05 w=0.74 l=0.15
X9 a_65284_57370.t4 a_65509_57000# a_65798_57680# w_64971_58015# sky130_fd_pr__pfet_01v8 ad=0.295 pd=2.59 as=0.135 ps=1.27 w=1 l=0.15
X10 a_65640_57000# a_66085_57540# w_64971_58015# w_64971_58015# sky130_fd_pr__pfet_01v8 ad=0.1232 pd=2.46 as=0.3192 ps=2.81 w=1.12 l=0.15
X11 a_65798_57680# a_65393_57318# w_64971_58015# w_64971_58015# sky130_fd_pr__pfet_01v8 ad=0.135 pd=1.27 as=0.195 ps=1.39 w=1 l=0.15
X12 a_65144_58051# a_65114_58025# w_64971_58015# w_64971_58015# sky130_fd_pr__pfet_01v8 ad=0.07227 pd=1.08 as=0.04715 ps=0.63 w=0.245 l=0.15
X13 a_65423_57416# a_65393_57318# a_65135_57360# a_65135_57360# sky130_fd_pr__nfet_01v8_lvt ad=0.0768 pd=0.88 as=0.1389 ps=1.135 w=0.64 l=0.15
X14 a_65284_57370.t1 a_65471_57390# a_65423_57416# a_65135_57360# sky130_fd_pr__nfet_01v8_lvt ad=0.1222 pd=1.08 as=0.0768 ps=0.88 w=0.64 l=0.15
X15 a_65284_57370.t5 a_65509_57000# a_65795_57432# a_65135_57360# sky130_fd_pr__nfet_01v8_lvt ad=0.1733 pd=1.85 as=0.0864 ps=0.91 w=0.64 l=0.15
X16 a_65602_58036# a_65572_58010# w_64971_58015# w_64971_58015# sky130_fd_pr__pfet_01v8 ad=0.048 pd=0.62 as=0.0912 ps=1.21 w=0.32 l=0.15
X17 a_65284_57370.t3 a_65471_57390# a_65426_57680# w_64971_58015# sky130_fd_pr__pfet_01v8 ad=0.165 pd=1.33 as=0.135 ps=1.27 w=1 l=0.15
X18 a_66181_57370# a_66085_57540# a_65135_57360# a_65135_57360# sky130_fd_pr__nfet_01v8_lvt ad=0.0703 pd=1.67 as=0.2109 ps=2.05 w=0.74 l=0.15
X19 a_65678_57074# a_65640_57000# a_65323_57074# a_65135_57360# sky130_fd_pr__nfet_01v8_lvt ad=0.2627 pd=2.19 as=0.1036 ps=1.02 w=0.74 l=0.15
X20 a_65426_57680# a_65393_57318# w_64971_58015# w_64971_58015# sky130_fd_pr__pfet_01v8 ad=0.135 pd=1.27 as=0.1934 ps=1.475 w=1 l=0.15
X21 w_64971_58015# a_65662_58010# a_65602_58036# w_64971_58015# sky130_fd_pr__pfet_01v8 ad=0.0912 pd=1.21 as=0.048 ps=0.62 w=0.32 l=0.15
X22 a_65135_57360# a_65509_57000# a_65603_57432# a_65135_57360# sky130_fd_pr__nfet_01v8_lvt ad=0.1344 pd=1.06 as=0.0768 ps=0.88 w=0.64 l=0.15
X23 a_65603_57432# a_65471_57390# a_65284_57370.t2 a_65135_57360# sky130_fd_pr__nfet_01v8_lvt ad=0.0768 pd=0.88 as=0.1222 ps=1.08 w=0.64 l=0.15
X24 a_66085_57074# a_65471_57390# a_65135_57360# a_65135_57360# sky130_fd_pr__nfet_01v8_lvt ad=0.0888 pd=0.98 as=0.2109 ps=2.05 w=0.74 l=0.15
X25 a_66163_57074# a_66133_57000# a_66085_57074# a_65135_57360# sky130_fd_pr__nfet_01v8_lvt ad=0.1369 pd=1.85 as=0.0888 ps=0.98 w=0.74 l=0.15
X26 w_64971_58015# a_65007_58025# a_65000_58051# w_64971_58015# sky130_fd_pr__pfet_01v8 ad=0.04715 pd=0.63 as=8.575m ps=0.56 w=0.245 l=0.15
X27 w_64971_58015# a_65509_57000# a_65606_57680# w_64971_58015# sky130_fd_pr__pfet_01v8 ad=0.195 pd=1.39 as=0.135 ps=1.27 w=1 l=0.15
C0 a_65640_57000# a_65284_57370# 7.884790000000001e-17
C1 a_65640_57000# a_65606_57680# 2.8342100000000004e-18
C2 a_65662_58010# a_65860_58010# 2.4761900000000002e-18
C3 a_66085_57540# a_65303_58036# 2.7886200000000005e-20
C4 a_65393_57318# a_65678_57074# 3.9933600000000001e-18
C5 m2_65762_57000# a_65890_58036# 1.6090100000000002e-18
C6 a_65284_57370# a_65798_57680# 1.5220100000000001e-17
C7 a_65678_57074# a_65341_57000# 4.1481499999999999e-17
C8 a_66085_57540# a_65795_57432# 1.6275300000000004e-19
C9 a_65227_57396# a_65509_57000# 9.5911500000000015e-17
C10 w_64971_58015# a_65860_58010# 2.7664100000000004e-17
C11 w_64971_58015# a_65662_58010# 2.5985200000000003e-17
C12 w_64971_58015# a_65603_57432# 8.376100000000001e-20
C13 a_66163_57074# a_66085_57540# 6.48293e-19
C14 a_65393_57318# a_65662_58010# 6.2474899999999999e-19
C15 w_64971_58015# li_65000_58047# 3.0158300000000004e-17
C16 a_65323_57074# a_65371_58010# 1.3839500000000001e-20
C17 a_65393_57318# a_65603_57432# 2.2929800000000002e-18
C18 w_64971_58015# a_65471_57390# 3.1898500000000004e-16
C19 a_65423_57416# w_64971_58015# 1.9499500000000001e-19
C20 a_65606_57680# a_65284_57370# 1.53845e-17
C21 a_65602_58036# a_65114_58025# 2.7325000000000004e-20
C22 a_66133_57000# a_65227_57396# 6.8638300000000001e-20
C23 a_65227_57396# m2_65762_57000# 2.2907000000000003e-17
C24 a_66163_57074# a_65678_57074# 2.3058499999999999e-18
C25 a_65393_57318# a_65471_57390# 2.2328400000000002e-16
C26 a_66085_57540# a_65509_57000# 2.1925000000000003e-17
C27 a_65950_58010# a_65860_58010# 6.9333299999999999e-18
C28 a_65423_57416# a_65393_57318# 2.6894400000000002e-18
C29 a_65303_58036# a_65860_58010# 1.6602e-18
C30 w_64971_58015# a_65393_57318# 2.4502600000000004e-16
C31 a_65303_58036# a_65662_58010# 1.6452700000000002e-18
C32 a_65341_57000# li_65000_58047# 9.9668599999999998e-20
C33 a_65341_57000# a_65471_57390# 2.4124199999999999e-16
C34 a_65007_58025# a_65114_58025# 5.4026e-18
C35 a_65000_58051# li_65000_58047# 4.7419700000000007e-19
C36 a_65426_57680# a_65471_57390# 9.7789800000000022e-18
C37 a_65423_57416# a_65341_57000# 1.3151400000000002e-18
C38 a_65640_57000# a_65227_57396# 9.6798000000000005e-17
C39 w_64971_58015# a_65341_57000# 9.76638e-17
C40 a_65426_57680# w_64971_58015# 1.6789700000000002e-17
C41 a_65950_58010# a_65471_57390# 7.45899e-20
C42 a_65303_58036# li_65000_58047# 1.6723100000000002e-19
C43 a_65303_58036# a_65471_57390# 1.7258699999999999e-19
C44 w_64971_58015# a_65950_58010# 3.0538599999999999e-17
C45 a_65114_58025# m2_65762_57000# 1.07704e-20
C46 a_65678_57074# a_65509_57000# 6.2277500000000017e-17
C47 w_64971_58015# a_65303_58036# 4.9704300000000004e-16
C48 a_65662_58010# a_65572_58010# 6.9333299999999999e-18
C49 a_65227_57396# a_65798_57680# 2.2455400000000001e-19
C50 a_65393_57318# a_65341_57000# 2.9164500000000003e-16
C51 a_65426_57680# a_65393_57318# 2.7964100000000001e-18
C52 a_66133_57000# a_66085_57540# 3.9973600000000003e-18
C53 a_66085_57540# m2_65762_57000# 3.6721800000000001e-18
C54 m2_65762_57000# a_66181_57370# 1.6968400000000001e-19
C55 a_65393_57318# a_65950_58010# 2.4525700000000004e-20
C56 a_65393_57318# a_65303_58036# 5.9027999999999999e-18
C57 a_65426_57680# a_65341_57000# 2.1755000000000001e-18
C58 w_64971_58015# a_65795_57432# 5.8910300000000008e-19
C59 a_65572_58010# a_65471_57390# 4.1833299999999999e-18
C60 a_65284_57370# a_65371_58010# 2.6437100000000003e-20
C61 a_66163_57074# a_65471_57390# 4.2332000000000006e-17
C62 w_64971_58015# a_65572_58010# 2.5332600000000003e-17
C63 a_65640_57000# a_66085_57540# 1.0939100000000001e-16
C64 a_65303_58036# a_65341_57000# 1.9277200000000004e-17
C65 a_66163_57074# w_64971_58015# 5.0104699999999997e-18
C66 a_65640_57000# a_66181_57370# 2.2027500000000001e-18
C67 a_65323_57074# a_65678_57074# 1.35861e-16
C68 a_65602_58036# a_65662_58010# 2.5371500000000004e-18
C69 m2_65762_57000# a_65678_57074# 5.5011300000000007e-18
C70 a_65393_57318# a_65795_57432# 5.5129600000000001e-18
C71 a_65227_57396# a_65284_57370# 1.8875200000000002e-16
C72 a_65860_58010# a_65509_57000# 3.7447400000000003e-18
C73 a_65662_58010# a_65509_57000# 4.4004500000000003e-18
C74 a_65950_58010# a_65303_58036# 1.6059000000000003e-18
C75 a_65603_57432# a_65509_57000# 1.02074e-18
C76 a_65393_57318# a_65572_58010# 7.9005300000000006e-19
C77 a_66163_57074# a_65393_57318# 1.25932e-17
C78 a_65602_58036# a_65471_57390# 6.7005300000000012e-20
C79 a_65640_57000# a_65678_57074# 9.0398200000000003e-17
C80 a_65471_57390# a_65509_57000# 1.5009000000000001e-16
C81 a_65602_58036# w_64971_58015# 7.7271700000000011e-17
C82 w_64971_58015# a_65509_57000# 1.5770600000000001e-16
C83 a_65303_58036# a_65572_58010# 1.7219000000000001e-18
C84 m2_65762_57000# a_65860_58010# 7.9005300000000006e-19
C85 m2_65762_57000# a_65662_58010# 7.6429000000000011e-19
C86 a_65007_58025# li_65000_58047# 3.2339699999999999e-18
C87 a_65602_58036# a_65393_57318# 1.6514800000000002e-18
C88 a_66085_57540# a_65284_57370# 5.9352200000000001e-18
C89 a_65393_57318# a_65509_57000# 2.7393100000000001e-16
C90 a_65284_57370# a_66181_57370# 8.6133900000000014e-20
C91 a_65007_58025# w_64971_58015# 2.1275200000000002e-17
C92 a_65323_57074# a_65471_57390# 6.2222299999999996e-17
C93 a_65341_57000# a_65509_57000# 1.3032700000000001e-16
C94 a_66133_57000# a_65471_57390# 3.8272200000000002e-17
C95 m2_65762_57000# a_65471_57390# 6.6543200000000008e-17
C96 a_65640_57000# a_65662_58010# 5.0895800000000004e-19
C97 a_65323_57074# w_64971_58015# 8.5838200000000002e-19
C98 a_65640_57000# a_65603_57432# 6.9248800000000005e-19
C99 a_65114_58025# a_65890_58036# 1.1013600000000002e-20
C100 a_66133_57000# w_64971_58015# 2.6501600000000002e-18
C101 w_64971_58015# m2_65762_57000# 1.7386000000000003e-16
C102 a_65602_58036# a_65303_58036# 7.6517600000000006e-18
C103 a_65227_57396# a_65371_58010# 8.6713399999999997e-21
C104 a_65303_58036# a_65509_57000# 2.3919500000000004e-20
C105 a_65323_57074# a_65393_57318# 2.7082400000000001e-18
C106 a_65007_58025# a_65341_57000# 2.3509500000000004e-19
C107 a_65114_58025# a_65144_58051# 2.1797200000000003e-18
C108 a_65640_57000# a_65471_57390# 6.4273899999999995e-17
C109 a_66133_57000# a_65393_57318# 4.3689500000000002e-18
C110 a_65393_57318# m2_65762_57000# 1.2946700000000003e-16
C111 a_65640_57000# w_64971_58015# 3.4073300000000002e-16
C112 a_65323_57074# a_65341_57000# 6.1638599999999995e-17
C113 a_65795_57432# a_65509_57000# 4.9296499999999994e-19
C114 a_65007_58025# a_65303_58036# 2.0467400000000001e-19
C115 a_65602_58036# a_65572_58010# 3.1566900000000006e-18
C116 a_65572_58010# a_65509_57000# 3.9871600000000003e-19
C117 w_64971_58015# a_65798_57680# 1.4889200000000002e-17
C118 a_65640_57000# a_65393_57318# 6.1903599999999998e-17
C119 a_65114_58025# a_65371_58010# 7.7533000000000002e-19
C120 a_65323_57074# a_65303_58036# 1.3551400000000001e-20
C121 a_65950_58010# m2_65762_57000# 6.2474899999999999e-19
C122 a_65303_58036# m2_65762_57000# 6.3323700000000011e-18
C123 a_65284_57370# a_65860_58010# 2.4787700000000001e-19
C124 a_66085_57074# a_65678_57074# 5.4999900000000004e-20
C125 a_65284_57370# a_65662_58010# 5.4890599999999998e-21
C126 a_65603_57432# a_65284_57370# 9.4184300000000014e-18
C127 a_65640_57000# a_65341_57000# 2.3518200000000003e-19
C128 a_65640_57000# a_65426_57680# 9.0593100000000001e-19
C129 m1_66189_57000# a_65471_57390# 6.8735200000000007e-18
C130 m1_66189_57000# w_64971_58015# 1.5660600000000001e-19
C131 a_65227_57396# a_66085_57540# 5.3351999999999998e-17
C132 a_65640_57000# a_65950_58010# 8.1219899999999993e-20
C133 a_65795_57432# m2_65762_57000# 8.1544100000000002e-19
C134 a_65640_57000# a_65303_58036# 2.9648299999999999e-20
C135 a_65227_57396# a_66181_57370# 1.2422800000000003e-18
C136 a_65284_57370# a_65471_57390# 2.1461800000000001e-16
C137 a_65602_58036# a_65509_57000# 1.2115e-19
C138 m2_65762_57000# a_65572_58010# 6.4311500000000006e-19
C139 a_65423_57416# a_65284_57370# 8.7512000000000016e-18
C140 w_64971_58015# a_65284_57370# 3.8296000000000001e-16
C141 a_66163_57074# a_66133_57000# 6.1671200000000005e-17
C142 a_66163_57074# m2_65762_57000# 9.9417800000000005e-20
C143 a_65606_57680# w_64971_58015# 1.2966900000000001e-17
C144 m1_66189_57000# a_65393_57318# 9.4120099999999994e-19
C145 a_65860_58010# a_65890_58036# 3.1566900000000006e-18
C146 a_65640_57000# a_65795_57432# 2.2391100000000004e-19
C147 a_65393_57318# a_65284_57370# 2.0105600000000004e-16
C148 a_65606_57680# a_65393_57318# 2.0324900000000004e-18
C149 a_65341_57000# a_65284_57370# 1.0703900000000002e-17
C150 w_64971_58015# a_65890_58036# 8.1292900000000006e-17
C151 a_65602_58036# m2_65762_57000# 1.5713500000000001e-18
C152 a_65426_57680# a_65284_57370# 7.4942300000000005e-18
C153 a_65323_57074# a_65509_57000# 1.8250000000000001e-17
C154 a_66085_57074# a_65471_57390# 1.8831199999999999e-18
C155 m2_65762_57000# a_65509_57000# 1.51276e-17
C156 a_65144_58051# a_65471_57390# 2.3518800000000004e-19
C157 a_66085_57074# w_64971_58015# 2.0039000000000002e-18
C158 a_65303_58036# a_65284_57370# 2.5997300000000005e-18
C159 w_64971_58015# a_65144_58051# 3.6487600000000003e-17
C160 a_65640_57000# a_65602_58036# 9.4943700000000014e-20
C161 a_66085_57074# a_65393_57318# 2.9103699999999999e-18
C162 a_65640_57000# a_65509_57000# 4.1094900000000003e-16
C163 a_65227_57396# a_65603_57432# 1.7056700000000001e-18
C164 a_66163_57074# m1_66189_57000# 2.4043700000000005e-18
C165 a_65795_57432# a_65284_57370# 8.9289200000000013e-18
C166 a_65371_58010# a_65471_57390# 3.7482900000000001e-20
C167 a_65284_57370# a_65572_58010# 1.2278200000000001e-19
C168 w_64971_58015# a_65371_58010# 3.1879699999999998e-17
C169 a_65950_58010# a_65890_58036# 2.5371500000000004e-18
C170 a_65798_57680# a_65509_57000# 2.4333900000000002e-19
C171 a_65144_58051# a_65341_57000# 5.1695400000000004e-19
C172 a_65303_58036# a_65890_58036# 7.557760000000001e-18
C173 a_65227_57396# a_65471_57390# 1.69921e-16
C174 a_65423_57416# a_65227_57396# 2.8543500000000005e-18
C175 a_65227_57396# w_64971_58015# 2.3739100000000002e-16
C176 a_65393_57318# a_65371_58010# 9.6666900000000014e-19
C177 a_65303_58036# a_65144_58051# 2.3493500000000002e-17
C178 a_65323_57074# a_65640_57000# 8.8842800000000003e-18
C179 a_66133_57000# a_65640_57000# 1.2287099999999999e-19
C180 a_65640_57000# m2_65762_57000# 3.3447300000000004e-16
C181 a_65227_57396# a_65393_57318# 3.1102700000000004e-16
C182 a_65341_57000# a_65371_58010# 1.8290400000000002e-18
C183 a_66085_57540# a_65603_57432# 4.8900500000000001e-20
C184 a_65284_57370# a_65509_57000# 3.3845000000000001e-16
C185 m2_65762_57000# a_65798_57680# 1.93852e-18
C186 a_65606_57680# a_65509_57000# 2.7291600000000004e-18
C187 a_65227_57396# a_65341_57000# 3.5616900000000003e-17
C188 a_66163_57074# a_66085_57074# 9.5891499999999995e-18
C189 a_65303_58036# a_65371_58010# 5.0178300000000004e-18
C190 a_65227_57396# a_65426_57680# 1.4596999999999999e-19
C191 a_65114_58025# w_64971_58015# 2.8601400000000006e-17
C192 a_66085_57540# a_65471_57390# 3.8532600000000004e-18
C193 a_65227_57396# a_65950_58010# 3.4138000000000004e-20
C194 a_66181_57370# a_65471_57390# 2.42422e-19
C195 a_66085_57540# w_64971_58015# 1.2244100000000002e-16
C196 a_65227_57396# a_65303_58036# 1.8695100000000001e-18
C197 w_64971_58015# a_66181_57370# 7.6170000000000006e-19
C198 a_65640_57000# a_65798_57680# 5.0784800000000001e-18
C199 a_66133_57000# m1_66189_57000# 3.0396e-18
C200 a_65114_58025# a_65393_57318# 2.1394200000000001e-20
C201 a_65509_57000# a_65890_58036# 7.150579999999999e-20
C202 a_65572_58010# a_65371_58010# 2.43275e-18
C203 a_65323_57074# a_65284_57370# 2.0853500000000002e-19
C204 a_66085_57540# a_65393_57318# 6.6713500000000011e-18
C205 a_65227_57396# a_65795_57432# 1.9381700000000002e-18
C206 m2_65762_57000# a_65284_57370# 1.8190400000000001e-17
C207 a_65114_58025# a_65341_57000# 3.56527e-19
C208 a_65393_57318# a_66181_57370# 1.28619e-18
C209 a_65606_57680# m2_65762_57000# 1.42315e-18
C210 a_65678_57074# a_65471_57390# 4.6397200000000005e-17
C211 w_64971_58015# a_65678_57074# 2.63995e-18
C212 a_66085_57540# a_65341_57000# 3.7339900000000009e-20
C213 a_65114_58025# a_65303_58036# 1.4515000000000001e-18
R0 a_65284_57370.n5 a_65284_57370.n0 98.8784
R1 a_65284_57370.t1 a_65284_57370.n0 26.2505
R2 a_65284_57370.n0 a_65284_57370.t2 43.7951
R3 a_65284_57370.n5 a_65284_57370.n3 12.8005
R4 a_65284_57370.n4 a_65284_57370.n5 223.374
R5 a_65284_57370.t7 a_65284_57370.n4 177.981
R6 a_65284_57370# a_65284_57370.t7 160.667
R7 a_65284_57370.n4 a_65284_57370.t6 250.548
R8 a_65284_57370.n3 a_65284_57370.n2 51.9534
R9 a_65284_57370.n2 a_65284_57370.t4 340.596
R10 a_65284_57370.n2 a_65284_57370.n1 210.905
R11 a_65284_57370.n1 a_65284_57370.t3 35.4605
R12 a_65284_57370.n1 a_65284_57370.t0 29.5505
R13 a_65284_57370.n3 a_65284_57370.t5 322.863
C214 m5_65000_57184# a_65135_57360# 0 $ **FLOATING
C215 m4_65564_57016# a_65135_57360# 0 $ **FLOATING
C216 m4_65388_57016# a_65135_57360# 0 $ **FLOATING
C217 m4_65212_57016# a_65135_57360# 0 $ **FLOATING
C218 m4_65036_57016# a_65135_57360# 0 $ **FLOATING
C219 m4_65528_57192# a_65135_57360# 0 $ **FLOATING
C220 m4_65352_57192# a_65135_57360# 0 $ **FLOATING
C221 m4_65176_57192# a_65135_57360# 0 $ **FLOATING
C222 m4_65000_57192# a_65135_57360# 0 $ **FLOATING
C223 m4_65492_57368# a_65135_57360# 0 $ **FLOATING
C224 m4_65316_57368# a_65135_57360# 0 $ **FLOATING
C225 m4_65140_57368# a_65135_57360# 0 $ **FLOATING
C226 m4_65000_57368# a_65135_57360# 0 $ **FLOATING
C227 m4_65456_57544# a_65135_57360# 0 $ **FLOATING
C228 m4_65280_57544# a_65135_57360# 0 $ **FLOATING
C229 m4_65104_57544# a_65135_57360# 0 $ **FLOATING
C230 m4_65000_57544# a_65135_57360# 0 $ **FLOATING
C231 m4_65596_57720# a_65135_57360# 0 $ **FLOATING
C232 m4_65420_57720# a_65135_57360# 0 $ **FLOATING
C233 m4_65244_57720# a_65135_57360# 0 $ **FLOATING
C234 m4_65068_57720# a_65135_57360# 0 $ **FLOATING
C235 m4_65000_57720# a_65135_57360# 0 $ **FLOATING
C236 m4_65560_57896# a_65135_57360# 0 $ **FLOATING
C237 m4_65384_57896# a_65135_57360# 0 $ **FLOATING
C238 m4_65208_57896# a_65135_57360# 0 $ **FLOATING
C239 m4_65032_57896# a_65135_57360# 0 $ **FLOATING
C240 m4_65524_58072# a_65135_57360# 0 $ **FLOATING
C241 m4_65348_58072# a_65135_57360# 0 $ **FLOATING
C242 m4_65172_58072# a_65135_57360# 0 $ **FLOATING
C243 m4_65000_58072# a_65135_57360# 0 $ **FLOATING
C244 m3_65634_57122# a_65135_57360# 0 $ **FLOATING
C245 m3_65458_57122# a_65135_57360# 0 $ **FLOATING
C246 m3_65282_57122# a_65135_57360# 0 $ **FLOATING
C247 m3_65106_57122# a_65135_57360# 0 $ **FLOATING
C248 m3_65000_57122# a_65135_57360# 0 $ **FLOATING
C249 m3_66126_57298# a_65135_57360# 0 $ **FLOATING
C250 m3_65950_57298# a_65135_57360# 0 $ **FLOATING
C251 m3_65774_57298# a_65135_57360# 0 $ **FLOATING
C252 m3_65598_57298# a_65135_57360# 0 $ **FLOATING
C253 m3_65422_57298# a_65135_57360# 0 $ **FLOATING
C254 m3_65246_57298# a_65135_57360# 0 $ **FLOATING
C255 m3_65070_57298# a_65135_57360# 0 $ **FLOATING
C256 m3_65000_57298# a_65135_57360# 0 $ **FLOATING
C257 m3_66090_57474# a_65135_57360# 0 $ **FLOATING
C258 m3_65914_57474# a_65135_57360# 0 $ **FLOATING
C259 m3_65738_57474# a_65135_57360# 0 $ **FLOATING
C260 m3_65562_57474# a_65135_57360# 0 $ **FLOATING
C261 m3_65386_57474# a_65135_57360# 0 $ **FLOATING
C262 m3_65210_57474# a_65135_57360# 0 $ **FLOATING
C263 m3_65034_57474# a_65135_57360# 0 $ **FLOATING
C264 m3_66054_57650# a_65135_57360# 0 $ **FLOATING
C265 m3_65878_57650# a_65135_57360# 0 $ **FLOATING
C266 m3_65702_57650# a_65135_57360# 0 $ **FLOATING
C267 m3_65526_57650# a_65135_57360# 0 $ **FLOATING
C268 m3_65350_57650# a_65135_57360# 0 $ **FLOATING
C269 m3_65174_57650# a_65135_57360# 0 $ **FLOATING
C270 m3_65000_57650# a_65135_57360# 0 $ **FLOATING
C271 m3_65490_57826# a_65135_57360# 0 $ **FLOATING
C272 m3_65314_57826# a_65135_57360# 0 $ **FLOATING
C273 m3_65138_57826# a_65135_57360# 0 $ **FLOATING
C274 m3_65000_57826# a_65135_57360# 0 $ **FLOATING
C275 m3_65454_58002# a_65135_57360# 0 $ **FLOATING
C276 m3_65278_58002# a_65135_57360# 0 $ **FLOATING
C277 m3_65102_58002# a_65135_57360# 0 $ **FLOATING
C278 m3_65000_58002# a_65135_57360# 0 $ **FLOATING
C279 m2_66192_57344# a_65135_57360# 0 $ **FLOATING
C280 m2_65920_57240# a_65135_57360# 0 $ **FLOATING
C281 m2_65860_57440# a_65135_57360# 0 $ **FLOATING
C282 m2_66080_57540# a_65135_57360# 0 $ **FLOATING
C283 m2_65980_57540# a_65135_57360# 0 $ **FLOATING
C284 m2_65880_57540# a_65135_57360# 0 $ **FLOATING
C285 m2_66004_57656# a_65135_57360# 0 $ **FLOATING
C286 m2_65900_57640# a_65135_57360# 0 $ **FLOATING
C287 m2_65762_57000# a_65135_57360# 1.6110700000000002e-16
C288 m2_65640_57840# a_65135_57360# 0 $ **FLOATING
C289 m2_65580_58040# a_65135_57360# 0 $ **FLOATING
C290 m2_65000_57140# a_65135_57360# 0 $ **FLOATING
C291 m2_65020_57240# a_65135_57360# 0 $ **FLOATING
C292 m2_65040_57340# a_65135_57360# 0 $ **FLOATING
C293 m2_65060_57440# a_65135_57360# 0 $ **FLOATING
C294 m2_65000_57640# a_65135_57360# 0 $ **FLOATING
C295 m2_65220_57740# a_65135_57360# 0 $ **FLOATING
C296 m2_65240_57840# a_65135_57360# 0 $ **FLOATING
C297 m2_65052_57812# a_65135_57360# 0 $ **FLOATING
C298 m2_65036_57968# a_65135_57360# 0 $ **FLOATING
C299 m1_66189_57000# a_65135_57360# 8.801600000000001e-18
C300 m1_65050_57430# a_65135_57360# 0 $ **FLOATING
C301 m1_65000_57430# a_65135_57360# 0 $ **FLOATING
C302 m1_65000_57530# a_65135_57360# 0 $ **FLOATING
C303 m1_65000_57630# a_65135_57360# 0 $ **FLOATING
C304 m1_65510_57730# a_65135_57360# 0 $ **FLOATING
C305 m1_65410_57730# a_65135_57360# 0 $ **FLOATING
C306 m1_65310_57730# a_65135_57360# 0 $ **FLOATING
C307 m1_65210_57730# a_65135_57360# 0 $ **FLOATING
C308 m1_65110_57730# a_65135_57360# 0 $ **FLOATING
C309 m1_65010_57730# a_65135_57360# 0 $ **FLOATING
C310 li_65000_57610# a_65135_57360# 0 $ **FLOATING
C311 li_65000_58047# a_65135_57360# 1.3219700000000001e-17
C312 a_66163_57074# a_65135_57360# 1.23758e-16 $ **FLOATING
C313 a_66085_57074# a_65135_57360# 8.9298699999999998e-18 $ **FLOATING
C314 a_65678_57074# a_65135_57360# 1.1318800000000001e-16 $ **FLOATING
C315 a_66133_57000# a_65135_57360# 1.12804e-16 $ **FLOATING
C316 a_65323_57074# a_65135_57360# 2.1271300000000001e-16 $ **FLOATING
C317 a_65341_57000# a_65135_57360# 3.8175700000000006e-16 $ **FLOATING
C318 a_66181_57370# a_65135_57360# 4.1553300000000005e-18 $ **FLOATING
C319 a_65795_57432# a_65135_57360# 2.0767899999999999e-18 $ **FLOATING
C320 a_65603_57432# a_65135_57360# 3.3862100000000003e-18 $ **FLOATING
C321 a_65423_57416# a_65135_57360# 5.4932000000000009e-18 $ **FLOATING
C322 a_65640_57000# a_65135_57360# 3.3092400000000003e-16 $ **FLOATING
C323 a_65798_57680# a_65135_57360# 0 $ **FLOATING
C324 a_65606_57680# a_65135_57360# 0 $ **FLOATING
C325 a_65426_57680# a_65135_57360# 0 $ **FLOATING
C326 a_66085_57540# a_65135_57360# 2.1942900000000003e-16 $ **FLOATING
C327 a_65509_57000# a_65135_57360# 3.3313e-16 $ **FLOATING
C328 a_65471_57390# a_65135_57360# 1.1461e-15 $ **FLOATING
C329 a_65393_57318# a_65135_57360# 1.1571500000000003e-15 $ **FLOATING
C330 a_65227_57396# a_65135_57360# 3.0900000000000004e-16 $ **FLOATING
C331 a_65284_57370# a_65135_57360# 3.2597060382919765e-18 $ **FLOATING
C332 a_65950_58010# a_65135_57360# 3.1852600000000002e-18 $ **FLOATING
C333 a_65890_58036# a_65135_57360# 1.0435600000000002e-17 $ **FLOATING
C334 a_65860_58010# a_65135_57360# 0 $ **FLOATING
C335 a_65662_58010# a_65135_57360# 0 $ **FLOATING
C336 a_65602_58036# a_65135_57360# 1.0435600000000002e-17 $ **FLOATING
C337 a_65572_58010# a_65135_57360# 0 $ **FLOATING
C338 a_65371_58010# a_65135_57360# 1.2316500000000001e-18 $ **FLOATING
C339 a_65303_58036# a_65135_57360# 2.3712400000000001e-16 $ **FLOATING
C340 a_65144_58051# a_65135_57360# 6.52454e-18 $ **FLOATING
C341 a_65114_58025# a_65135_57360# 1.6069500000000001e-18 $ **FLOATING
C342 a_65007_58025# a_65135_57360# 6.8012700000000002e-18 $ **FLOATING
C343 a_65000_58051# a_65135_57360# 0 $ **FLOATING
C344 w_64971_58015# a_65135_57360# 2.6712600000000003e-15 $ **FLOATING
C345 a_65135_57360# a_65135_57360# 0 $ **FLOATING
C346 a_65284_57370.t1 a_65135_57360# 3.8942776715342566e-18 $ **FLOATING
C347 a_65284_57370.n0 a_65135_57360# 1.1923789327179825e-17 $ **FLOATING
C348 a_65284_57370.t5 a_65135_57360# 2.1524593899928563e-17 $ **FLOATING
C349 a_65284_57370.n1 a_65135_57360# 1.648735469729148e-17 $ **FLOATING
C350 a_65284_57370.t3 a_65135_57360# 7.8233258326905879e-18 $ **FLOATING
C351 a_65284_57370.t0 a_65135_57360# 6.5194379554902384e-18 $ **FLOATING
C352 a_65284_57370.t4 a_65135_57360# 3.7099736202226534e-17 $ **FLOATING
C353 a_65284_57370.n2 a_65135_57360# 7.1034143344571457e-17 $ **FLOATING
C354 a_65284_57370.n3 a_65135_57360# 3.2482430329346235e-17 $ **FLOATING
C355 a_65284_57370.t6 a_65135_57360# 1.4318981534311451e-17 $ **FLOATING
C356 a_65284_57370.t7 a_65135_57360# 7.1267682931801461e-18 $ **FLOATING
C357 a_65284_57370.n4 a_65135_57360# 2.1731609896397055e-17 $ **FLOATING
C358 a_65284_57370.n5 a_65135_57360# 3.8608719852610525e-17 $ **FLOATING
C359 a_65284_57370.t2 a_65135_57360# 6.5721251249496663e-18 $ **FLOATING
.ends
