* NGSPICE file created from OpenPLL_Coupling_R_Probe.ext - technology: sky130A

.subckt OpenPLL_Coupling_R_Probe A B AFAR C CFAR
C0 AFAR B 3.9111100000000006e-15
C1 B CFAR 8.5853700000000009e-16
R0 A AFAR 4.9755
R1 A AFAR 4.9755
R2 C CFAR 4.9755
R3 C CFAR 4.9755
C2 AFAR SUB 1.4277531863403307e-15
C3 A SUB 1.4135468136596698e-15
C4 B SUB 1.9913500000000003e-15
C5 CFAR SUB 1.76277001953125e-15
C6 C SUB 1.7452299804687502e-15
C7 dummy SUB 0 $ **FLOATING
C8 SUB SUB 0
.ends
