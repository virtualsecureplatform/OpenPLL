* NGSPICE file created from OpenPLL_Coupling_R_Probe.ext - technology: sky130A

.subckt OpenPLL_Coupling_R_Probe A B AFAR C CFAR
R0 CFAR C 0.000000
R1 A AFAR 4.9755
C0 AFAR SUB 2.1898648046874998e-15
C1 A SUB 2.1680751953125001e-15
C2 B SUB 4.35794e-15
C3 CFAR SUB 4.35794e-15
C4 C SUB 0
C5 dummy SUB 0 $ **FLOATING
C6 SUB SUB 0
.ends
