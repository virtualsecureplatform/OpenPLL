* NGSPICE file created from FringeContactProbe.ext - technology: sky130A

C0 TARGET SOURCE 0.28319f
C1 TARGET SHIELD 0.57103f
C2 SHIELD SOURCE 0.10347f
C3 SOURCE SUB 0.95428f
C4 SHIELD SUB 0.16458f
C5 TARGET SUB 1.39327f
C6 SUB SUB 0
