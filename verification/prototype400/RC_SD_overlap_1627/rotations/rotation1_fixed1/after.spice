* NGSPICE file created from RotatedCrop.ext - technology: sky130A

.subckt RotatedCrop
X0 a_n57888_66178.t0 a_n57914_66148# w_n58136_64971.t20 w_n58136_64971.t19 sky130_fd_pr__pfet_01v8 ad=0.1232 pd=2.46 as=0.3192 ps=2.81 w=1.12 l=0.15
X1 w_n58136_64971.t14 a_n58100_65371# a_n58100_65303.t0 w_n58136_64971.t13 sky130_fd_pr__pfet_01v8 ad=0.096 pd=1.24 as=0.1088 ps=1.32 w=0.32 l=0.15
X2 a_n57560_65795# a_n57906_65396# a_n57560_65681.t9 a_n57560_65681.t8 sky130_fd_pr__nfet_01v8_lvt ad=0.0864 pd=0.91 as=0.1344 ps=1.06 w=0.64 l=0.15
X3 a_n57222_65323.t0 a_n57906_65660# a_n57560_65681.t12 a_n57560_65681.t11 sky130_fd_pr__nfet_01v8_lvt ad=0.1036 pd=1.02 as=0.3361 ps=1.68 w=0.74 l=0.15
X4 w_n58136_64971.t16 a_n58100_65007# a_n58100_65000.t0 w_n58136_64971.t15 sky130_fd_pr__pfet_01v8 ad=0.04715 pd=0.63 as=8.575m ps=0.56 w=0.245 l=0.15
X5 a_n57914_65295.t4 a_n57906_65660# a_n57880_65798.t0 w_n58136_64971.t8 sky130_fd_pr__pfet_01v8 ad=0.295 pd=2.59 as=0.135 ps=1.27 w=1 l=0.15
X6 w_n58136_64971.t22 a_n57914_65295.t7 a_n57888_65236.t1 w_n58136_64971.t21 sky130_fd_pr__pfet_01v8 ad=0.1934 pd=1.475 as=0.3304 ps=2.83 w=1.12 l=0.15
X7 a_n57880_65798# a_n57906_65396# w_n58136_64971.t5 w_n58136_64971.t4 sky130_fd_pr__pfet_01v8 ad=0.135 pd=1.27 as=0.195 ps=1.39 w=1 l=0.15
X8 a_n57560_65681# a_n57906_65660# a_n57560_65603.t0 a_n57560_65681.t13 sky130_fd_pr__nfet_01v8_lvt ad=0.1344 pd=1.06 as=0.0768 ps=0.88 w=0.64 l=0.15
X9 a_n57914_65295.t1 a_n57906_65480# a_n57544_65423.t0 a_n57560_65681.t4 sky130_fd_pr__nfet_01v8_lvt ad=0.1222 pd=1.08 as=0.0768 ps=0.88 w=0.64 l=0.15
X10 a_n57560_65681.t15 a_n57248_65380# a_n57222_65323.t1 a_n57560_65681.t14 sky130_fd_pr__nfet_01v8_lvt ad=0.3361 pd=1.68 as=0.2109 ps=2.05 w=0.74 l=0.15
X11 a_n57518_66181.t0 a_n57914_66148# a_n57560_65681.t17 a_n57560_65681.t16 sky130_fd_pr__nfet_01v8_lvt ad=0.0703 pd=1.67 as=0.2109 ps=2.05 w=0.74 l=0.15
X12 w_n58136_64971.t26 a_n58100_65950# a_n58100_65890.t0 w_n58136_64971.t25 sky130_fd_pr__pfet_01v8 ad=0.0912 pd=1.21 as=0.048 ps=0.62 w=0.32 l=0.15
X13 a_n58100_65890# a_n58100_65860# w_n58136_64971.t24 w_n58136_64971.t23 sky130_fd_pr__pfet_01v8 ad=0.048 pd=0.62 as=0.0912 ps=1.21 w=0.32 l=0.15
X14 a_n57222_65678.t0 a_n57888_66178.t1 a_n57222_65323.t2 a_n57560_65681.t0 sky130_fd_pr__nfet_01v8_lvt ad=0.2627 pd=2.19 as=0.1036 ps=1.02 w=0.74 l=0.15
X15 a_n58100_65144.t0 a_n58100_65114# w_n58136_64971.t18 w_n58136_64971.t17 sky130_fd_pr__pfet_01v8 ad=0.07227 pd=1.08 as=0.04715 ps=0.63 w=0.245 l=0.15
X16 a_n57222_66163.t0 a_n57248_66133# a_n57222_66085.t0 a_n57560_65681.t5 sky130_fd_pr__nfet_01v8_lvt ad=0.1369 pd=1.85 as=0.0888 ps=0.98 w=0.74 l=0.15
X17 a_n57560_65603# a_n57906_65480# a_n57914_65295.t3 a_n57560_65681.t3 sky130_fd_pr__nfet_01v8_lvt ad=0.0768 pd=0.88 as=0.1222 ps=1.08 w=0.64 l=0.15
X18 a_n57560_65681.t19 a_n57914_65295.t6 a_n57888_65236.t0 a_n57560_65681.t18 sky130_fd_pr__nfet_01v8_lvt ad=0.1389 pd=1.135 as=0.2081 ps=2.05 w=0.74 l=0.15
X19 a_n57914_65295.t5 a_n57906_65660# a_n57560_65795.t0 a_n57560_65681.t10 sky130_fd_pr__nfet_01v8_lvt ad=0.1733 pd=1.85 as=0.0864 ps=0.91 w=0.64 l=0.15
X20 w_n58136_64971.t1 a_n58100_65662# a_n58100_65602.t0 w_n58136_64971.t0 sky130_fd_pr__pfet_01v8 ad=0.0912 pd=1.21 as=0.048 ps=0.62 w=0.32 l=0.15
X21 a_n58100_65602# a_n58100_65572# w_n58136_64971.t12 w_n58136_64971.t11 sky130_fd_pr__pfet_01v8 ad=0.048 pd=0.62 as=0.0912 ps=1.21 w=0.32 l=0.15
X22 a_n57544_65423# a_n57906_65396# a_n57560_65681.t7 a_n57560_65681.t6 sky130_fd_pr__nfet_01v8_lvt ad=0.0768 pd=0.88 as=0.1389 ps=1.135 w=0.64 l=0.15
X23 w_n58136_64971.t10 a_n57906_65660# a_n57880_65606.t0 w_n58136_64971.t9 sky130_fd_pr__pfet_01v8 ad=0.195 pd=1.39 as=0.135 ps=1.27 w=1 l=0.15
X24 a_n57914_65295.t2 a_n57906_65480# a_n57880_65426.t0 w_n58136_64971.t3 sky130_fd_pr__pfet_01v8 ad=0.165 pd=1.33 as=0.135 ps=1.27 w=1 l=0.15
X25 a_n57880_65606# a_n57906_65480# a_n57914_65295.t0 w_n58136_64971.t2 sky130_fd_pr__pfet_01v8 ad=0.135 pd=1.27 as=0.165 ps=1.33 w=1 l=0.15
X26 a_n57880_65426# a_n57906_65396# w_n58136_64971.t7 w_n58136_64971.t6 sky130_fd_pr__pfet_01v8 ad=0.135 pd=1.27 as=0.1934 ps=1.475 w=1 l=0.15
X27 a_n57222_66085# a_n57906_65480# a_n57560_65681.t2 a_n57560_65681.t1 sky130_fd_pr__nfet_01v8_lvt ad=0.0888 pd=0.98 as=0.2109 ps=2.05 w=0.74 l=0.15
C0 a_n57914_65295# a_n57906_65480# 0.21462f
C1 a_n58100_65371# a_n57248_65380# 0.00175f
C2 a_n57906_65396# a_n58100_65602# 0.00165f
C3 a_n57222_65323# a_n57906_65480# 0.06222f
C4 w_n58136_64971# a_n58100_65303# 0.49704f
C5 a_n58100_65662# a_n58100_65602# 0.00254f
C6 a_n57914_65295# a_n57888_65236# 0.18875f
C7 a_n57906_65660# a_n57560_65795# 0
C8 w_n58136_64971# a_n57880_65606# 0.01297f
C9 a_n57906_65480# a_n58100_65950# 0
C10 a_n57888_66178# a_n57906_65480# 0.06427f
C11 w_n58136_64971# a_n57560_65603# 0
C12 a_n58100_65007# a_n58100_65114# 0.0054f
C13 a_n57906_65660# a_n57248_65380# 0.13033f
C14 a_n58100_65371# a_n57914_65295# 0
C15 m2_n58100_65762# a_n57518_66181# 0
C16 a_n57906_65480# a_n58100_65144# 0
C17 a_n57888_65236# a_n58100_65950# 0
C18 a_n57888_66178# a_n57888_65236# 0.0968f
C19 a_n57222_66085# a_n57906_65480# 0.00188f
C20 a_n58100_65371# a_n57222_65323# 0
C21 a_n57560_65795# a_n57914_66148# 0
C22 a_n57222_66085# a_n57222_66163# 0.00959f
C23 a_n57906_65396# m2_n58100_65762# 0.12987f
C24 li_n58100_65000# a_n58100_65303# 0
C25 a_n58100_65114# a_n57248_65380# 0
C26 a_n58100_65572# a_n58100_65303# 0.00172f
C27 a_n57906_65660# a_n57222_65678# 0.06228f
C28 a_n57248_65380# a_n57914_66148# 0
C29 a_n57906_65396# a_n57518_66181# 0.00129f
C30 m2_n58100_65762# a_n58100_65662# 0
C31 a_n57906_65660# a_n57914_65295# 0.33845f
C32 a_n58100_65007# a_n58100_65303# 0
C33 a_n58100_65602# a_n57906_65480# 0
C34 w_n58136_64971# li_n58100_65000# 0.03016f
C35 m2_n58100_65762# a_n57880_65798# 0.00194f
C36 a_n57906_65396# a_n58100_65662# 0
C37 a_n57906_65396# a_n57544_65423# 0.00269f
C38 w_n58136_64971# a_n58100_65572# 0.02533f
C39 a_n57880_65426# w_n58136_64971# 0.01679f
C40 a_n57906_65660# a_n57222_65323# 0.01825f
C41 a_n58100_65303# a_n57248_65380# 0.01928f
C42 a_n57914_65295# a_n57914_66148# 0.00594f
C43 w_n58136_64971# a_n58100_65007# 0.02128f
C44 a_n57906_65660# a_n57888_66178# 0.41095f
C45 a_n57888_66178# a_n57248_66133# 0
C46 a_n58100_65890# a_n58100_65950# 0.00254f
C47 w_n58136_64971# a_n57560_65795# 0
C48 a_n57906_65660# a_n58100_65860# 0.00374f
C49 a_n58100_65860# a_n58100_65890# 0.00316f
C50 m2_n58100_65762# a_n57906_65480# 0.06654f
C51 m2_n58100_65762# a_n57222_66163# 0
C52 w_n58136_64971# a_n57248_65380# 0.09768f
C53 a_n57888_66178# a_n57914_66148# 0.10939f
C54 a_n57518_66181# a_n57906_65480# 0
C55 a_n57914_65295# a_n58100_65303# 0.0026f
C56 li_n58100_65000# a_n58100_65007# 0.00323f
C57 a_n57906_65396# a_n57906_65480# 0.22329f
C58 a_n57906_65396# a_n57222_66163# 0.01259f
C59 m2_n58100_65762# a_n57888_65236# 0.02291f
C60 a_n57914_65295# a_n57880_65606# 0.01538f
C61 a_n58100_65114# a_n58100_65144# 0.00218f
C62 a_n57914_65295# a_n57560_65603# 0.00942f
C63 a_n57906_65660# a_n58100_65602# 0
C64 w_n58136_64971# a_n57222_65678# 0.00264f
C65 a_n58100_65303# a_n57222_65323# 0
C66 a_n57518_66181# a_n57888_65236# 0.00124f
C67 w_n58136_64971# a_n57914_65295# 0.38297f
C68 a_n57906_65396# a_n57888_65236# 0.311f
C69 li_n58100_65000# a_n57248_65380# 0
C70 a_n58100_65303# a_n58100_65950# 0.00161f
C71 a_n57888_66178# a_n58100_65303# 0
C72 a_n57880_65426# a_n57248_65380# 0.00218f
C73 a_n57888_66178# a_n57880_65606# 0.00283f
C74 a_n57888_66178# a_n57560_65603# 0
C75 a_n58100_65114# a_n58100_65602# 0
C76 a_n57544_65423# a_n57888_65236# 0.00285f
C77 w_n58136_64971# a_n57222_65323# 0
C78 a_n58100_65371# a_n57906_65396# 0
C79 a_n58100_65860# a_n58100_65303# 0.00166f
C80 a_n58100_65007# a_n57248_65380# 0
C81 a_n58100_65303# a_n58100_65144# 0.02349f
C82 w_n58136_64971# a_n58100_65950# 0.03054f
C83 a_n57880_65798# a_n57888_65236# 0
C84 w_n58136_64971# a_n57888_66178# 0.34073f
C85 a_n57906_65660# m2_n58100_65762# 0.01513f
C86 m2_n58100_65762# a_n58100_65890# 0.00161f
C87 a_n57880_65426# a_n57914_65295# 0.00749f
C88 a_n57914_65295# a_n58100_65572# 0
C89 w_n58136_64971# a_n58100_65860# 0.02766f
C90 a_n57222_66163# a_n57906_65480# 0.04233f
C91 w_n58136_64971# a_n58100_65144# 0.03649f
C92 a_n57906_65660# a_n57906_65396# 0.27393f
C93 a_n57906_65396# a_n57248_66133# 0.00437f
C94 a_n58100_65303# a_n58100_65602# 0.00765f
C95 w_n58136_64971# a_n57222_66085# 0.00205f
C96 m2_n58100_65762# a_n58100_65114# 0
C97 m2_n58100_65762# a_n57914_66148# 0.00365f
C98 a_n57906_65660# a_n58100_65662# 0.0044f
C99 a_n57888_65236# a_n57906_65480# 0.16992f
C100 a_n57880_65426# a_n57888_66178# 0
C101 a_n57248_65380# a_n57222_65678# 0.04148f
C102 a_n57560_65795# a_n57914_65295# 0.00893f
C103 a_n57906_65396# a_n58100_65114# 0
C104 w_n58136_64971# a_n58100_65602# 0.07727f
C105 a_n57906_65396# a_n57914_66148# 0.00662f
C106 a_n57906_65660# a_n57880_65798# 0
C107 a_n57914_65295# a_n57248_65380# 0.0107f
C108 a_n58100_65371# a_n57906_65480# 0
C109 a_n57906_65396# m1_n57023_66189# 0
C110 a_n57222_65323# a_n57248_65380# 0.06164f
C111 m2_n58100_65762# a_n58100_65303# 0.00633f
C112 a_n57888_66178# a_n57560_65795# 0
C113 a_n58100_65371# a_n57888_65236# 0
C114 m2_n58100_65762# a_n57880_65606# 0.00142f
C115 a_n57888_66178# a_n57248_65380# 0
C116 a_n57906_65396# a_n58100_65303# 0.0059f
C117 a_n57906_65660# a_n57906_65480# 0.15009f
C118 a_n57248_66133# a_n57906_65480# 0.03827f
C119 a_n58100_65572# a_n58100_65602# 0.00316f
C120 a_n57222_66163# a_n57248_66133# 0.06167f
C121 w_n58136_64971# m2_n58100_65762# 0.17378f
C122 a_n57222_65323# a_n57222_65678# 0.13586f
C123 a_n57906_65396# a_n57880_65606# 0.00203f
C124 a_n57906_65396# a_n57560_65603# 0.00229f
C125 a_n58100_65662# a_n58100_65303# 0.00165f
C126 a_n57248_65380# a_n58100_65144# 0
C127 w_n58136_64971# a_n57518_66181# 0
C128 a_n57914_65295# a_n57222_65323# 0
C129 a_n57888_66178# a_n57222_65678# 0.0904f
C130 a_n57906_65660# a_n57888_65236# 0.09591f
C131 a_n57248_66133# a_n57888_65236# 0
C132 w_n58136_64971# a_n57906_65396# 0.24396f
C133 a_n57888_66178# a_n57914_65295# 0.07885f
C134 a_n57914_66148# a_n57906_65480# 0.00385f
C135 a_n57222_66163# a_n57914_66148# 0
C136 w_n58136_64971# a_n58100_65662# 0.02599f
C137 w_n58136_64971# a_n57544_65423# 0
C138 a_n57906_65480# m1_n57023_66189# 0.00687f
C139 a_n57222_66163# m1_n57023_66189# 0.0024f
C140 a_n57222_66085# a_n57222_65678# 0
C141 a_n58100_65860# a_n57914_65295# 0
C142 a_n57888_66178# a_n57222_65323# 0.00888f
C143 m2_n58100_65762# a_n58100_65572# 0
C144 a_n57914_66148# a_n57888_65236# 0.05335f
C145 w_n58136_64971# a_n57880_65798# 0.01489f
C146 a_n57888_66178# a_n58100_65950# 0
C147 a_n58100_65371# a_n58100_65114# 0
C148 a_n57880_65426# a_n57906_65396# 0.0028f
C149 a_n57906_65396# a_n58100_65572# 0
C150 a_n58100_65303# a_n57906_65480# 0
C151 a_n58100_65860# a_n58100_65950# 0.00693f
C152 a_n57560_65795# m2_n58100_65762# 0
C153 a_n58100_65662# a_n58100_65572# 0.00693f
C154 a_n57906_65660# a_n58100_65890# 0
C155 a_n58100_65303# a_n57888_65236# 0.00187f
C156 w_n58136_64971# a_n57906_65480# 0.31846f
C157 w_n58136_64971# a_n57222_66163# 0.00501f
C158 a_n57560_65795# a_n57906_65396# 0.00551f
C159 a_n57560_65603# a_n57888_65236# 0.00171f
C160 a_n58100_65114# a_n58100_65890# 0
C161 a_n57906_65660# a_n57914_66148# 0.02192f
C162 a_n57248_66133# a_n57914_66148# 0.004f
C163 a_n58100_65371# a_n58100_65303# 0.00502f
C164 a_n57906_65396# a_n57248_65380# 0.29057f
C165 a_n57888_66178# a_n58100_65602# 0
C166 a_n57248_66133# m1_n57023_66189# 0.00304f
C167 w_n58136_64971# a_n57888_65236# 0.23775f
C168 m2_n58100_65762# a_n57222_65678# 0.0055f
C169 a_n57544_65423# a_n57248_65380# 0.00132f
C170 m2_n58100_65762# a_n57914_65295# 0.01819f
C171 w_n58136_64971# a_n58100_65371# 0.03188f
C172 a_n57906_65396# a_n57222_65678# 0.00409f
C173 a_n57914_65295# a_n57518_66181# 0
C174 a_n58100_65572# a_n57906_65480# 0.00416f
C175 a_n57880_65426# a_n57906_65480# 0.00978f
C176 a_n57906_65660# a_n58100_65303# 0
C177 a_n58100_65890# a_n58100_65303# 0.00756f
C178 a_n57906_65396# a_n57914_65295# 0.19896f
C179 a_n57906_65660# a_n57880_65606# 0.00273f
C180 a_n57906_65660# a_n57560_65603# 0.00102f
C181 m2_n58100_65762# a_n58100_65950# 0
C182 a_n57888_66178# m2_n58100_65762# 0.33447f
C183 a_n58100_65662# a_n57914_65295# 0
C184 a_n57914_65295# a_n57544_65423# 0.00875f
C185 a_n57880_65426# a_n57888_65236# 0
C186 a_n57906_65396# a_n57222_65323# 0.00271f
C187 a_n57888_66178# a_n57518_66181# 0.0022f
C188 a_n58100_65114# a_n58100_65303# 0.00145f
C189 w_n58136_64971# a_n57906_65660# 0.15771f
C190 w_n58136_64971# a_n57248_66133# 0.00265f
C191 a_n58100_65860# m2_n58100_65762# 0
C192 w_n58136_64971# a_n58100_65890# 0.08129f
C193 a_n58100_65303# a_n57914_66148# 0
C194 a_n57906_65396# a_n58100_65950# 0
C195 a_n57880_65798# a_n57914_65295# 0.01522f
C196 a_n57888_66178# a_n57906_65396# 0.06121f
C197 a_n58100_65371# a_n58100_65572# 0.00243f
C198 a_n57248_65380# a_n57906_65480# 0.24124f
C199 a_n57914_66148# a_n57560_65603# 0
C200 a_n57888_66178# a_n58100_65662# 0
C201 li_n58100_65000# a_n58100_65000# 0
C202 a_n57560_65795# a_n57888_65236# 0.00194f
C203 w_n58136_64971# a_n58100_65114# 0.0286f
C204 w_n58136_64971# a_n57914_66148# 0.12244f
C205 a_n57248_65380# a_n57888_65236# 0.03562f
C206 a_n57906_65396# a_n57222_66085# 0.00291f
C207 a_n58100_65860# a_n58100_65662# 0.00248f
C208 a_n57888_66178# a_n57880_65798# 0.00508f
C209 w_n58136_64971# m1_n57023_66189# 0
C210 a_n57222_65678# a_n57906_65480# 0.0464f
C211 m2_n58100_65762# a_n58100_65602# 0.00157f
C212 a_n57222_66163# a_n57222_65678# 0.00231f
C213 a_n57906_65660# a_n58100_65572# 0
R0 a_n58100_65000# a_n58100_65000.t0 675.429
R1 a_n58100_65144# a_n58100_65144.t0 80.1361
R2 a_n57888_65236.t0 a_n57888_65236.n0 421.759
R3 a_n57888_65236# a_n57888_65236.n0 25.505
R4 a_n57888_65236.n0 a_n57888_65236.t1 26.3844
R5 a_n58100_65303# a_n58100_65303.t0 209.312
R6 a_n57222_65323.t0 a_n57222_65323.n0 22.7032
R7 a_n57222_65323.n0 a_n57222_65323.t2 22.7032
R8 a_n57222_65323.n1 a_n57222_65323.n0 360.495
R9 a_n57222_65323# a_n57222_65323.n1 94.0662
R10 a_n57222_65323.n1 a_n57222_65323.t1 45.6705
R11 a_n57222_65678# a_n57222_65678.t0 114.35
R12 a_n57544_65423# a_n57544_65423.t0 45.0005
R13 a_n57880_65426# a_n57880_65426.t0 53.1905
R14 a_n57560_65603# a_n57560_65603.t0 45.0005
R15 a_n57880_65606# a_n57880_65606.t0 53.1905
R16 a_n58100_65602# a_n58100_65602.t0 184.689
R17 a_n57560_65795# a_n57560_65795.t0 50.6255
R18 a_n57880_65798# a_n57880_65798.t0 53.1905
R19 a_n57914_65295.t1 a_n57914_65295.n0 26.2505
R20 a_n57914_65295.n5 a_n57914_65295.n0 98.8784
R21 a_n57914_65295.n0 a_n57914_65295.t3 43.7951
R22 a_n57914_65295.n5 a_n57914_65295.n2 6.4005
R23 a_n57914_65295.n2 a_n57914_65295.n4 64.7534
R24 a_n57914_65295.n4 a_n57914_65295.n3 204.505
R25 a_n57914_65295.n4 a_n57914_65295.t4 334.197
R26 a_n57914_65295.n3 a_n57914_65295.t2 35.4605
R27 a_n57914_65295.n3 a_n57914_65295.t0 29.5505
R28 a_n57914_65295.n2 a_n57914_65295.t5 316.462
R29 a_n57914_65295.n1 a_n57914_65295.n5 223.374
R30 a_n57914_65295.n1 a_n57914_65295.t6 177.981
R31 a_n57914_65295.t7 a_n57914_65295.n1 250.548
R32 a_n57914_65295# a_n57914_65295.t7 221.72
R33 a_n58100_65890# a_n58100_65890.t0 184.689
R34 a_n57222_66085# a_n57222_66085.t0 38.9194
R35 a_n57222_66163# a_n57222_66163.t0 207.774
R36 a_n57518_66181# a_n57518_66181.t0 467.368
R37 a_n57888_66178# a_n57888_66178.n0 532.463
R38 a_n57888_66178.n0 a_n57888_66178.t0 165.525
R39 a_n57888_66178.n0 a_n57888_66178.t1 587.451
R40 w_n58136_64971.t16 w_n58136_64971.n0 188.959
R41 w_n58136_64971.n0 w_n58136_64971.t18 120.612
R42 w_n58136_64971.n33 w_n58136_64971.n0 608.746
R43 w_n58136_64971.n3 w_n58136_64971.n4 4.5005
R44 w_n58136_64971.n5 w_n58136_64971.n6 4.5005
R45 w_n58136_64971.n7 w_n58136_64971.n8 4.5005
R46 w_n58136_64971.n9 w_n58136_64971.n10 4.5005
R47 w_n58136_64971.n11 w_n58136_64971.n21 4.5005
R48 w_n58136_64971.n22 w_n58136_64971.n44 9.3005
R49 w_n58136_64971.n5 w_n58136_64971.n23 9.3005
R50 w_n58136_64971.n24 w_n58136_64971.n43 9.3005
R51 w_n58136_64971.n26 w_n58136_64971.n25 9.3005
R52 w_n58136_64971.n27 w_n58136_64971.n40 9.3005
R53 w_n58136_64971.n28 w_n58136_64971.n39 9.3005
R54 w_n58136_64971.n29 w_n58136_64971.n37 9.3005
R55 w_n58136_64971.n31 w_n58136_64971.n30 9.3005
R56 w_n58136_64971.n32 w_n58136_64971.n41 9.3005
R57 w_n58136_64971.n11 w_n58136_64971.n1 0.0225246
R58 w_n58136_64971.n33 w_n58136_64971.n31 4.37628
R59 w_n58136_64971.n31 w_n58136_64971.n29 0.122949
R60 w_n58136_64971.n29 w_n58136_64971.n28 0.122949
R61 w_n58136_64971.n28 w_n58136_64971.n27 0.122949
R62 w_n58136_64971.n27 w_n58136_64971.n26 0.122949
R63 w_n58136_64971.n26 w_n58136_64971.n32 0.122949
R64 w_n58136_64971.n32 w_n58136_64971.n24 0.122949
R65 w_n58136_64971.n24 w_n58136_64971.n3 0.0413163
R66 w_n58136_64971.n3 w_n58136_64971.n5 0.0821327
R67 w_n58136_64971.n5 w_n58136_64971.n7 0.0821327
R68 w_n58136_64971.n7 w_n58136_64971.n22 0.0413163
R69 w_n58136_64971.n22 w_n58136_64971.n9 0.0413163
R70 w_n58136_64971.n9 w_n58136_64971.n11 0.0821327
R71 w_n58136_64971.n1 w_n58136_64971.n2 4.56092
R72 w_n58136_64971.n45 w_n58136_64971.t20 250.081
R73 w_n58136_64971.n1 w_n58136_64971.n45 6.82729
R74 w_n58136_64971.n44 w_n58136_64971.n45 15.8123
R75 w_n58136_64971.n44 w_n58136_64971.t26 698.289
R76 w_n58136_64971.n43 w_n58136_64971.n23 27.4829
R77 w_n58136_64971.n23 w_n58136_64971.n44 21.4593
R78 w_n58136_64971.n43 w_n58136_64971.t24 703.712
R79 w_n58136_64971.n41 w_n58136_64971.n43 10.9181
R80 w_n58136_64971.n41 w_n58136_64971.n42 313.168
R81 w_n58136_64971.n41 w_n58136_64971.t1 697.679
R82 w_n58136_64971.n42 w_n58136_64971.t10 37.4305
R83 w_n58136_64971.n42 w_n58136_64971.t5 39.4005
R84 w_n58136_64971.n40 w_n58136_64971.n25 27.4829
R85 w_n58136_64971.n25 w_n58136_64971.n41 20.7064
R86 w_n58136_64971.n40 w_n58136_64971.t12 703.712
R87 w_n58136_64971.n39 w_n58136_64971.n40 16.5652
R88 w_n58136_64971.n39 w_n58136_64971.t14 700.399
R89 w_n58136_64971.n37 w_n58136_64971.n39 0.376971
R90 w_n58136_64971.n37 w_n58136_64971.n38 223.704
R91 w_n58136_64971.n38 w_n58136_64971.t22 36.6566
R92 w_n58136_64971.n38 w_n58136_64971.t7 30.5355
R93 w_n58136_64971.n34 w_n58136_64971.n30 24.8476
R94 w_n58136_64971.n30 w_n58136_64971.n37 31.624
R95 w_n58136_64971.n35 w_n58136_64971.n34 211.838
R96 w_n58136_64971.n36 w_n58136_64971.t17 200.756
R97 w_n58136_64971.t17 w_n58136_64971.n35 46.2929
R98 w_n58136_64971.n35 w_n58136_64971.t21 318.009
R99 w_n58136_64971.t21 w_n58136_64971.t13 152.966
R100 w_n58136_64971.t13 w_n58136_64971.t6 50.3183
R101 w_n58136_64971.t6 w_n58136_64971.t3 169.069
R102 w_n58136_64971.t3 w_n58136_64971.t11 185.169
R103 w_n58136_64971.t11 w_n58136_64971.t2 8.05135
R104 w_n58136_64971.t2 w_n58136_64971.t9 169.069
R105 w_n58136_64971.t9 w_n58136_64971.t0 4.02592
R106 w_n58136_64971.t0 w_n58136_64971.t4 213.347
R107 w_n58136_64971.t4 w_n58136_64971.t8 169.069
R108 w_n58136_64971.t8 w_n58136_64971.t23 16.1022
R109 w_n58136_64971.t23 w_n58136_64971.t25 181.144
R110 w_n58136_64971.t25 w_n58136_64971.t19 398.517
R111 w_n58136_64971.n36 w_n58136_64971.t15 14.3226
R112 w_n58136_64971# w_n58136_64971.n36 1053.47
R113 w_n58136_64971.n34 w_n58136_64971.n33 0.850602
R114 w_n58136_64971.n12 w_n58136_64971.n13 3.4105
R115 w_n58136_64971.n14 w_n58136_64971.n15 3.4105
R116 w_n58136_64971.n16 w_n58136_64971.n17 3.4105
R117 w_n58136_64971.n4 w_n58136_64971.n6 0.108608
R118 w_n58136_64971.n6 w_n58136_64971.n12 0.027527
R119 w_n58136_64971.n12 w_n58136_64971.n8 0.0815811
R120 w_n58136_64971.n8 w_n58136_64971.n14 0.0545541
R121 w_n58136_64971.n14 w_n58136_64971.n10 0.0545541
R122 w_n58136_64971.n10 w_n58136_64971.n16 0.0815811
R123 w_n58136_64971.n16 w_n58136_64971.n21 0.027527
R124 w_n58136_64971.n21 w_n58136_64971.n2 0.108608
R125 w_n58136_64971.n19 w_n58136_64971.n13 0.0292348
R126 w_n58136_64971.n15 w_n58136_64971.n20 3.4105
R127 w_n58136_64971.n17 w_n58136_64971.n18 0.0292348
R128 w_n58136_64971.n4 w_n58136_64971.n19 3.43926
R129 w_n58136_64971.n13 w_n58136_64971.n15 0.0574697
R130 w_n58136_64971.n15 w_n58136_64971.n17 0.0574697
R131 w_n58136_64971.n18 w_n58136_64971.n2 3.43926
R132 w_n58136_64971.n19 w_n58136_64971.n20 1.69615
R133 w_n58136_64971.n20 w_n58136_64971.n18 1.69615
R134 a_n57560_65681# a_n57560_65681.n0 39.3755
R135 a_n57560_65681.n0 a_n57560_65681.t9 39.3755
R136 a_n57560_65681.n0 a_n57560_65681.n20 257.659
R137 a_n57560_65681.n1 a_n57560_65681.n2 9.3005
R138 a_n57560_65681.n20 a_n57560_65681.n1 10.9181
R139 a_n57560_65681.n4 a_n57560_65681.n3 9.3005
R140 a_n57560_65681.n6 a_n57560_65681.n5 9.3005
R141 a_n57560_65681.n7 a_n57560_65681.n8 9.3005
R142 a_n57560_65681.n20 a_n57560_65681.n7 12.424
R143 a_n57560_65681.n7 a_n57560_65681.n5 36.1417
R144 a_n57560_65681.n5 a_n57560_65681.n3 36.1417
R145 a_n57560_65681.n3 a_n57560_65681.n9 27.8593
R146 a_n57560_65681.n10 a_n57560_65681.n9 3.83061
R147 a_n57560_65681.n4 a_n57560_65681.n10 2.44039
R148 a_n57560_65681.n13 a_n57560_65681.n12 9.3005
R149 a_n57560_65681.n19 a_n57560_65681.n18 9.3005
R150 a_n57560_65681.n13 a_n57560_65681.n11 0.493603
R151 a_n57560_65681.n19 a_n57560_65681.n13 0.122949
R152 a_n57560_65681.n2 a_n57560_65681.n19 0.122949
R153 a_n57560_65681.n2 a_n57560_65681.n8 0.122949
R154 a_n57560_65681.n8 a_n57560_65681.n6 0.122949
R155 a_n57560_65681.n6 a_n57560_65681.n4 0.122949
R156 a_n57560_65681.n12 a_n57560_65681.n14 4.98327
R157 a_n57560_65681.n14 a_n57560_65681.n18 5.42088
R158 a_n57560_65681.n18 a_n57560_65681.n1 31.0674
R159 a_n57560_65681.n16 a_n57560_65681.n12 9.66968
R160 a_n57560_65681.n16 a_n57560_65681.n17 211.284
R161 a_n57560_65681.n17 a_n57560_65681.t19 39.9583
R162 a_n57560_65681.n17 a_n57560_65681.t7 30.938
R163 a_n57560_65681.n11 a_n57560_65681.n16 7.00366
R164 a_n57560_65681.n11 a_n57560_65681.t18 1629.77
R165 a_n57560_65681.t18 a_n57560_65681.t14 661.034
R166 a_n57560_65681.t14 a_n57560_65681.t6 89.5154
R167 a_n57560_65681.t6 a_n57560_65681.t4 537.09
R168 a_n57560_65681.t4 a_n57560_65681.t11 626.605
R169 a_n57560_65681.t11 a_n57560_65681.t3 75.7439
R170 a_n57560_65681.t3 a_n57560_65681.t0 516.433
R171 a_n57560_65681.t0 a_n57560_65681.t13 20.6578
R172 a_n57560_65681.t13 a_n57560_65681.t8 784.977
R173 a_n57560_65681.t8 a_n57560_65681.t10 578.404
R174 a_n57560_65681.t10 a_n57560_65681.t1 1418.47
R175 a_n57560_65681.t1 a_n57560_65681.t5 537.09
R176 a_n57560_65681.t5 a_n57560_65681.t16 123.945
R177 a_n57560_65681.n14 a_n57560_65681.n15 150.556
R178 a_n57560_65681.n15 a_n57560_65681.t15 61.6221
R179 a_n57560_65681.n15 a_n57560_65681.t12 61.6221
R180 a_n57560_65681.n10 a_n57560_65681.t17 162.424
R181 a_n57560_65681.n9 a_n57560_65681.t2 159.611
C214 m5_n58100_65000# a_n57560_65681# 0 $ **FLOATING
C215 m4_n57132_65036# a_n57560_65681# 0 $ **FLOATING
C216 m4_n57308_65000# a_n57560_65681# 0 $ **FLOATING
C217 m4_n57484_65000# a_n57560_65681# 0 $ **FLOATING
C218 m4_n57660_65000# a_n57560_65681# 0 $ **FLOATING
C219 m4_n57836_65000# a_n57560_65681# 0 $ **FLOATING
C220 m4_n57132_65212# a_n57560_65681# 0 $ **FLOATING
C221 m4_n57308_65176# a_n57560_65681# 0 $ **FLOATING
C222 m4_n57484_65140# a_n57560_65681# 0 $ **FLOATING
C223 m4_n57660_65104# a_n57560_65681# 0 $ **FLOATING
C224 m4_n57836_65068# a_n57560_65681# 0 $ **FLOATING
C225 m4_n58012_65032# a_n57560_65681# 0 $ **FLOATING
C226 m4_n58100_65000# a_n57560_65681# 0 $ **FLOATING
C227 m4_n57132_65388# a_n57560_65681# 0 $ **FLOATING
C228 m4_n57308_65352# a_n57560_65681# 0 $ **FLOATING
C229 m4_n57484_65316# a_n57560_65681# 0 $ **FLOATING
C230 m4_n57660_65280# a_n57560_65681# 0 $ **FLOATING
C231 m4_n57836_65244# a_n57560_65681# 0 $ **FLOATING
C232 m4_n58012_65208# a_n57560_65681# 0 $ **FLOATING
C233 m4_n58100_65172# a_n57560_65681# 0 $ **FLOATING
C234 m4_n57132_65564# a_n57560_65681# 0 $ **FLOATING
C235 m4_n57308_65528# a_n57560_65681# 0 $ **FLOATING
C236 m4_n57484_65492# a_n57560_65681# 0 $ **FLOATING
C237 m4_n57660_65456# a_n57560_65681# 0 $ **FLOATING
C238 m4_n57836_65420# a_n57560_65681# 0 $ **FLOATING
C239 m4_n58012_65384# a_n57560_65681# 0 $ **FLOATING
C240 m4_n58100_65348# a_n57560_65681# 0 $ **FLOATING
C241 m4_n57836_65596# a_n57560_65681# 0 $ **FLOATING
C242 m4_n58012_65560# a_n57560_65681# 0 $ **FLOATING
C243 m4_n58100_65524# a_n57560_65681# 0 $ **FLOATING
C244 m3_n57238_65000# a_n57560_65681# 0 $ **FLOATING
C245 m3_n57414_65000# a_n57560_65681# 0 $ **FLOATING
C246 m3_n57238_65106# a_n57560_65681# 0 $ **FLOATING
C247 m3_n57414_65070# a_n57560_65681# 0 $ **FLOATING
C248 m3_n57590_65034# a_n57560_65681# 0 $ **FLOATING
C249 m3_n57766_65000# a_n57560_65681# 0 $ **FLOATING
C250 m3_n57942_65000# a_n57560_65681# 0 $ **FLOATING
C251 m3_n58100_65000# a_n57560_65681# 0 $ **FLOATING
C252 m3_n57238_65282# a_n57560_65681# 0 $ **FLOATING
C253 m3_n57414_65246# a_n57560_65681# 0 $ **FLOATING
C254 m3_n57590_65210# a_n57560_65681# 0 $ **FLOATING
C255 m3_n57766_65174# a_n57560_65681# 0 $ **FLOATING
C256 m3_n57942_65138# a_n57560_65681# 0 $ **FLOATING
C257 m3_n58100_65102# a_n57560_65681# 0 $ **FLOATING
C258 m3_n57238_65458# a_n57560_65681# 0 $ **FLOATING
C259 m3_n57414_65422# a_n57560_65681# 0 $ **FLOATING
C260 m3_n57590_65386# a_n57560_65681# 0 $ **FLOATING
C261 m3_n57766_65350# a_n57560_65681# 0 $ **FLOATING
C262 m3_n57942_65314# a_n57560_65681# 0 $ **FLOATING
C263 m3_n58100_65278# a_n57560_65681# 0 $ **FLOATING
C264 m3_n57238_65634# a_n57560_65681# 0 $ **FLOATING
C265 m3_n57414_65598# a_n57560_65681# 0 $ **FLOATING
C266 m3_n57590_65562# a_n57560_65681# 0 $ **FLOATING
C267 m3_n57766_65526# a_n57560_65681# 0 $ **FLOATING
C268 m3_n57942_65490# a_n57560_65681# 0 $ **FLOATING
C269 m3_n58100_65454# a_n57560_65681# 0 $ **FLOATING
C270 m3_n57414_65774# a_n57560_65681# 0 $ **FLOATING
C271 m3_n57590_65738# a_n57560_65681# 0 $ **FLOATING
C272 m3_n57766_65702# a_n57560_65681# 0 $ **FLOATING
C273 m3_n57414_65950# a_n57560_65681# 0 $ **FLOATING
C274 m3_n57590_65914# a_n57560_65681# 0 $ **FLOATING
C275 m3_n57766_65878# a_n57560_65681# 0 $ **FLOATING
C276 m3_n57414_66126# a_n57560_65681# 0 $ **FLOATING
C277 m3_n57590_66090# a_n57560_65681# 0 $ **FLOATING
C278 m3_n57766_66054# a_n57560_65681# 0 $ **FLOATING
C279 m2_n57200_65000# a_n57560_65681# 0 $ **FLOATING
C280 m2_n57300_65020# a_n57560_65681# 0 $ **FLOATING
C281 m2_n57400_65040# a_n57560_65681# 0 $ **FLOATING
C282 m2_n57700_65000# a_n57560_65681# 0 $ **FLOATING
C283 m2_n57500_65060# a_n57560_65681# 0 $ **FLOATING
C284 m2_n57928_65052# a_n57560_65681# 0 $ **FLOATING
C285 m2_n58084_65036# a_n57560_65681# 0 $ **FLOATING
C286 m2_n57800_65220# a_n57560_65681# 0 $ **FLOATING
C287 m2_n57900_65240# a_n57560_65681# 0 $ **FLOATING
C288 m2_n58100_65580# a_n57560_65681# 0 $ **FLOATING
C289 m2_n57900_65640# a_n57560_65681# 0 $ **FLOATING
C290 m2_n58100_65762# a_n57560_65681# 0.16042f
C291 m2_n57500_65860# a_n57560_65681# 0 $ **FLOATING
C292 m2_n57300_65920# a_n57560_65681# 0 $ **FLOATING
C293 m2_n57600_65880# a_n57560_65681# 0 $ **FLOATING
C294 m2_n57700_65900# a_n57560_65681# 0 $ **FLOATING
C295 m2_n57600_65980# a_n57560_65681# 0 $ **FLOATING
C296 m2_n57600_66080# a_n57560_65681# 0 $ **FLOATING
C297 m2_n57772_66004# a_n57560_65681# 0 $ **FLOATING
C298 m2_n57460_66192# a_n57560_65681# 0 $ **FLOATING
C299 m1_n57490_65000# a_n57560_65681# 0 $ **FLOATING
C300 m1_n57590_65000# a_n57560_65681# 0 $ **FLOATING
C301 m1_n57690_65000# a_n57560_65681# 0 $ **FLOATING
C302 m1_n57490_65050# a_n57560_65681# 0 $ **FLOATING
C303 m1_n57790_65010# a_n57560_65681# 0 $ **FLOATING
C304 m1_n57790_65110# a_n57560_65681# 0 $ **FLOATING
C305 m1_n57023_66189# a_n57560_65681# 0.0088f
C306 m1_n57790_65210# a_n57560_65681# 0 $ **FLOATING
C307 m1_n57790_65310# a_n57560_65681# 0 $ **FLOATING
C308 m1_n57790_65410# a_n57560_65681# 0 $ **FLOATING
C309 m1_n57790_65510# a_n57560_65681# 0 $ **FLOATING
C310 li_n57726_65000# a_n57560_65681# 0 $ **FLOATING
C311 li_n58100_65000# a_n57560_65681# 0.01322f
C312 a_n58100_65000# a_n57560_65681# 0 $ **FLOATING
C313 a_n58100_65007# a_n57560_65681# 0.0068f $ **FLOATING
C314 a_n58100_65114# a_n57560_65681# 0.00161f $ **FLOATING
C315 a_n58100_65144# a_n57560_65681# 0.00652f $ **FLOATING
C316 a_n57888_65236# a_n57560_65681# 0.309f $ **FLOATING
C317 a_n58100_65303# a_n57560_65681# 0.23712f $ **FLOATING
C318 a_n57248_65380# a_n57560_65681# 0.38189f $ **FLOATING
C319 a_n57222_65323# a_n57560_65681# 0.21271f $ **FLOATING
C320 a_n57222_65678# a_n57560_65681# 0.11319f $ **FLOATING
C321 a_n57544_65423# a_n57560_65681# 0.00549f $ **FLOATING
C322 a_n58100_65371# a_n57560_65681# 0.00123f $ **FLOATING
C323 a_n57880_65426# a_n57560_65681# 0 $ **FLOATING
C324 a_n57560_65603# a_n57560_65681# 0.00339f $ **FLOATING
C325 a_n58100_65572# a_n57560_65681# 0 $ **FLOATING
C326 a_n57880_65606# a_n57560_65681# 0 $ **FLOATING
C327 a_n58100_65602# a_n57560_65681# 0.01044f $ **FLOATING
C328 a_n58100_65662# a_n57560_65681# 0 $ **FLOATING
C329 a_n57560_65795# a_n57560_65681# 0.00208f $ **FLOATING
C330 a_n57906_65396# a_n57560_65681# 1.16062f $ **FLOATING
C331 a_n57880_65798# a_n57560_65681# 0 $ **FLOATING
C332 a_n57906_65660# a_n57560_65681# 0.33313f $ **FLOATING
C333 a_n58100_65860# a_n57560_65681# 0 $ **FLOATING
C334 a_n57914_65295# a_n57560_65681# 0.30041f $ **FLOATING
C335 a_n58100_65890# a_n57560_65681# 0.01044f $ **FLOATING
C336 a_n58100_65950# a_n57560_65681# 0.00319f $ **FLOATING
C337 a_n57906_65480# a_n57560_65681# 1.14614f $ **FLOATING
C338 a_n57222_66085# a_n57560_65681# 0.00893f $ **FLOATING
C339 a_n57248_66133# a_n57560_65681# 0.1128f $ **FLOATING
C340 a_n57222_66163# a_n57560_65681# 0.12376f $ **FLOATING
C341 a_n57914_66148# a_n57560_65681# 0.21943f $ **FLOATING
C342 a_n57518_66181# a_n57560_65681# 0.00416f $ **FLOATING
C343 a_n57888_66178# a_n57560_65681# 0.33092f $ **FLOATING
C344 w_n58136_64971# a_n57560_65681# 2.67195f $ **FLOATING
C345 a_n57560_65681# a_n57560_65681# 0 $ **FLOATING
C346 a_n57560_65681.t9 a_n57560_65681# 0 $ **FLOATING
C347 a_n57560_65681.n0 a_n57560_65681# 0 $ **FLOATING
C348 a_n57560_65681.n1 a_n57560_65681# 0 $ **FLOATING
C349 a_n57560_65681.n2 a_n57560_65681# 0 $ **FLOATING
C350 a_n57560_65681.n3 a_n57560_65681# 0 $ **FLOATING
C351 a_n57560_65681.n4 a_n57560_65681# 0 $ **FLOATING
C352 a_n57560_65681.n5 a_n57560_65681# 0 $ **FLOATING
C353 a_n57560_65681.n6 a_n57560_65681# 0 $ **FLOATING
C354 a_n57560_65681.n7 a_n57560_65681# 0 $ **FLOATING
C355 a_n57560_65681.n8 a_n57560_65681# 0 $ **FLOATING
C356 a_n57560_65681.n9 a_n57560_65681# 0 $ **FLOATING
C357 a_n57560_65681.t2 a_n57560_65681# 0 $ **FLOATING
C358 a_n57560_65681.n10 a_n57560_65681# 0 $ **FLOATING
C359 a_n57560_65681.t17 a_n57560_65681# 0 $ **FLOATING
C360 a_n57560_65681.n11 a_n57560_65681# 0 $ **FLOATING
C361 a_n57560_65681.n12 a_n57560_65681# 0 $ **FLOATING
C362 a_n57560_65681.n13 a_n57560_65681# 0 $ **FLOATING
C363 a_n57560_65681.n14 a_n57560_65681# 0 $ **FLOATING
C364 a_n57560_65681.t12 a_n57560_65681# 0 $ **FLOATING
C365 a_n57560_65681.t15 a_n57560_65681# 0 $ **FLOATING
C366 a_n57560_65681.n15 a_n57560_65681# 0 $ **FLOATING
C367 a_n57560_65681.t16 a_n57560_65681# 0 $ **FLOATING
C368 a_n57560_65681.t5 a_n57560_65681# 0 $ **FLOATING
C369 a_n57560_65681.t1 a_n57560_65681# 0 $ **FLOATING
C370 a_n57560_65681.t10 a_n57560_65681# 0 $ **FLOATING
C371 a_n57560_65681.t8 a_n57560_65681# 0 $ **FLOATING
C372 a_n57560_65681.t13 a_n57560_65681# 0 $ **FLOATING
C373 a_n57560_65681.t0 a_n57560_65681# 0 $ **FLOATING
C374 a_n57560_65681.t3 a_n57560_65681# 0 $ **FLOATING
C375 a_n57560_65681.t11 a_n57560_65681# 0 $ **FLOATING
C376 a_n57560_65681.t4 a_n57560_65681# 0 $ **FLOATING
C377 a_n57560_65681.t6 a_n57560_65681# 0 $ **FLOATING
C378 a_n57560_65681.t14 a_n57560_65681# 0 $ **FLOATING
C379 a_n57560_65681.t18 a_n57560_65681# 0 $ **FLOATING
C380 a_n57560_65681.n16 a_n57560_65681# 0 $ **FLOATING
C381 a_n57560_65681.t7 a_n57560_65681# 0 $ **FLOATING
C382 a_n57560_65681.t19 a_n57560_65681# 0 $ **FLOATING
C383 a_n57560_65681.n17 a_n57560_65681# 0 $ **FLOATING
C384 a_n57560_65681.n18 a_n57560_65681# 0 $ **FLOATING
C385 a_n57560_65681.n19 a_n57560_65681# 0 $ **FLOATING
C386 a_n57560_65681.n20 a_n57560_65681# 0 $ **FLOATING
C387 w_n58136_64971.t16 a_n57560_65681# 0 $ **FLOATING
C388 w_n58136_64971.n0 a_n57560_65681# 0 $ **FLOATING
C389 w_n58136_64971.n1 a_n57560_65681# 0 $ **FLOATING
C390 w_n58136_64971.n2 a_n57560_65681# 0 $ **FLOATING
C391 w_n58136_64971.n3 a_n57560_65681# 0 $ **FLOATING
C392 w_n58136_64971.n4 a_n57560_65681# 0 $ **FLOATING
C393 w_n58136_64971.n5 a_n57560_65681# 0 $ **FLOATING
C394 w_n58136_64971.n6 a_n57560_65681# 0 $ **FLOATING
C395 w_n58136_64971.n7 a_n57560_65681# 0 $ **FLOATING
C396 w_n58136_64971.n8 a_n57560_65681# 0 $ **FLOATING
C397 w_n58136_64971.n9 a_n57560_65681# 0 $ **FLOATING
C398 w_n58136_64971.n10 a_n57560_65681# 0 $ **FLOATING
C399 w_n58136_64971.n11 a_n57560_65681# 0 $ **FLOATING
C400 w_n58136_64971.n12 a_n57560_65681# 0 $ **FLOATING
C401 w_n58136_64971.n13 a_n57560_65681# 0 $ **FLOATING
C402 w_n58136_64971.n14 a_n57560_65681# 0 $ **FLOATING
C403 w_n58136_64971.n15 a_n57560_65681# 0 $ **FLOATING
C404 w_n58136_64971.n16 a_n57560_65681# 0 $ **FLOATING
C405 w_n58136_64971.n17 a_n57560_65681# 0 $ **FLOATING
C406 w_n58136_64971.n18 a_n57560_65681# 0 $ **FLOATING
C407 w_n58136_64971.n19 a_n57560_65681# 0 $ **FLOATING
C408 w_n58136_64971.n20 a_n57560_65681# 0 $ **FLOATING
C409 w_n58136_64971.n21 a_n57560_65681# 0 $ **FLOATING
C410 w_n58136_64971.n22 a_n57560_65681# 0 $ **FLOATING
C411 w_n58136_64971.n23 a_n57560_65681# 0 $ **FLOATING
C412 w_n58136_64971.n24 a_n57560_65681# 0 $ **FLOATING
C413 w_n58136_64971.n25 a_n57560_65681# 0 $ **FLOATING
C414 w_n58136_64971.n26 a_n57560_65681# 0 $ **FLOATING
C415 w_n58136_64971.n27 a_n57560_65681# 0 $ **FLOATING
C416 w_n58136_64971.n28 a_n57560_65681# 0 $ **FLOATING
C417 w_n58136_64971.n29 a_n57560_65681# 0 $ **FLOATING
C418 w_n58136_64971.n30 a_n57560_65681# 0 $ **FLOATING
C419 w_n58136_64971.n31 a_n57560_65681# 0 $ **FLOATING
C420 w_n58136_64971.n32 a_n57560_65681# 0 $ **FLOATING
C421 w_n58136_64971.n33 a_n57560_65681# 0 $ **FLOATING
C422 w_n58136_64971.n34 a_n57560_65681# 0 $ **FLOATING
C423 w_n58136_64971.n35 a_n57560_65681# 0 $ **FLOATING
C424 w_n58136_64971.n36 a_n57560_65681# 0 $ **FLOATING
C425 w_n58136_64971.t19 a_n57560_65681# 0 $ **FLOATING
C426 w_n58136_64971.t25 a_n57560_65681# 0 $ **FLOATING
C427 w_n58136_64971.t23 a_n57560_65681# 0 $ **FLOATING
C428 w_n58136_64971.t8 a_n57560_65681# 0 $ **FLOATING
C429 w_n58136_64971.t4 a_n57560_65681# 0 $ **FLOATING
C430 w_n58136_64971.t0 a_n57560_65681# 0 $ **FLOATING
C431 w_n58136_64971.t9 a_n57560_65681# 0 $ **FLOATING
C432 w_n58136_64971.t11 a_n57560_65681# 0 $ **FLOATING
C433 w_n58136_64971.t2 a_n57560_65681# 0 $ **FLOATING
C434 w_n58136_64971.t3 a_n57560_65681# 0 $ **FLOATING
C435 w_n58136_64971.t13 a_n57560_65681# 0 $ **FLOATING
C436 w_n58136_64971.t6 a_n57560_65681# 0 $ **FLOATING
C437 w_n58136_64971.t21 a_n57560_65681# 0 $ **FLOATING
C438 w_n58136_64971.t17 a_n57560_65681# 0 $ **FLOATING
C439 w_n58136_64971.t15 a_n57560_65681# 0 $ **FLOATING
C440 w_n58136_64971.n37 a_n57560_65681# 0 $ **FLOATING
C441 w_n58136_64971.n38 a_n57560_65681# 0 $ **FLOATING
C442 w_n58136_64971.t7 a_n57560_65681# 0 $ **FLOATING
C443 w_n58136_64971.t22 a_n57560_65681# 0 $ **FLOATING
C444 w_n58136_64971.n39 a_n57560_65681# 0 $ **FLOATING
C445 w_n58136_64971.t14 a_n57560_65681# 0 $ **FLOATING
C446 w_n58136_64971.n40 a_n57560_65681# 0 $ **FLOATING
C447 w_n58136_64971.t12 a_n57560_65681# 0 $ **FLOATING
C448 w_n58136_64971.n41 a_n57560_65681# 0 $ **FLOATING
C449 w_n58136_64971.n42 a_n57560_65681# 0 $ **FLOATING
C450 w_n58136_64971.t5 a_n57560_65681# 0 $ **FLOATING
C451 w_n58136_64971.t10 a_n57560_65681# 0 $ **FLOATING
C452 w_n58136_64971.t1 a_n57560_65681# 0 $ **FLOATING
C453 w_n58136_64971.n43 a_n57560_65681# 0 $ **FLOATING
C454 w_n58136_64971.t24 a_n57560_65681# 0 $ **FLOATING
C455 w_n58136_64971.n44 a_n57560_65681# 0 $ **FLOATING
C456 w_n58136_64971.t26 a_n57560_65681# 0 $ **FLOATING
C457 w_n58136_64971.n45 a_n57560_65681# 0 $ **FLOATING
C458 w_n58136_64971.t20 a_n57560_65681# 0 $ **FLOATING
C459 w_n58136_64971.t18 a_n57560_65681# 0 $ **FLOATING
C460 a_n57888_66178.t0 a_n57560_65681# 0 $ **FLOATING
C461 a_n57888_66178.n0 a_n57560_65681# 0 $ **FLOATING
C462 a_n57888_66178.t1 a_n57560_65681# 0 $ **FLOATING
C463 a_n57518_66181.t0 a_n57560_65681# 0 $ **FLOATING
C464 a_n57222_66163.t0 a_n57560_65681# 0 $ **FLOATING
C465 a_n57222_66085.t0 a_n57560_65681# 0 $ **FLOATING
C466 a_n58100_65890.t0 a_n57560_65681# 0 $ **FLOATING
C467 a_n57914_65295.t1 a_n57560_65681# 0 $ **FLOATING
C468 a_n57914_65295.n0 a_n57560_65681# 0 $ **FLOATING
C469 a_n57914_65295.t7 a_n57560_65681# 0 $ **FLOATING
C470 a_n57914_65295.t6 a_n57560_65681# 0 $ **FLOATING
C471 a_n57914_65295.n1 a_n57560_65681# 0 $ **FLOATING
C472 a_n57914_65295.t5 a_n57560_65681# 0 $ **FLOATING
C473 a_n57914_65295.n2 a_n57560_65681# 0 $ **FLOATING
C474 a_n57914_65295.n3 a_n57560_65681# 0 $ **FLOATING
C475 a_n57914_65295.t0 a_n57560_65681# 0 $ **FLOATING
C476 a_n57914_65295.t2 a_n57560_65681# 0 $ **FLOATING
C477 a_n57914_65295.t4 a_n57560_65681# 0 $ **FLOATING
C478 a_n57914_65295.n4 a_n57560_65681# 0 $ **FLOATING
C479 a_n57914_65295.n5 a_n57560_65681# 0 $ **FLOATING
C480 a_n57914_65295.t3 a_n57560_65681# 0 $ **FLOATING
C481 a_n57880_65798.t0 a_n57560_65681# 0 $ **FLOATING
C482 a_n57560_65795.t0 a_n57560_65681# 0 $ **FLOATING
C483 a_n58100_65602.t0 a_n57560_65681# 0 $ **FLOATING
C484 a_n57880_65606.t0 a_n57560_65681# 0 $ **FLOATING
C485 a_n57560_65603.t0 a_n57560_65681# 0 $ **FLOATING
C486 a_n57880_65426.t0 a_n57560_65681# 0 $ **FLOATING
C487 a_n57544_65423.t0 a_n57560_65681# 0 $ **FLOATING
C488 a_n57222_65678.t0 a_n57560_65681# 0 $ **FLOATING
C489 a_n57222_65323.t0 a_n57560_65681# 0 $ **FLOATING
C490 a_n57222_65323.n0 a_n57560_65681# 0 $ **FLOATING
C491 a_n57222_65323.n1 a_n57560_65681# 0 $ **FLOATING
C492 a_n57222_65323.t1 a_n57560_65681# 0 $ **FLOATING
C493 a_n57222_65323.t2 a_n57560_65681# 0 $ **FLOATING
C494 a_n58100_65303.t0 a_n57560_65681# 0 $ **FLOATING
C495 a_n57888_65236.t0 a_n57560_65681# 0 $ **FLOATING
C496 a_n57888_65236.n0 a_n57560_65681# 0 $ **FLOATING
C497 a_n57888_65236.t1 a_n57560_65681# 0 $ **FLOATING
C498 a_n58100_65144.t0 a_n57560_65681# 0 $ **FLOATING
C499 a_n58100_65000.t0 a_n57560_65681# 0 $ **FLOATING
.ends
