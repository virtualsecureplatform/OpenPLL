* NGSPICE file created from RotatedCrop.ext - technology: sky130A

.subckt RotatedCrop
X0 a_n57888_66178# a_n57914_66148# w_n58136_64971# w_n58136_64971# sky130_fd_pr__pfet_01v8 ad=0.1232 pd=2.46 as=0.3192 ps=2.81 w=1.12 l=0.15
X1 w_n58136_64971# a_n58100_65371# a_n58100_65303# w_n58136_64971# sky130_fd_pr__pfet_01v8 ad=0.096 pd=1.24 as=0.1088 ps=1.32 w=0.32 l=0.15
X2 a_n57560_65795# a_n57906_65396# a_n57560_65681# a_n57560_65681# sky130_fd_pr__nfet_01v8_lvt ad=0.0864 pd=0.91 as=0.1344 ps=1.06 w=0.64 l=0.15
X3 a_n57222_65323# a_n57906_65660# a_n57560_65681# a_n57560_65681# sky130_fd_pr__nfet_01v8_lvt ad=0.1036 pd=1.02 as=0.3361 ps=1.68 w=0.74 l=0.15
X4 w_n58136_64971# a_n58100_65007# a_n58100_65000# w_n58136_64971# sky130_fd_pr__pfet_01v8 ad=0.04715 pd=0.63 as=8.575m ps=0.56 w=0.245 l=0.15
X5 a_n57914_65295# a_n57906_65660# a_n57880_65798# w_n58136_64971# sky130_fd_pr__pfet_01v8 ad=0.295 pd=2.59 as=0.135 ps=1.27 w=1 l=0.15
X6 w_n58136_64971# a_n57914_65295# a_n57888_65236# w_n58136_64971# sky130_fd_pr__pfet_01v8 ad=0.1934 pd=1.475 as=0.3304 ps=2.83 w=1.12 l=0.15
X7 a_n57880_65798# a_n57906_65396# w_n58136_64971# w_n58136_64971# sky130_fd_pr__pfet_01v8 ad=0.135 pd=1.27 as=0.195 ps=1.39 w=1 l=0.15
X8 a_n57560_65681# a_n57906_65660# a_n57560_65603# a_n57560_65681# sky130_fd_pr__nfet_01v8_lvt ad=0.1344 pd=1.06 as=0.0768 ps=0.88 w=0.64 l=0.15
X9 a_n57914_65295# a_n57906_65480# a_n57544_65423# a_n57560_65681# sky130_fd_pr__nfet_01v8_lvt ad=0.1222 pd=1.08 as=0.0768 ps=0.88 w=0.64 l=0.15
X10 a_n57560_65681# a_n57248_65380# a_n57222_65323# a_n57560_65681# sky130_fd_pr__nfet_01v8_lvt ad=0.3361 pd=1.68 as=0.2109 ps=2.05 w=0.74 l=0.15
X11 a_n57518_66181# a_n57914_66148# a_n57560_65681# a_n57560_65681# sky130_fd_pr__nfet_01v8_lvt ad=0.0703 pd=1.67 as=0.2109 ps=2.05 w=0.74 l=0.15
X12 w_n58136_64971# a_n58100_65950# a_n58100_65890# w_n58136_64971# sky130_fd_pr__pfet_01v8 ad=0.0912 pd=1.21 as=0.048 ps=0.62 w=0.32 l=0.15
X13 a_n58100_65890# a_n58100_65860# w_n58136_64971# w_n58136_64971# sky130_fd_pr__pfet_01v8 ad=0.048 pd=0.62 as=0.0912 ps=1.21 w=0.32 l=0.15
X14 a_n57222_65678# a_n57888_66178# a_n57222_65323# a_n57560_65681# sky130_fd_pr__nfet_01v8_lvt ad=0.2627 pd=2.19 as=0.1036 ps=1.02 w=0.74 l=0.15
X15 a_n58100_65144# a_n58100_65114# w_n58136_64971# w_n58136_64971# sky130_fd_pr__pfet_01v8 ad=0.07227 pd=1.08 as=0.04715 ps=0.63 w=0.245 l=0.15
X16 a_n57222_66163# a_n57248_66133# a_n57222_66085# a_n57560_65681# sky130_fd_pr__nfet_01v8_lvt ad=0.1369 pd=1.85 as=0.0888 ps=0.98 w=0.74 l=0.15
X17 a_n57560_65603# a_n57906_65480# a_n57914_65295# a_n57560_65681# sky130_fd_pr__nfet_01v8_lvt ad=0.0768 pd=0.88 as=0.1222 ps=1.08 w=0.64 l=0.15
X18 a_n57560_65681# a_n57914_65295# a_n57888_65236# a_n57560_65681# sky130_fd_pr__nfet_01v8_lvt ad=0.1389 pd=1.135 as=0.2081 ps=2.05 w=0.74 l=0.15
X19 a_n57914_65295# a_n57906_65660# a_n57560_65795# a_n57560_65681# sky130_fd_pr__nfet_01v8_lvt ad=0.1733 pd=1.85 as=0.0864 ps=0.91 w=0.64 l=0.15
X20 w_n58136_64971# a_n58100_65662# a_n58100_65602# w_n58136_64971# sky130_fd_pr__pfet_01v8 ad=0.0912 pd=1.21 as=0.048 ps=0.62 w=0.32 l=0.15
X21 a_n58100_65602# a_n58100_65572# w_n58136_64971# w_n58136_64971# sky130_fd_pr__pfet_01v8 ad=0.048 pd=0.62 as=0.0912 ps=1.21 w=0.32 l=0.15
X22 a_n57544_65423# a_n57906_65396# a_n57560_65681# a_n57560_65681# sky130_fd_pr__nfet_01v8_lvt ad=0.0768 pd=0.88 as=0.1389 ps=1.135 w=0.64 l=0.15
X23 w_n58136_64971# a_n57906_65660# a_n57880_65606# w_n58136_64971# sky130_fd_pr__pfet_01v8 ad=0.195 pd=1.39 as=0.135 ps=1.27 w=1 l=0.15
X24 a_n57914_65295# a_n57906_65480# a_n57880_65426# w_n58136_64971# sky130_fd_pr__pfet_01v8 ad=0.165 pd=1.33 as=0.135 ps=1.27 w=1 l=0.15
X25 a_n57880_65606# a_n57906_65480# a_n57914_65295# w_n58136_64971# sky130_fd_pr__pfet_01v8 ad=0.135 pd=1.27 as=0.165 ps=1.33 w=1 l=0.15
X26 a_n57880_65426# a_n57906_65396# w_n58136_64971# w_n58136_64971# sky130_fd_pr__pfet_01v8 ad=0.135 pd=1.27 as=0.1934 ps=1.475 w=1 l=0.15
X27 a_n57222_66085# a_n57906_65480# a_n57560_65681# a_n57560_65681# sky130_fd_pr__nfet_01v8_lvt ad=0.0888 pd=0.98 as=0.2109 ps=2.05 w=0.74 l=0.15
C0 a_n57222_65678# a_n57906_65396# 0.00409f
C1 a_n57914_65295# a_n57248_65380# 0.0107f
C2 a_n57906_65660# a_n58100_65860# 0.00374f
C3 a_n57880_65426# a_n57914_65295# 0.00749f
C4 a_n58100_65572# a_n57906_65396# 0
C5 a_n57222_65678# a_n57906_65480# 0.0464f
C6 a_n58100_65860# a_n58100_65950# 0.00693f
C7 a_n58100_65572# a_n57906_65480# 0.00416f
C8 a_n57880_65798# a_n57906_65660# 0
C9 a_n57248_65380# a_n58100_65144# 0
C10 a_n57906_65396# a_n58100_65371# 0
C11 a_n58100_65890# a_n57906_65660# 0
C12 a_n58100_65662# a_n57914_65295# 0
C13 a_n57888_65236# a_n57248_65380# 0.03562f
C14 a_n57906_65480# a_n58100_65371# 0
C15 a_n58100_65890# a_n58100_65950# 0.00254f
C16 a_n57880_65426# a_n57888_65236# 0
C17 a_n57914_65295# a_n57888_65236# 0.18875f
C18 a_n58100_65662# m2_n58100_65762# 0
C19 a_n57518_66181# w_n58136_64971# 0
C20 a_n58100_65860# w_n58136_64971# 0.02766f
C21 a_n57914_65295# m2_n58100_65762# 0.01819f
C22 a_n57880_65798# w_n58136_64971# 0.01489f
C23 a_n58100_65890# w_n58136_64971# 0.08129f
C24 a_n58100_65303# a_n58100_65602# 0.00765f
C25 m2_n58100_65762# a_n57888_65236# 0.02291f
C26 a_n57888_66178# a_n57248_65380# 0
C27 m2_n58100_65762# a_n57222_66163# 0
C28 a_n57880_65426# a_n57888_66178# 0
C29 a_n58100_65114# a_n57906_65396# 0
C30 a_n58100_65662# a_n57888_66178# 0
C31 a_n57906_65660# a_n57560_65603# 0.00102f
C32 a_n57914_65295# a_n57888_66178# 0.07885f
C33 a_n58100_65000# li_n58100_65000# 0
C34 a_n57906_65396# a_n57906_65660# 0.27393f
C35 a_n57906_65396# a_n58100_65950# 0
C36 a_n57906_65480# a_n57906_65660# 0.15009f
C37 a_n57888_66178# a_n57888_65236# 0.0968f
C38 a_n57222_66085# a_n57222_66163# 0.00959f
C39 a_n57222_65323# a_n57248_65380# 0.06164f
C40 a_n57906_65480# a_n58100_65950# 0
C41 a_n58100_65572# a_n58100_65371# 0.00243f
C42 m2_n58100_65762# a_n57888_66178# 0.33447f
C43 a_n57914_65295# a_n57222_65323# 0
C44 a_n57248_65380# li_n58100_65000# 0
C45 a_n57560_65603# w_n58136_64971# 0
C46 a_n58100_65303# a_n57248_65380# 0.01928f
C47 a_n57906_65396# w_n58136_64971# 0.24396f
C48 a_n57914_66148# a_n57906_65660# 0.02192f
C49 a_n57906_65480# w_n58136_64971# 0.31846f
C50 a_n57880_65606# a_n57906_65660# 0.00273f
C51 a_n58100_65662# a_n58100_65303# 0.00165f
C52 a_n57914_65295# a_n58100_65303# 0.0026f
C53 a_n57248_66133# w_n58136_64971# 0.00265f
C54 a_n58100_65007# a_n58100_65114# 0.0054f
C55 a_n58100_65303# a_n58100_65144# 0.02349f
C56 m1_n57023_66189# a_n57906_65396# 0
C57 a_n58100_65303# a_n57888_65236# 0.00187f
C58 m1_n57023_66189# a_n57906_65480# 0.00687f
C59 a_n57914_66148# w_n58136_64971# 0.12244f
C60 m2_n58100_65762# a_n58100_65303# 0.00633f
C61 a_n57880_65606# w_n58136_64971# 0.01297f
C62 m1_n57023_66189# a_n57248_66133# 0.00304f
C63 a_n58100_65114# a_n58100_65371# 0
C64 a_n57888_66178# a_n57222_65323# 0.00888f
C65 a_n57222_65678# a_n57906_65660# 0.06228f
C66 a_n57544_65423# w_n58136_64971# 0
C67 a_n58100_65572# a_n57906_65660# 0
C68 a_n57906_65396# a_n58100_65602# 0.00165f
C69 a_n57906_65480# a_n58100_65602# 0
C70 a_n58100_65662# a_n58100_65860# 0.00248f
C71 a_n57914_65295# a_n57518_66181# 0
C72 a_n57914_65295# a_n58100_65860# 0
C73 a_n57906_65396# a_n57560_65795# 0.00551f
C74 a_n58100_65007# w_n58136_64971# 0.02128f
C75 a_n57914_65295# a_n57880_65798# 0.01522f
C76 a_n57888_66178# a_n58100_65303# 0
C77 a_n57518_66181# a_n57888_65236# 0.00124f
C78 a_n57880_65798# a_n57888_65236# 0
C79 a_n57222_65678# w_n58136_64971# 0.00264f
C80 m2_n58100_65762# a_n58100_65860# 0
C81 a_n57518_66181# m2_n58100_65762# 0
C82 a_n58100_65572# w_n58136_64971# 0.02533f
C83 a_n58100_65371# w_n58136_64971# 0.03188f
C84 m2_n58100_65762# a_n57880_65798# 0.00194f
C85 a_n58100_65890# m2_n58100_65762# 0.00161f
C86 a_n57914_66148# a_n57560_65795# 0
C87 a_n58100_65303# a_n57222_65323# 0
C88 a_n57518_66181# a_n57888_66178# 0.0022f
C89 a_n58100_65303# li_n58100_65000# 0
C90 a_n57906_65396# a_n57248_65380# 0.29057f
C91 a_n57880_65798# a_n57888_66178# 0.00508f
C92 a_n57906_65480# a_n57248_65380# 0.24124f
C93 a_n57880_65426# a_n57906_65396# 0.0028f
C94 a_n57914_65295# a_n57560_65603# 0.00942f
C95 a_n57880_65426# a_n57906_65480# 0.00978f
C96 a_n58100_65662# a_n57906_65396# 0
C97 a_n58100_65572# a_n58100_65602# 0.00316f
C98 a_n57906_65396# a_n57914_65295# 0.19896f
C99 a_n57914_65295# a_n57906_65480# 0.21462f
C100 a_n57888_65236# a_n57560_65603# 0.00171f
C101 a_n58100_65114# w_n58136_64971# 0.0286f
C102 a_n57906_65396# a_n57888_65236# 0.311f
C103 a_n57906_65480# a_n58100_65144# 0
C104 a_n57906_65480# a_n57888_65236# 0.16992f
C105 a_n57906_65396# a_n57222_66163# 0.01259f
C106 a_n57914_66148# a_n57248_65380# 0
C107 a_n57906_65660# w_n58136_64971# 0.15771f
C108 a_n57906_65396# m2_n58100_65762# 0.12987f
C109 a_n57906_65480# a_n57222_66163# 0.04233f
C110 a_n58100_65950# w_n58136_64971# 0.03054f
C111 a_n57906_65480# m2_n58100_65762# 0.06654f
C112 a_n57248_66133# a_n57888_65236# 0
C113 a_n57248_65380# a_n57544_65423# 0.00132f
C114 a_n57222_66163# a_n57248_66133# 0.06167f
C115 a_n58100_65303# a_n58100_65860# 0.00166f
C116 a_n57914_66148# a_n57914_65295# 0.00594f
C117 a_n57880_65606# a_n57914_65295# 0.01538f
C118 a_n58100_65890# a_n58100_65303# 0.00756f
C119 a_n57914_65295# a_n57544_65423# 0.00875f
C120 a_n58100_65007# a_n57248_65380# 0
C121 a_n57888_66178# a_n57560_65603# 0
C122 a_n57906_65396# a_n57222_66085# 0.00291f
C123 a_n57914_66148# a_n57888_65236# 0.05335f
C124 a_n57906_65480# a_n57222_66085# 0.00188f
C125 a_n57906_65396# a_n57888_66178# 0.06121f
C126 a_n57914_66148# a_n57222_66163# 0
C127 a_n57906_65480# a_n57888_66178# 0.06427f
C128 a_n57888_65236# a_n57544_65423# 0.00285f
C129 a_n57914_66148# m2_n58100_65762# 0.00365f
C130 a_n57880_65606# m2_n58100_65762# 0.00142f
C131 a_n58100_65114# a_n58100_65602# 0
C132 a_n57222_65678# a_n57248_65380# 0.04148f
C133 a_n57888_66178# a_n57248_66133# 0
C134 a_n58100_65371# a_n57248_65380# 0.00175f
C135 a_n58100_65602# a_n57906_65660# 0
C136 a_n58100_65572# a_n58100_65662# 0.00693f
C137 m1_n57023_66189# w_n58136_64971# 0
C138 a_n58100_65572# a_n57914_65295# 0
C139 a_n57560_65795# a_n57906_65660# 0
C140 a_n57906_65396# a_n57222_65323# 0.00271f
C141 a_n57914_65295# a_n58100_65371# 0
C142 a_n57906_65480# a_n57222_65323# 0.06222f
C143 a_n58100_65890# a_n58100_65860# 0.00316f
C144 a_n57914_66148# a_n57888_66178# 0.10939f
C145 a_n57880_65606# a_n57888_66178# 0.00283f
C146 a_n57222_65678# a_n57222_66163# 0.00231f
C147 a_n58100_65371# a_n57888_65236# 0
C148 a_n57222_65678# m2_n58100_65762# 0.0055f
C149 a_n58100_65572# m2_n58100_65762# 0
C150 a_n58100_65602# w_n58136_64971# 0.07727f
C151 a_n57906_65396# a_n58100_65303# 0.0059f
C152 a_n57906_65480# a_n58100_65303# 0
C153 a_n57560_65795# w_n58136_64971# 0
C154 a_n57222_65678# a_n57222_66085# 0
C155 a_n58100_65114# a_n57248_65380# 0
C156 a_n57222_65678# a_n57888_66178# 0.0904f
C157 a_n57906_65660# a_n57248_65380# 0.13033f
C158 a_n57914_66148# a_n58100_65303# 0
C159 a_n58100_65662# a_n57906_65660# 0.0044f
C160 a_n58100_65114# a_n58100_65144# 0.00218f
C161 a_n57914_65295# a_n57906_65660# 0.33845f
C162 a_n57906_65396# a_n57518_66181# 0.00129f
C163 a_n57906_65480# a_n57518_66181# 0
C164 a_n57222_65678# a_n57222_65323# 0.13586f
C165 a_n58100_65007# li_n58100_65000# 0.00323f
C166 a_n58100_65114# m2_n58100_65762# 0
C167 a_n57906_65660# a_n57888_65236# 0.09591f
C168 a_n57222_65323# a_n58100_65371# 0
C169 a_n58100_65950# a_n57888_65236# 0
C170 a_n58100_65007# a_n58100_65303# 0
C171 a_n57248_65380# w_n58136_64971# 0.09768f
C172 a_n57880_65426# w_n58136_64971# 0.01679f
C173 m2_n58100_65762# a_n57906_65660# 0.01513f
C174 m2_n58100_65762# a_n58100_65950# 0
C175 a_n58100_65662# w_n58136_64971# 0.02599f
C176 a_n57914_65295# w_n58136_64971# 0.38297f
C177 a_n58100_65572# a_n58100_65303# 0.00172f
C178 a_n58100_65303# a_n58100_65371# 0.00502f
C179 w_n58136_64971# a_n58100_65144# 0.03649f
C180 a_n57888_65236# w_n58136_64971# 0.23775f
C181 a_n57222_66163# w_n58136_64971# 0.00501f
C182 a_n57888_66178# a_n57906_65660# 0.41095f
C183 m2_n58100_65762# w_n58136_64971# 0.17378f
C184 a_n57888_66178# a_n58100_65950# 0
C185 a_n57906_65396# a_n57560_65603# 0.00229f
C186 a_n57906_65396# a_n57906_65480# 0.22329f
C187 m1_n57023_66189# a_n57222_66163# 0.0024f
C188 a_n57222_66085# w_n58136_64971# 0.00205f
C189 a_n58100_65662# a_n58100_65602# 0.00254f
C190 a_n57222_65323# a_n57906_65660# 0.01825f
C191 a_n57888_66178# w_n58136_64971# 0.34073f
C192 a_n57906_65396# a_n57248_66133# 0.00437f
C193 a_n57906_65480# a_n57248_66133# 0.03827f
C194 a_n57914_65295# a_n57560_65795# 0.00893f
C195 a_n58100_65114# a_n58100_65303# 0.00145f
C196 a_n57914_66148# a_n57560_65603# 0
C197 a_n57560_65795# a_n57888_65236# 0.00194f
C198 m2_n58100_65762# a_n58100_65602# 0.00157f
C199 a_n58100_65303# a_n57906_65660# 0
C200 a_n57914_66148# a_n57906_65396# 0.00662f
C201 a_n57880_65606# a_n57906_65396# 0.00203f
C202 a_n58100_65303# a_n58100_65950# 0.00161f
C203 a_n57914_66148# a_n57906_65480# 0.00385f
C204 m2_n58100_65762# a_n57560_65795# 0
C205 a_n57222_65323# w_n58136_64971# 0
C206 a_n57906_65396# a_n57544_65423# 0.00269f
C207 a_n57914_66148# a_n57248_66133# 0.004f
C208 w_n58136_64971# li_n58100_65000# 0.03016f
C209 a_n57880_65426# a_n57248_65380# 0.00218f
C210 a_n57888_66178# a_n58100_65602# 0
C211 a_n58100_65303# w_n58136_64971# 0.49704f
C212 a_n57560_65795# a_n57888_66178# 0
C213 a_n58100_65114# a_n58100_65890# 0
C214 m5_n58100_65000# a_n57560_65681# 0 $ **FLOATING
C215 m4_n57132_65036# a_n57560_65681# 0 $ **FLOATING
C216 m4_n57308_65000# a_n57560_65681# 0 $ **FLOATING
C217 m4_n57484_65000# a_n57560_65681# 0 $ **FLOATING
C218 m4_n57660_65000# a_n57560_65681# 0 $ **FLOATING
C219 m4_n57836_65000# a_n57560_65681# 0 $ **FLOATING
C220 m4_n57132_65212# a_n57560_65681# 0 $ **FLOATING
C221 m4_n57308_65176# a_n57560_65681# 0 $ **FLOATING
C222 m4_n57484_65140# a_n57560_65681# 0 $ **FLOATING
C223 m4_n57660_65104# a_n57560_65681# 0 $ **FLOATING
C224 m4_n57836_65068# a_n57560_65681# 0 $ **FLOATING
C225 m4_n58012_65032# a_n57560_65681# 0 $ **FLOATING
C226 m4_n58100_65000# a_n57560_65681# 0 $ **FLOATING
C227 m4_n57132_65388# a_n57560_65681# 0 $ **FLOATING
C228 m4_n57308_65352# a_n57560_65681# 0 $ **FLOATING
C229 m4_n57484_65316# a_n57560_65681# 0 $ **FLOATING
C230 m4_n57660_65280# a_n57560_65681# 0 $ **FLOATING
C231 m4_n57836_65244# a_n57560_65681# 0 $ **FLOATING
C232 m4_n58012_65208# a_n57560_65681# 0 $ **FLOATING
C233 m4_n58100_65172# a_n57560_65681# 0 $ **FLOATING
C234 m4_n57132_65564# a_n57560_65681# 0 $ **FLOATING
C235 m4_n57308_65528# a_n57560_65681# 0 $ **FLOATING
C236 m4_n57484_65492# a_n57560_65681# 0 $ **FLOATING
C237 m4_n57660_65456# a_n57560_65681# 0 $ **FLOATING
C238 m4_n57836_65420# a_n57560_65681# 0 $ **FLOATING
C239 m4_n58012_65384# a_n57560_65681# 0 $ **FLOATING
C240 m4_n58100_65348# a_n57560_65681# 0 $ **FLOATING
C241 m4_n57836_65596# a_n57560_65681# 0 $ **FLOATING
C242 m4_n58012_65560# a_n57560_65681# 0 $ **FLOATING
C243 m4_n58100_65524# a_n57560_65681# 0 $ **FLOATING
C244 m3_n57238_65000# a_n57560_65681# 0 $ **FLOATING
C245 m3_n57414_65000# a_n57560_65681# 0 $ **FLOATING
C246 m3_n57238_65106# a_n57560_65681# 0 $ **FLOATING
C247 m3_n57414_65070# a_n57560_65681# 0 $ **FLOATING
C248 m3_n57590_65034# a_n57560_65681# 0 $ **FLOATING
C249 m3_n57766_65000# a_n57560_65681# 0 $ **FLOATING
C250 m3_n57942_65000# a_n57560_65681# 0 $ **FLOATING
C251 m3_n58100_65000# a_n57560_65681# 0 $ **FLOATING
C252 m3_n57238_65282# a_n57560_65681# 0 $ **FLOATING
C253 m3_n57414_65246# a_n57560_65681# 0 $ **FLOATING
C254 m3_n57590_65210# a_n57560_65681# 0 $ **FLOATING
C255 m3_n57766_65174# a_n57560_65681# 0 $ **FLOATING
C256 m3_n57942_65138# a_n57560_65681# 0 $ **FLOATING
C257 m3_n58100_65102# a_n57560_65681# 0 $ **FLOATING
C258 m3_n57238_65458# a_n57560_65681# 0 $ **FLOATING
C259 m3_n57414_65422# a_n57560_65681# 0 $ **FLOATING
C260 m3_n57590_65386# a_n57560_65681# 0 $ **FLOATING
C261 m3_n57766_65350# a_n57560_65681# 0 $ **FLOATING
C262 m3_n57942_65314# a_n57560_65681# 0 $ **FLOATING
C263 m3_n58100_65278# a_n57560_65681# 0 $ **FLOATING
C264 m3_n57238_65634# a_n57560_65681# 0 $ **FLOATING
C265 m3_n57414_65598# a_n57560_65681# 0 $ **FLOATING
C266 m3_n57590_65562# a_n57560_65681# 0 $ **FLOATING
C267 m3_n57766_65526# a_n57560_65681# 0 $ **FLOATING
C268 m3_n57942_65490# a_n57560_65681# 0 $ **FLOATING
C269 m3_n58100_65454# a_n57560_65681# 0 $ **FLOATING
C270 m3_n57414_65774# a_n57560_65681# 0 $ **FLOATING
C271 m3_n57590_65738# a_n57560_65681# 0 $ **FLOATING
C272 m3_n57766_65702# a_n57560_65681# 0 $ **FLOATING
C273 m3_n57414_65950# a_n57560_65681# 0 $ **FLOATING
C274 m3_n57590_65914# a_n57560_65681# 0 $ **FLOATING
C275 m3_n57766_65878# a_n57560_65681# 0 $ **FLOATING
C276 m3_n57414_66126# a_n57560_65681# 0 $ **FLOATING
C277 m3_n57590_66090# a_n57560_65681# 0 $ **FLOATING
C278 m3_n57766_66054# a_n57560_65681# 0 $ **FLOATING
C279 m2_n57200_65000# a_n57560_65681# 0 $ **FLOATING
C280 m2_n57300_65020# a_n57560_65681# 0 $ **FLOATING
C281 m2_n57400_65040# a_n57560_65681# 0 $ **FLOATING
C282 m2_n57700_65000# a_n57560_65681# 0 $ **FLOATING
C283 m2_n57500_65060# a_n57560_65681# 0 $ **FLOATING
C284 m2_n57928_65052# a_n57560_65681# 0 $ **FLOATING
C285 m2_n58084_65036# a_n57560_65681# 0 $ **FLOATING
C286 m2_n57800_65220# a_n57560_65681# 0 $ **FLOATING
C287 m2_n57900_65240# a_n57560_65681# 0 $ **FLOATING
C288 m2_n58100_65580# a_n57560_65681# 0 $ **FLOATING
C289 m2_n57900_65640# a_n57560_65681# 0 $ **FLOATING
C290 m2_n58100_65762# a_n57560_65681# 0.16042f
C291 m2_n57500_65860# a_n57560_65681# 0 $ **FLOATING
C292 m2_n57300_65920# a_n57560_65681# 0 $ **FLOATING
C293 m2_n57600_65880# a_n57560_65681# 0 $ **FLOATING
C294 m2_n57700_65900# a_n57560_65681# 0 $ **FLOATING
C295 m2_n57600_65980# a_n57560_65681# 0 $ **FLOATING
C296 m2_n57600_66080# a_n57560_65681# 0 $ **FLOATING
C297 m2_n57772_66004# a_n57560_65681# 0 $ **FLOATING
C298 m2_n57460_66192# a_n57560_65681# 0 $ **FLOATING
C299 m1_n57490_65000# a_n57560_65681# 0 $ **FLOATING
C300 m1_n57590_65000# a_n57560_65681# 0 $ **FLOATING
C301 m1_n57690_65000# a_n57560_65681# 0 $ **FLOATING
C302 m1_n57490_65050# a_n57560_65681# 0 $ **FLOATING
C303 m1_n57790_65010# a_n57560_65681# 0 $ **FLOATING
C304 m1_n57790_65110# a_n57560_65681# 0 $ **FLOATING
C305 m1_n57023_66189# a_n57560_65681# 0.0088f
C306 m1_n57790_65210# a_n57560_65681# 0 $ **FLOATING
C307 m1_n57790_65310# a_n57560_65681# 0 $ **FLOATING
C308 m1_n57790_65410# a_n57560_65681# 0 $ **FLOATING
C309 m1_n57790_65510# a_n57560_65681# 0 $ **FLOATING
C310 li_n57726_65000# a_n57560_65681# 0 $ **FLOATING
C311 li_n58100_65000# a_n57560_65681# 0.01322f
C312 a_n58100_65000# a_n57560_65681# 0 $ **FLOATING
C313 a_n58100_65007# a_n57560_65681# 0.0068f $ **FLOATING
C314 a_n58100_65114# a_n57560_65681# 0.00161f $ **FLOATING
C315 a_n58100_65144# a_n57560_65681# 0.00652f $ **FLOATING
C316 a_n57888_65236# a_n57560_65681# 0.309f $ **FLOATING
C317 a_n58100_65303# a_n57560_65681# 0.23712f $ **FLOATING
C318 a_n57248_65380# a_n57560_65681# 0.38189f $ **FLOATING
C319 a_n57222_65323# a_n57560_65681# 0.21271f $ **FLOATING
C320 a_n57222_65678# a_n57560_65681# 0.11319f $ **FLOATING
C321 a_n57544_65423# a_n57560_65681# 0.00549f $ **FLOATING
C322 a_n58100_65371# a_n57560_65681# 0.00123f $ **FLOATING
C323 a_n57880_65426# a_n57560_65681# 0 $ **FLOATING
C324 a_n57560_65603# a_n57560_65681# 0.00339f $ **FLOATING
C325 a_n58100_65572# a_n57560_65681# 0 $ **FLOATING
C326 a_n57880_65606# a_n57560_65681# 0 $ **FLOATING
C327 a_n58100_65602# a_n57560_65681# 0.01044f $ **FLOATING
C328 a_n58100_65662# a_n57560_65681# 0 $ **FLOATING
C329 a_n57560_65795# a_n57560_65681# 0.00208f $ **FLOATING
C330 a_n57906_65396# a_n57560_65681# 1.16062f $ **FLOATING
C331 a_n57880_65798# a_n57560_65681# 0 $ **FLOATING
C332 a_n57906_65660# a_n57560_65681# 0.33313f $ **FLOATING
C333 a_n58100_65860# a_n57560_65681# 0 $ **FLOATING
C334 a_n57914_65295# a_n57560_65681# 0.30041f $ **FLOATING
C335 a_n58100_65890# a_n57560_65681# 0.01044f $ **FLOATING
C336 a_n58100_65950# a_n57560_65681# 0.00319f $ **FLOATING
C337 a_n57906_65480# a_n57560_65681# 1.14614f $ **FLOATING
C338 a_n57222_66085# a_n57560_65681# 0.00893f $ **FLOATING
C339 a_n57248_66133# a_n57560_65681# 0.1128f $ **FLOATING
C340 a_n57222_66163# a_n57560_65681# 0.12376f $ **FLOATING
C341 a_n57914_66148# a_n57560_65681# 0.21943f $ **FLOATING
C342 a_n57518_66181# a_n57560_65681# 0.00416f $ **FLOATING
C343 a_n57888_66178# a_n57560_65681# 0.33092f $ **FLOATING
C344 w_n58136_64971# a_n57560_65681# 2.67195f $ **FLOATING
C345 a_n57560_65681# a_n57560_65681# 0 $ **FLOATING
.ends
