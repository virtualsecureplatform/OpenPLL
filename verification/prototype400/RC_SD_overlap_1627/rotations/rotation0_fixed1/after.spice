* NGSPICE file created from RotatedCrop.ext - technology: sky130A

.subckt RotatedCrop
X0 a_65606_57680# a_65471_57390# a_65284_57370.t5 w_64971_58015.t6 sky130_fd_pr__pfet_01v8 ad=0.135 pd=1.27 as=0.165 ps=1.33 w=1 l=0.15
X1 w_64971_58015.t12 a_65371_58010# a_65303_58036.t0 w_64971_58015.t11 sky130_fd_pr__pfet_01v8 ad=0.096 pd=1.24 as=0.1088 ps=1.32 w=0.32 l=0.15
X2 w_64971_58015.t14 a_65284_57370.t7 a_65227_57396.t0 w_64971_58015.t13 sky130_fd_pr__pfet_01v8 ad=0.1934 pd=1.475 as=0.3304 ps=2.83 w=1.12 l=0.15
X3 a_65323_57074.t0 a_65509_57000# a_65135_57360.t4 a_65135_57360.t3 sky130_fd_pr__nfet_01v8_lvt ad=0.1036 pd=1.02 as=0.3361 ps=1.68 w=0.74 l=0.15
X4 a_65890_58036# a_65860_58010# w_64971_58015.t22 w_64971_58015.t21 sky130_fd_pr__pfet_01v8 ad=0.048 pd=0.62 as=0.0912 ps=1.21 w=0.32 l=0.15
X5 a_65795_57432# a_65393_57318# a_65135_57360.t20 a_65135_57360.t19 sky130_fd_pr__nfet_01v8_lvt ad=0.0864 pd=0.91 as=0.1344 ps=1.06 w=0.64 l=0.15
X6 w_64971_58015.t16 a_65950_58010# a_65890_58036.t0 w_64971_58015.t15 sky130_fd_pr__pfet_01v8 ad=0.0912 pd=1.21 as=0.048 ps=0.62 w=0.32 l=0.15
X7 a_65135_57360.t15 a_65341_57000# a_65323_57074.t2 a_65135_57360.t14 sky130_fd_pr__nfet_01v8_lvt ad=0.3361 pd=1.68 as=0.2109 ps=2.05 w=0.74 l=0.15
X8 a_65135_57360.t12 a_65284_57370.t6 a_65227_57396.t1 a_65135_57360.t11 sky130_fd_pr__nfet_01v8_lvt ad=0.1389 pd=1.135 as=0.2081 ps=2.05 w=0.74 l=0.15
X9 a_65284_57370.t1 a_65509_57000# a_65798_57680.t0 w_64971_58015.t2 sky130_fd_pr__pfet_01v8 ad=0.295 pd=2.59 as=0.135 ps=1.27 w=1 l=0.15
X10 a_65640_57000.t0 a_66085_57540# w_64971_58015.t4 w_64971_58015.t3 sky130_fd_pr__pfet_01v8 ad=0.1232 pd=2.46 as=0.3192 ps=2.81 w=1.12 l=0.15
X11 a_65798_57680# a_65393_57318# w_64971_58015.t26 w_64971_58015.t25 sky130_fd_pr__pfet_01v8 ad=0.135 pd=1.27 as=0.195 ps=1.39 w=1 l=0.15
X12 a_65144_58051# a_65114_58025# w_64971_58015.t20 w_64971_58015.t19 sky130_fd_pr__pfet_01v8 ad=0.07227 pd=1.08 as=0.04715 ps=0.63 w=0.245 l=0.15
X13 a_65423_57416# a_65393_57318# a_65135_57360.t18 a_65135_57360.t17 sky130_fd_pr__nfet_01v8_lvt ad=0.0768 pd=0.88 as=0.1389 ps=1.135 w=0.64 l=0.15
X14 a_65284_57370.t2 a_65471_57390# a_65423_57416.t0 a_65135_57360.t7 sky130_fd_pr__nfet_01v8_lvt ad=0.1222 pd=1.08 as=0.0768 ps=0.88 w=0.64 l=0.15
X15 a_65284_57370.t0 a_65509_57000# a_65795_57432.t0 a_65135_57360.t2 sky130_fd_pr__nfet_01v8_lvt ad=0.1733 pd=1.85 as=0.0864 ps=0.91 w=0.64 l=0.15
X16 a_65602_58036# a_65572_58010# w_64971_58015.t10 w_64971_58015.t9 sky130_fd_pr__pfet_01v8 ad=0.048 pd=0.62 as=0.0912 ps=1.21 w=0.32 l=0.15
X17 a_65284_57370.t3 a_65471_57390# a_65426_57680.t0 w_64971_58015.t5 sky130_fd_pr__pfet_01v8 ad=0.165 pd=1.33 as=0.135 ps=1.27 w=1 l=0.15
X18 a_66181_57370.t0 a_66085_57540# a_65135_57360.t6 a_65135_57360.t5 sky130_fd_pr__nfet_01v8_lvt ad=0.0703 pd=1.67 as=0.2109 ps=2.05 w=0.74 l=0.15
X19 a_65678_57074.t0 a_65640_57000.t1 a_65323_57074.t1 a_65135_57360.t13 sky130_fd_pr__nfet_01v8_lvt ad=0.2627 pd=2.19 as=0.1036 ps=1.02 w=0.74 l=0.15
X20 a_65426_57680# a_65393_57318# w_64971_58015.t24 w_64971_58015.t23 sky130_fd_pr__pfet_01v8 ad=0.135 pd=1.27 as=0.1934 ps=1.475 w=1 l=0.15
X21 w_64971_58015.t18 a_65662_58010# a_65602_58036.t0 w_64971_58015.t17 sky130_fd_pr__pfet_01v8 ad=0.0912 pd=1.21 as=0.048 ps=0.62 w=0.32 l=0.15
X22 a_65135_57360.t1 a_65509_57000# a_65603_57432.t0 a_65135_57360.t0 sky130_fd_pr__nfet_01v8_lvt ad=0.1344 pd=1.06 as=0.0768 ps=0.88 w=0.64 l=0.15
X23 a_65603_57432# a_65471_57390# a_65284_57370.t4 a_65135_57360.t8 sky130_fd_pr__nfet_01v8_lvt ad=0.0768 pd=0.88 as=0.1222 ps=1.08 w=0.64 l=0.15
X24 a_66085_57074# a_65471_57390# a_65135_57360.t10 a_65135_57360.t9 sky130_fd_pr__nfet_01v8_lvt ad=0.0888 pd=0.98 as=0.2109 ps=2.05 w=0.74 l=0.15
X25 a_66163_57074.t0 a_66133_57000# a_66085_57074.t0 a_65135_57360.t16 sky130_fd_pr__nfet_01v8_lvt ad=0.1369 pd=1.85 as=0.0888 ps=0.98 w=0.74 l=0.15
X26 w_64971_58015.t8 a_65007_58025# a_65000_58051.t0 w_64971_58015.t7 sky130_fd_pr__pfet_01v8 ad=0.04715 pd=0.63 as=8.575m ps=0.56 w=0.245 l=0.15
X27 w_64971_58015.t1 a_65509_57000# a_65606_57680.t0 w_64971_58015.t0 sky130_fd_pr__pfet_01v8 ad=0.195 pd=1.39 as=0.135 ps=1.27 w=1 l=0.15
C0 a_65602_58036# a_65572_58010# 0.00316f
C1 a_65227_57396# w_64971_58015# 0.23739f
C2 a_65798_57680# w_64971_58015# 0.01489f
C3 a_65393_57318# a_65303_58036# 0.0059f
C4 a_66133_57000# a_65471_57390# 0.03827f
C5 a_66133_57000# a_66085_57540# 0.004f
C6 a_65950_58010# a_65227_57396# 0
C7 a_65323_57074# a_65640_57000# 0.00888f
C8 a_65284_57370# a_65795_57432# 0.00893f
C9 a_65890_58036# w_64971_58015# 0.08129f
C10 a_65227_57396# a_65798_57680# 0
C11 a_65284_57370# a_65471_57390# 0.21462f
C12 a_66181_57370# a_65393_57318# 0.00129f
C13 a_65284_57370# a_66085_57540# 0.00594f
C14 a_65678_57074# a_65341_57000# 0.04148f
C15 a_65114_58025# a_65371_58010# 0
C16 a_65950_58010# a_65890_58036# 0.00254f
C17 a_66085_57074# a_66163_57074# 0.00959f
C18 a_65572_58010# a_65371_58010# 0.00243f
C19 a_65603_57432# a_66085_57540# 0
C20 a_65662_58010# m2_65762_57000# 0
C21 a_65606_57680# a_65393_57318# 0.00203f
C22 a_65860_58010# a_65662_58010# 0.00248f
C23 a_65662_58010# a_65572_58010# 0.00693f
C24 a_66163_57074# a_66133_57000# 0.06167f
C25 a_65114_58025# a_65341_57000# 0
C26 a_65323_57074# a_65371_58010# 0
C27 a_65144_58051# a_65114_58025# 0.00218f
C28 a_65795_57432# a_65640_57000# 0
C29 a_65678_57074# a_65393_57318# 0.00399f
C30 li_65000_58047# a_65303_58036# 0
C31 w_64971_58015# a_65303_58036# 0.49704f
C32 li_65000_58047# a_65007_58025# 0.00323f
C33 w_64971_58015# a_65007_58025# 0.02128f
C34 a_65640_57000# a_65471_57390# 0.06427f
C35 a_65640_57000# a_66085_57540# 0.10939f
C36 a_65950_58010# a_65303_58036# 0.00161f
C37 a_65323_57074# a_65341_57000# 0.06164f
C38 a_65602_58036# a_65471_57390# 0
C39 a_65393_57318# m2_65762_57000# 0.12947f
C40 a_65114_58025# a_65393_57318# 0
C41 a_65227_57396# a_65303_58036# 0.00187f
C42 w_64971_58015# a_66181_57370# 0
C43 a_65572_58010# a_65393_57318# 0
C44 a_65284_57370# a_65509_57000# 0.33845f
C45 a_65426_57680# a_65284_57370# 0.00749f
C46 a_65509_57000# a_65603_57432# 0.00102f
C47 a_65890_58036# a_65303_58036# 0.00756f
C48 a_65606_57680# w_64971_58015# 0.01297f
C49 a_65471_57390# a_65371_58010# 0
C50 a_65227_57396# a_66181_57370# 0.00124f
C51 a_65323_57074# a_65393_57318# 0.00271f
C52 a_65678_57074# w_64971_58015# 0.00264f
C53 a_65471_57390# a_65341_57000# 0.24124f
C54 a_65426_57680# a_65640_57000# 0
C55 a_66085_57540# a_65341_57000# 0
C56 a_65509_57000# a_65640_57000# 0.41095f
C57 a_65284_57370# a_65603_57432# 0.00942f
C58 a_65144_58051# a_65471_57390# 0
C59 w_64971_58015# m2_65762_57000# 0.17386f
C60 a_65602_58036# a_65509_57000# 0
C61 w_64971_58015# a_65114_58025# 0.0286f
C62 a_65860_58010# w_64971_58015# 0.02766f
C63 a_65572_58010# w_64971_58015# 0.02533f
C64 a_66133_57000# a_65640_57000# 0
C65 a_65007_58025# a_65303_58036# 0
C66 a_65950_58010# m2_65762_57000# 0
C67 a_65860_58010# a_65950_58010# 0.00693f
C68 a_65795_57432# a_65393_57318# 0.00551f
C69 a_65227_57396# m2_65762_57000# 0.02291f
C70 a_65393_57318# a_65471_57390# 0.22328f
C71 a_65284_57370# a_65640_57000# 0.07885f
C72 a_66085_57540# a_65393_57318# 0.00667f
C73 a_65798_57680# m2_65762_57000# 0.00194f
C74 a_65323_57074# w_64971_58015# 0
C75 li_65000_58047# a_65000_58051# 0
C76 a_65603_57432# a_65640_57000# 0
C77 a_65890_58036# m2_65762_57000# 0.00161f
C78 a_65890_58036# a_65114_58025# 0
C79 a_65860_58010# a_65890_58036# 0.00316f
C80 a_65662_58010# a_65509_57000# 0.0044f
C81 a_65284_57370# a_65423_57416# 0.00875f
C82 a_65426_57680# a_65341_57000# 0.00218f
C83 a_65509_57000# a_65341_57000# 0.13033f
C84 a_66163_57074# a_65393_57318# 0.01259f
C85 a_65284_57370# a_65371_58010# 0
C86 w_64971_58015# a_65795_57432# 0
C87 a_65602_58036# a_65640_57000# 0
C88 a_65662_58010# a_65284_57370# 0
C89 m1_66189_57000# a_65471_57390# 0.00687f
C90 w_64971_58015# a_65471_57390# 0.31898f
C91 w_64971_58015# a_66085_57540# 0.12244f
C92 a_66085_57074# a_65393_57318# 0.00291f
C93 a_65303_58036# m2_65762_57000# 0.00633f
C94 a_65284_57370# a_65341_57000# 0.0107f
C95 a_65426_57680# a_65393_57318# 0.0028f
C96 a_65114_58025# a_65303_58036# 0.00145f
C97 a_65860_58010# a_65303_58036# 0.00166f
C98 a_65509_57000# a_65393_57318# 0.27393f
C99 a_65572_58010# a_65303_58036# 0.00172f
C100 a_65007_58025# a_65114_58025# 0.0054f
C101 a_65950_58010# a_65471_57390# 0
C102 a_65227_57396# a_65795_57432# 0.00194f
C103 a_65227_57396# a_65471_57390# 0.16992f
C104 a_66133_57000# a_65393_57318# 0.00437f
C105 a_65227_57396# a_66085_57540# 0.05335f
C106 a_66181_57370# m2_65762_57000# 0
C107 a_65323_57074# a_65303_58036# 0
C108 a_65284_57370# a_65393_57318# 0.20106f
C109 a_65662_58010# a_65640_57000# 0
C110 a_66163_57074# m1_66189_57000# 0.0024f
C111 a_66163_57074# w_64971_58015# 0.00501f
C112 a_65606_57680# m2_65762_57000# 0.00142f
C113 a_65640_57000# a_65341_57000# 0
C114 a_65603_57432# a_65393_57318# 0.00229f
C115 a_65662_58010# a_65602_58036# 0.00254f
C116 a_65678_57074# m2_65762_57000# 0.0055f
C117 a_66085_57074# w_64971_58015# 0.002f
C118 a_65426_57680# w_64971_58015# 0.01679f
C119 a_65509_57000# w_64971_58015# 0.15771f
C120 a_65423_57416# a_65341_57000# 0.00132f
C121 a_65640_57000# a_65393_57318# 0.0619f
C122 a_66133_57000# w_64971_58015# 0.00265f
C123 a_66133_57000# m1_66189_57000# 0.00304f
C124 a_65860_58010# m2_65762_57000# 0
C125 a_65114_58025# m2_65762_57000# 0
C126 a_65303_58036# a_65471_57390# 0
C127 a_66085_57540# a_65303_58036# 0
C128 a_65572_58010# m2_65762_57000# 0
C129 a_65426_57680# a_65227_57396# 0
C130 a_65341_57000# a_65371_58010# 0.00183f
C131 a_65227_57396# a_65509_57000# 0.09591f
C132 a_65678_57074# a_65323_57074# 0.13586f
C133 a_65509_57000# a_65798_57680# 0
C134 a_65602_58036# a_65393_57318# 0.00165f
C135 a_65284_57370# w_64971_58015# 0.38296f
C136 a_66133_57000# a_65227_57396# 0
C137 a_65423_57416# a_65393_57318# 0.00269f
C138 a_65890_58036# a_65509_57000# 0
C139 a_66181_57370# a_65471_57390# 0
C140 w_64971_58015# a_65603_57432# 0
C141 a_65144_58051# a_65341_57000# 0
C142 a_65284_57370# a_65227_57396# 0.18875f
C143 a_65393_57318# a_65371_58010# 0
C144 a_65284_57370# a_65798_57680# 0.01522f
C145 a_65227_57396# a_65603_57432# 0.00171f
C146 a_65662_58010# a_65393_57318# 0
C147 w_64971_58015# a_65640_57000# 0.34073f
C148 a_65678_57074# a_65471_57390# 0.0464f
C149 a_65393_57318# a_65341_57000# 0.29164f
C150 a_65950_58010# a_65640_57000# 0
C151 a_65602_58036# w_64971_58015# 0.07727f
C152 a_65509_57000# a_65303_58036# 0
C153 a_65795_57432# m2_65762_57000# 0
C154 a_65227_57396# a_65640_57000# 0.0968f
C155 a_65798_57680# a_65640_57000# 0.00508f
C156 m2_65762_57000# a_65471_57390# 0.06654f
C157 a_66085_57540# m2_65762_57000# 0.00367f
C158 w_64971_58015# a_65423_57416# 0
C159 a_65572_58010# a_65471_57390# 0.00418f
C160 w_64971_58015# a_65371_58010# 0.03188f
C161 a_65284_57370# a_65303_58036# 0.0026f
C162 a_65678_57074# a_66163_57074# 0.00231f
C163 a_65227_57396# a_65423_57416# 0.00285f
C164 a_65323_57074# a_65471_57390# 0.06222f
C165 a_65606_57680# a_65509_57000# 0.00273f
C166 a_65662_58010# w_64971_58015# 0.02599f
C167 a_65227_57396# a_65371_58010# 0
C168 li_65000_58047# a_65341_57000# 0
C169 w_64971_58015# a_65341_57000# 0.09766f
C170 a_66163_57074# m2_65762_57000# 0
C171 a_66085_57074# a_65678_57074# 0
C172 a_65284_57370# a_66181_57370# 0
C173 a_65678_57074# a_65509_57000# 0.06228f
C174 w_64971_58015# a_65144_58051# 0.03649f
C175 a_65640_57000# a_65303_58036# 0
C176 a_65606_57680# a_65284_57370# 0.01538f
C177 a_65227_57396# a_65341_57000# 0.03562f
C178 a_65509_57000# m2_65762_57000# 0.01513f
C179 a_65860_58010# a_65509_57000# 0.00374f
C180 a_65509_57000# a_65572_58010# 0
C181 a_65602_58036# a_65303_58036# 0.00765f
C182 w_64971_58015# a_65393_57318# 0.24503f
C183 m1_66189_57000# a_65393_57318# 0
C184 a_65795_57432# a_66085_57540# 0
C185 a_66085_57540# a_65471_57390# 0.00385f
C186 a_65640_57000# a_66181_57370# 0.0022f
C187 a_65950_58010# a_65393_57318# 0
C188 a_65509_57000# a_65323_57074# 0.01825f
C189 a_65227_57396# a_65393_57318# 0.31103f
C190 a_65284_57370# m2_65762_57000# 0.01819f
C191 a_65860_58010# a_65284_57370# 0
C192 a_65303_58036# a_65371_58010# 0.00502f
C193 a_65606_57680# a_65640_57000# 0.00283f
C194 a_65284_57370# a_65572_58010# 0
C195 a_65678_57074# a_65640_57000# 0.0904f
C196 a_65662_58010# a_65303_58036# 0.00165f
C197 a_66163_57074# a_65471_57390# 0.04233f
C198 a_66163_57074# a_66085_57540# 0
C199 a_65303_58036# a_65341_57000# 0.01928f
C200 a_65284_57370# a_65323_57074# 0
C201 a_65007_58025# a_65341_57000# 0
C202 a_65144_58051# a_65303_58036# 0.02349f
C203 li_65000_58047# w_64971_58015# 0.03016f
C204 w_64971_58015# m1_66189_57000# 0
C205 a_65640_57000# m2_65762_57000# 0.33447f
C206 a_65509_57000# a_65795_57432# 0
C207 a_65950_58010# w_64971_58015# 0.03054f
C208 a_66085_57074# a_65471_57390# 0.00188f
C209 a_65426_57680# a_65471_57390# 0.00978f
C210 a_65509_57000# a_65471_57390# 0.15009f
C211 a_65509_57000# a_66085_57540# 0.02192f
C212 a_65602_58036# m2_65762_57000# 0.00157f
C213 a_65602_58036# a_65114_58025# 0
R0 a_66163_57074.t0 a_66163_57074# 218.214
R1 a_66085_57074# a_66085_57074.t0 38.9194
R2 a_65678_57074.t0 a_65678_57074# 114.352
R3 a_65323_57074.t0 a_65323_57074.n0 22.7032
R4 a_65323_57074.n0 a_65323_57074.t1 22.7032
R5 a_65323_57074# a_65323_57074.n1 104.593
R6 a_65323_57074.n1 a_65323_57074.t2 40.3453
R7 a_65323_57074.n1 a_65323_57074.n0 365.82
R8 a_66181_57370# a_66181_57370.t0 467.368
R9 a_65795_57432# a_65795_57432.t0 50.6255
R10 a_65603_57432# a_65603_57432.t0 45.0005
R11 a_65423_57416# a_65423_57416.t0 45.0005
R12 a_65640_57000.t0 a_65640_57000.n0 436.425
R13 a_65640_57000.n0 a_65640_57000.t1 216.9
R14 a_65640_57000# a_65640_57000.n0 78.3255
R15 a_65798_57680# a_65798_57680.t0 53.1905
R16 a_65606_57680# a_65606_57680.t0 53.1905
R17 a_65426_57680# a_65426_57680.t0 53.1905
R18 a_65227_57396.n0 a_65227_57396.t0 414.214
R19 a_65227_57396# a_65227_57396.n0 26.3641
R20 a_65227_57396.n0 a_65227_57396.t1 22.998
R21 a_65284_57370.n5 a_65284_57370.n1 12.8005
R22 a_65284_57370.t0 a_65284_57370.n5 294.688
R23 a_65284_57370.n5 a_65284_57370.n4 51.9534
R24 a_65284_57370.n4 a_65284_57370.t1 340.596
R25 a_65284_57370.n4 a_65284_57370.n3 210.905
R26 a_65284_57370.n3 a_65284_57370.t3 35.4605
R27 a_65284_57370.n3 a_65284_57370.t5 29.5505
R28 a_65284_57370.n1 a_65284_57370.n2 98.8784
R29 a_65284_57370.n2 a_65284_57370.t2 26.2505
R30 a_65284_57370.n2 a_65284_57370.t4 43.7951
R31 a_65284_57370.n1 a_65284_57370.n0 223.374
R32 a_65284_57370.n0 a_65284_57370.t6 177.981
R33 a_65284_57370# a_65284_57370.t6 160.667
R34 a_65284_57370.n0 a_65284_57370.t7 250.548
R35 a_65890_58036# a_65890_58036.t0 184.689
R36 a_65602_58036# a_65602_58036.t0 184.689
R37 a_65303_58036# a_65303_58036.t0 209.312
R38 a_65000_58051# a_65000_58051.t0 675.429
R39 w_64971_58015.t8 w_64971_58015.n0 188.959
R40 w_64971_58015.n0 w_64971_58015.t20 120.612
R41 w_64971_58015.n32 w_64971_58015.n0 608.746
R42 w_64971_58015.n2 w_64971_58015.n1 9.3005
R43 w_64971_58015.n3 w_64971_58015.n36 9.3005
R44 w_64971_58015.n4 w_64971_58015.n38 9.3005
R45 w_64971_58015.n5 w_64971_58015.n39 9.3005
R46 w_64971_58015.n7 w_64971_58015.n6 9.3005
R47 w_64971_58015.n8 w_64971_58015.n40 9.3005
R48 w_64971_58015.n9 w_64971_58015.n42 9.3005
R49 w_64971_58015.n11 w_64971_58015.n10 9.3005
R50 w_64971_58015.n11 w_64971_58015.n12 4.5005
R51 w_64971_58015.n13 w_64971_58015.n14 4.5005
R52 w_64971_58015.n15 w_64971_58015.n16 4.5005
R53 w_64971_58015.n17 w_64971_58015.n18 4.5005
R54 w_64971_58015.n20 w_64971_58015.n21 4.5005
R55 w_64971_58015.n31 w_64971_58015.n43 9.3005
R56 w_64971_58015.n44 w_64971_58015.n45 6.82729
R57 w_64971_58015.n32 w_64971_58015.n2 4.37628
R58 w_64971_58015.n2 w_64971_58015.n3 0.122949
R59 w_64971_58015.n3 w_64971_58015.n4 0.122949
R60 w_64971_58015.n4 w_64971_58015.n5 0.122949
R61 w_64971_58015.n5 w_64971_58015.n7 0.122949
R62 w_64971_58015.n7 w_64971_58015.n8 0.122949
R63 w_64971_58015.n8 w_64971_58015.n9 0.122949
R64 w_64971_58015.n9 w_64971_58015.n20 0.0413163
R65 w_64971_58015.n20 w_64971_58015.n11 0.0821327
R66 w_64971_58015.n11 w_64971_58015.n13 0.0821327
R67 w_64971_58015.n13 w_64971_58015.n31 0.0413163
R68 w_64971_58015.n31 w_64971_58015.n15 0.0413163
R69 w_64971_58015.n15 w_64971_58015.n17 0.0821327
R70 w_64971_58015.n17 w_64971_58015.n44 0.0225246
R71 w_64971_58015.n44 w_64971_58015.n19 4.56092
R72 w_64971_58015.n45 w_64971_58015.t4 250.081
R73 w_64971_58015.n43 w_64971_58015.n45 15.8123
R74 w_64971_58015.n43 w_64971_58015.t16 698.289
R75 w_64971_58015.n42 w_64971_58015.n10 27.4829
R76 w_64971_58015.n10 w_64971_58015.n43 21.4593
R77 w_64971_58015.n42 w_64971_58015.t22 703.712
R78 w_64971_58015.n40 w_64971_58015.n42 10.9181
R79 w_64971_58015.n40 w_64971_58015.n41 313.168
R80 w_64971_58015.n40 w_64971_58015.t18 697.679
R81 w_64971_58015.n41 w_64971_58015.t1 37.4305
R82 w_64971_58015.n41 w_64971_58015.t26 39.4005
R83 w_64971_58015.n39 w_64971_58015.n6 27.4829
R84 w_64971_58015.n6 w_64971_58015.n40 20.7064
R85 w_64971_58015.n39 w_64971_58015.t10 703.712
R86 w_64971_58015.n38 w_64971_58015.n39 16.5652
R87 w_64971_58015.n38 w_64971_58015.t12 700.399
R88 w_64971_58015.n36 w_64971_58015.n38 0.376971
R89 w_64971_58015.n36 w_64971_58015.n37 223.704
R90 w_64971_58015.n37 w_64971_58015.t14 36.6566
R91 w_64971_58015.n37 w_64971_58015.t24 30.5355
R92 w_64971_58015.n33 w_64971_58015.n1 24.8476
R93 w_64971_58015.n1 w_64971_58015.n36 31.624
R94 w_64971_58015.n34 w_64971_58015.n33 211.838
R95 w_64971_58015.n35 w_64971_58015.t7 0.414049
R96 w_64971_58015.n35 w_64971_58015.t19 214.685
R97 w_64971_58015.t19 w_64971_58015.n34 46.2929
R98 w_64971_58015.n34 w_64971_58015.t13 318.009
R99 w_64971_58015.t13 w_64971_58015.t11 152.966
R100 w_64971_58015.t11 w_64971_58015.t23 50.3183
R101 w_64971_58015.t23 w_64971_58015.t5 169.069
R102 w_64971_58015.t5 w_64971_58015.t9 185.169
R103 w_64971_58015.t9 w_64971_58015.t6 8.05135
R104 w_64971_58015.t6 w_64971_58015.t0 169.069
R105 w_64971_58015.t0 w_64971_58015.t17 4.02592
R106 w_64971_58015.t17 w_64971_58015.t25 213.347
R107 w_64971_58015.t25 w_64971_58015.t2 169.069
R108 w_64971_58015.t2 w_64971_58015.t21 16.1022
R109 w_64971_58015.t21 w_64971_58015.t15 181.144
R110 w_64971_58015.t15 w_64971_58015.t3 398.517
R111 w_64971_58015# w_64971_58015.n35 1419.08
R112 w_64971_58015.n33 w_64971_58015.n32 0.850602
R113 w_64971_58015.n22 w_64971_58015.n23 3.4105
R114 w_64971_58015.n24 w_64971_58015.n25 3.4105
R115 w_64971_58015.n26 w_64971_58015.n27 3.4105
R116 w_64971_58015.n21 w_64971_58015.n12 0.108608
R117 w_64971_58015.n12 w_64971_58015.n22 0.027527
R118 w_64971_58015.n22 w_64971_58015.n14 0.0815811
R119 w_64971_58015.n14 w_64971_58015.n24 0.0545541
R120 w_64971_58015.n24 w_64971_58015.n16 0.0545541
R121 w_64971_58015.n16 w_64971_58015.n26 0.0815811
R122 w_64971_58015.n26 w_64971_58015.n18 0.027527
R123 w_64971_58015.n18 w_64971_58015.n19 0.108608
R124 w_64971_58015.n28 w_64971_58015.n23 0.0292348
R125 w_64971_58015.n25 w_64971_58015.n29 3.4105
R126 w_64971_58015.n27 w_64971_58015.n30 0.0292348
R127 w_64971_58015.n21 w_64971_58015.n28 3.43926
R128 w_64971_58015.n23 w_64971_58015.n25 0.0574697
R129 w_64971_58015.n25 w_64971_58015.n27 0.0574697
R130 w_64971_58015.n30 w_64971_58015.n19 3.43926
R131 w_64971_58015.n28 w_64971_58015.n29 1.69615
R132 w_64971_58015.n29 w_64971_58015.n30 1.69615
R133 a_65135_57360.t1 a_65135_57360.n0 39.3755
R134 a_65135_57360.n0 a_65135_57360.t20 39.3755
R135 a_65135_57360.n21 a_65135_57360.n0 251.26
R136 a_65135_57360.n2 a_65135_57360.n1 9.3005
R137 a_65135_57360.n4 a_65135_57360.n3 9.3005
R138 a_65135_57360.n6 a_65135_57360.n5 9.3005
R139 a_65135_57360.n8 a_65135_57360.n7 9.3005
R140 a_65135_57360.n1 a_65135_57360.n21 17.3181
R141 a_65135_57360.n21 a_65135_57360.n3 18.824
R142 a_65135_57360.n3 a_65135_57360.n5 36.1417
R143 a_65135_57360.n5 a_65135_57360.n7 36.1417
R144 a_65135_57360.n7 a_65135_57360.n9 27.8593
R145 a_65135_57360.n15 a_65135_57360.n9 3.83075
R146 a_65135_57360.n10 a_65135_57360.n18 7.00366
R147 a_65135_57360.n12 a_65135_57360.n11 9.3005
R148 a_65135_57360.n14 a_65135_57360.n13 9.3005
R149 a_65135_57360.n10 a_65135_57360.n12 0.493603
R150 a_65135_57360.n12 a_65135_57360.n14 0.122949
R151 a_65135_57360.n14 a_65135_57360.n2 0.122949
R152 a_65135_57360.n2 a_65135_57360.n4 0.122949
R153 a_65135_57360.n4 a_65135_57360.n6 0.122949
R154 a_65135_57360.n6 a_65135_57360.n8 0.122949
R155 a_65135_57360# a_65135_57360.n20 302.779
R156 a_65135_57360.n20 a_65135_57360.t11 1305.69
R157 a_65135_57360.t11 a_65135_57360.t14 661.034
R158 a_65135_57360.t14 a_65135_57360.t17 89.5154
R159 a_65135_57360.t17 a_65135_57360.t7 537.09
R160 a_65135_57360.t7 a_65135_57360.t3 626.605
R161 a_65135_57360.t3 a_65135_57360.t8 75.7439
R162 a_65135_57360.t8 a_65135_57360.t13 516.433
R163 a_65135_57360.t13 a_65135_57360.t0 20.6578
R164 a_65135_57360.t0 a_65135_57360.t19 784.977
R165 a_65135_57360.t19 a_65135_57360.t2 578.404
R166 a_65135_57360.t2 a_65135_57360.t9 1418.47
R167 a_65135_57360.t9 a_65135_57360.t16 537.09
R168 a_65135_57360.t16 a_65135_57360.t5 123.945
R169 a_65135_57360.n20 a_65135_57360.n10 324.079
R170 a_65135_57360.n18 a_65135_57360.n19 211.284
R171 a_65135_57360.n19 a_65135_57360.t12 39.9583
R172 a_65135_57360.n19 a_65135_57360.t18 30.938
R173 a_65135_57360.n18 a_65135_57360.n11 9.66968
R174 a_65135_57360.n11 a_65135_57360.n16 4.98327
R175 a_65135_57360.n16 a_65135_57360.n13 5.42088
R176 a_65135_57360.n13 a_65135_57360.n1 31.0674
R177 a_65135_57360.n16 a_65135_57360.n17 150.556
R178 a_65135_57360.n17 a_65135_57360.t15 61.6221
R179 a_65135_57360.n17 a_65135_57360.t4 61.6221
R180 a_65135_57360.n8 a_65135_57360.n15 2.44013
R181 a_65135_57360.n15 a_65135_57360.t6 162.424
R182 a_65135_57360.n9 a_65135_57360.t10 159.611
C214 m5_65000_57184# a_65135_57360# 0 $ **FLOATING
C215 m4_65564_57016# a_65135_57360# 0 $ **FLOATING
C216 m4_65388_57016# a_65135_57360# 0 $ **FLOATING
C217 m4_65212_57016# a_65135_57360# 0 $ **FLOATING
C218 m4_65036_57016# a_65135_57360# 0 $ **FLOATING
C219 m4_65528_57192# a_65135_57360# 0 $ **FLOATING
C220 m4_65352_57192# a_65135_57360# 0 $ **FLOATING
C221 m4_65176_57192# a_65135_57360# 0 $ **FLOATING
C222 m4_65000_57192# a_65135_57360# 0 $ **FLOATING
C223 m4_65492_57368# a_65135_57360# 0 $ **FLOATING
C224 m4_65316_57368# a_65135_57360# 0 $ **FLOATING
C225 m4_65140_57368# a_65135_57360# 0 $ **FLOATING
C226 m4_65000_57368# a_65135_57360# 0 $ **FLOATING
C227 m4_65456_57544# a_65135_57360# 0 $ **FLOATING
C228 m4_65280_57544# a_65135_57360# 0 $ **FLOATING
C229 m4_65104_57544# a_65135_57360# 0 $ **FLOATING
C230 m4_65000_57544# a_65135_57360# 0 $ **FLOATING
C231 m4_65596_57720# a_65135_57360# 0 $ **FLOATING
C232 m4_65420_57720# a_65135_57360# 0 $ **FLOATING
C233 m4_65244_57720# a_65135_57360# 0 $ **FLOATING
C234 m4_65068_57720# a_65135_57360# 0 $ **FLOATING
C235 m4_65000_57720# a_65135_57360# 0 $ **FLOATING
C236 m4_65560_57896# a_65135_57360# 0 $ **FLOATING
C237 m4_65384_57896# a_65135_57360# 0 $ **FLOATING
C238 m4_65208_57896# a_65135_57360# 0 $ **FLOATING
C239 m4_65032_57896# a_65135_57360# 0 $ **FLOATING
C240 m4_65524_58072# a_65135_57360# 0 $ **FLOATING
C241 m4_65348_58072# a_65135_57360# 0 $ **FLOATING
C242 m4_65172_58072# a_65135_57360# 0 $ **FLOATING
C243 m4_65000_58072# a_65135_57360# 0 $ **FLOATING
C244 m3_65634_57122# a_65135_57360# 0 $ **FLOATING
C245 m3_65458_57122# a_65135_57360# 0 $ **FLOATING
C246 m3_65282_57122# a_65135_57360# 0 $ **FLOATING
C247 m3_65106_57122# a_65135_57360# 0 $ **FLOATING
C248 m3_65000_57122# a_65135_57360# 0 $ **FLOATING
C249 m3_66126_57298# a_65135_57360# 0 $ **FLOATING
C250 m3_65950_57298# a_65135_57360# 0 $ **FLOATING
C251 m3_65774_57298# a_65135_57360# 0 $ **FLOATING
C252 m3_65598_57298# a_65135_57360# 0 $ **FLOATING
C253 m3_65422_57298# a_65135_57360# 0 $ **FLOATING
C254 m3_65246_57298# a_65135_57360# 0 $ **FLOATING
C255 m3_65070_57298# a_65135_57360# 0 $ **FLOATING
C256 m3_65000_57298# a_65135_57360# 0 $ **FLOATING
C257 m3_66090_57474# a_65135_57360# 0 $ **FLOATING
C258 m3_65914_57474# a_65135_57360# 0 $ **FLOATING
C259 m3_65738_57474# a_65135_57360# 0 $ **FLOATING
C260 m3_65562_57474# a_65135_57360# 0 $ **FLOATING
C261 m3_65386_57474# a_65135_57360# 0 $ **FLOATING
C262 m3_65210_57474# a_65135_57360# 0 $ **FLOATING
C263 m3_65034_57474# a_65135_57360# 0 $ **FLOATING
C264 m3_66054_57650# a_65135_57360# 0 $ **FLOATING
C265 m3_65878_57650# a_65135_57360# 0 $ **FLOATING
C266 m3_65702_57650# a_65135_57360# 0 $ **FLOATING
C267 m3_65526_57650# a_65135_57360# 0 $ **FLOATING
C268 m3_65350_57650# a_65135_57360# 0 $ **FLOATING
C269 m3_65174_57650# a_65135_57360# 0 $ **FLOATING
C270 m3_65000_57650# a_65135_57360# 0 $ **FLOATING
C271 m3_65490_57826# a_65135_57360# 0 $ **FLOATING
C272 m3_65314_57826# a_65135_57360# 0 $ **FLOATING
C273 m3_65138_57826# a_65135_57360# 0 $ **FLOATING
C274 m3_65000_57826# a_65135_57360# 0 $ **FLOATING
C275 m3_65454_58002# a_65135_57360# 0 $ **FLOATING
C276 m3_65278_58002# a_65135_57360# 0 $ **FLOATING
C277 m3_65102_58002# a_65135_57360# 0 $ **FLOATING
C278 m3_65000_58002# a_65135_57360# 0 $ **FLOATING
C279 m2_66192_57344# a_65135_57360# 0 $ **FLOATING
C280 m2_65920_57240# a_65135_57360# 0 $ **FLOATING
C281 m2_65860_57440# a_65135_57360# 0 $ **FLOATING
C282 m2_66080_57540# a_65135_57360# 0 $ **FLOATING
C283 m2_65980_57540# a_65135_57360# 0 $ **FLOATING
C284 m2_65880_57540# a_65135_57360# 0 $ **FLOATING
C285 m2_66004_57656# a_65135_57360# 0 $ **FLOATING
C286 m2_65900_57640# a_65135_57360# 0 $ **FLOATING
C287 m2_65762_57000# a_65135_57360# 0.16111f
C288 m2_65640_57840# a_65135_57360# 0 $ **FLOATING
C289 m2_65580_58040# a_65135_57360# 0 $ **FLOATING
C290 m2_65000_57140# a_65135_57360# 0 $ **FLOATING
C291 m2_65020_57240# a_65135_57360# 0 $ **FLOATING
C292 m2_65040_57340# a_65135_57360# 0 $ **FLOATING
C293 m2_65060_57440# a_65135_57360# 0 $ **FLOATING
C294 m2_65000_57640# a_65135_57360# 0 $ **FLOATING
C295 m2_65220_57740# a_65135_57360# 0 $ **FLOATING
C296 m2_65240_57840# a_65135_57360# 0 $ **FLOATING
C297 m2_65052_57812# a_65135_57360# 0 $ **FLOATING
C298 m2_65036_57968# a_65135_57360# 0 $ **FLOATING
C299 m1_66189_57000# a_65135_57360# 0.0088f
C300 m1_65050_57430# a_65135_57360# 0 $ **FLOATING
C301 m1_65000_57430# a_65135_57360# 0 $ **FLOATING
C302 m1_65000_57530# a_65135_57360# 0 $ **FLOATING
C303 m1_65000_57630# a_65135_57360# 0 $ **FLOATING
C304 m1_65510_57730# a_65135_57360# 0 $ **FLOATING
C305 m1_65410_57730# a_65135_57360# 0 $ **FLOATING
C306 m1_65310_57730# a_65135_57360# 0 $ **FLOATING
C307 m1_65210_57730# a_65135_57360# 0 $ **FLOATING
C308 m1_65110_57730# a_65135_57360# 0 $ **FLOATING
C309 m1_65010_57730# a_65135_57360# 0 $ **FLOATING
C310 li_65000_57610# a_65135_57360# 0 $ **FLOATING
C311 li_65000_58047# a_65135_57360# 0.01322f
C312 a_66163_57074# a_65135_57360# 0.12376f $ **FLOATING
C313 a_66085_57074# a_65135_57360# 0.00893f $ **FLOATING
C314 a_65678_57074# a_65135_57360# 0.11319f $ **FLOATING
C315 a_66133_57000# a_65135_57360# 0.1128f $ **FLOATING
C316 a_65323_57074# a_65135_57360# 0.21271f $ **FLOATING
C317 a_65341_57000# a_65135_57360# 0.38176f $ **FLOATING
C318 a_66181_57370# a_65135_57360# 0.00416f $ **FLOATING
C319 a_65795_57432# a_65135_57360# 0.00208f $ **FLOATING
C320 a_65603_57432# a_65135_57360# 0.00339f $ **FLOATING
C321 a_65423_57416# a_65135_57360# 0.00549f $ **FLOATING
C322 a_65640_57000# a_65135_57360# 0.33092f $ **FLOATING
C323 a_65798_57680# a_65135_57360# 0 $ **FLOATING
C324 a_65606_57680# a_65135_57360# 0 $ **FLOATING
C325 a_65426_57680# a_65135_57360# 0 $ **FLOATING
C326 a_66085_57540# a_65135_57360# 0.21943f $ **FLOATING
C327 a_65509_57000# a_65135_57360# 0.33313f $ **FLOATING
C328 a_65471_57390# a_65135_57360# 1.1461f $ **FLOATING
C329 a_65393_57318# a_65135_57360# 1.15715f $ **FLOATING
C330 a_65227_57396# a_65135_57360# 0.309f $ **FLOATING
C331 a_65284_57370# a_65135_57360# 0.30041f $ **FLOATING
C332 a_65950_58010# a_65135_57360# 0.00319f $ **FLOATING
C333 a_65890_58036# a_65135_57360# 0.01044f $ **FLOATING
C334 a_65860_58010# a_65135_57360# 0 $ **FLOATING
C335 a_65662_58010# a_65135_57360# 0 $ **FLOATING
C336 a_65602_58036# a_65135_57360# 0.01044f $ **FLOATING
C337 a_65572_58010# a_65135_57360# 0 $ **FLOATING
C338 a_65371_58010# a_65135_57360# 0.00123f $ **FLOATING
C339 a_65303_58036# a_65135_57360# 0.23712f $ **FLOATING
C340 a_65144_58051# a_65135_57360# 0.00652f $ **FLOATING
C341 a_65114_58025# a_65135_57360# 0.00161f $ **FLOATING
C342 a_65007_58025# a_65135_57360# 0.0068f $ **FLOATING
C343 a_65000_58051# a_65135_57360# 0 $ **FLOATING
C344 w_64971_58015# a_65135_57360# 2.67126f $ **FLOATING
C345 a_65135_57360# a_65135_57360# 0 $ **FLOATING
C346 a_65135_57360.t1 a_65135_57360# 0 $ **FLOATING
C347 a_65135_57360.n0 a_65135_57360# 0 $ **FLOATING
C348 a_65135_57360.n1 a_65135_57360# 0 $ **FLOATING
C349 a_65135_57360.n2 a_65135_57360# 0 $ **FLOATING
C350 a_65135_57360.n3 a_65135_57360# 0 $ **FLOATING
C351 a_65135_57360.n4 a_65135_57360# 0 $ **FLOATING
C352 a_65135_57360.n5 a_65135_57360# 0 $ **FLOATING
C353 a_65135_57360.n6 a_65135_57360# 0 $ **FLOATING
C354 a_65135_57360.n7 a_65135_57360# 0 $ **FLOATING
C355 a_65135_57360.n8 a_65135_57360# 0 $ **FLOATING
C356 a_65135_57360.n9 a_65135_57360# 0 $ **FLOATING
C357 a_65135_57360.t10 a_65135_57360# 0 $ **FLOATING
C358 a_65135_57360.n10 a_65135_57360# 0 $ **FLOATING
C359 a_65135_57360.n11 a_65135_57360# 0 $ **FLOATING
C360 a_65135_57360.n12 a_65135_57360# 0 $ **FLOATING
C361 a_65135_57360.n13 a_65135_57360# 0 $ **FLOATING
C362 a_65135_57360.n14 a_65135_57360# 0 $ **FLOATING
C363 a_65135_57360.n15 a_65135_57360# 0 $ **FLOATING
C364 a_65135_57360.t6 a_65135_57360# 0 $ **FLOATING
C365 a_65135_57360.n16 a_65135_57360# 0 $ **FLOATING
C366 a_65135_57360.t15 a_65135_57360# 0 $ **FLOATING
C367 a_65135_57360.t4 a_65135_57360# 0 $ **FLOATING
C368 a_65135_57360.n17 a_65135_57360# 0 $ **FLOATING
C369 a_65135_57360.n18 a_65135_57360# 0 $ **FLOATING
C370 a_65135_57360.t12 a_65135_57360# 0 $ **FLOATING
C371 a_65135_57360.t18 a_65135_57360# 0 $ **FLOATING
C372 a_65135_57360.n19 a_65135_57360# 0 $ **FLOATING
C373 a_65135_57360.n20 a_65135_57360# 0 $ **FLOATING
C374 a_65135_57360.t11 a_65135_57360# 0 $ **FLOATING
C375 a_65135_57360.t17 a_65135_57360# 0 $ **FLOATING
C376 a_65135_57360.t7 a_65135_57360# 0 $ **FLOATING
C377 a_65135_57360.t8 a_65135_57360# 0 $ **FLOATING
C378 a_65135_57360.t0 a_65135_57360# 0 $ **FLOATING
C379 a_65135_57360.t19 a_65135_57360# 0 $ **FLOATING
C380 a_65135_57360.t2 a_65135_57360# 0 $ **FLOATING
C381 a_65135_57360.t5 a_65135_57360# 0 $ **FLOATING
C382 a_65135_57360.t14 a_65135_57360# 0 $ **FLOATING
C383 a_65135_57360.t3 a_65135_57360# 0 $ **FLOATING
C384 a_65135_57360.t13 a_65135_57360# 0 $ **FLOATING
C385 a_65135_57360.t9 a_65135_57360# 0 $ **FLOATING
C386 a_65135_57360.t16 a_65135_57360# 0 $ **FLOATING
C387 a_65135_57360.n21 a_65135_57360# 0 $ **FLOATING
C388 a_65135_57360.t20 a_65135_57360# 0 $ **FLOATING
C389 w_64971_58015.t8 a_65135_57360# 0 $ **FLOATING
C390 w_64971_58015.n0 a_65135_57360# 0 $ **FLOATING
C391 w_64971_58015.n1 a_65135_57360# 0 $ **FLOATING
C392 w_64971_58015.n2 a_65135_57360# 0 $ **FLOATING
C393 w_64971_58015.n3 a_65135_57360# 0 $ **FLOATING
C394 w_64971_58015.n4 a_65135_57360# 0 $ **FLOATING
C395 w_64971_58015.n5 a_65135_57360# 0 $ **FLOATING
C396 w_64971_58015.n6 a_65135_57360# 0 $ **FLOATING
C397 w_64971_58015.n7 a_65135_57360# 0 $ **FLOATING
C398 w_64971_58015.n8 a_65135_57360# 0 $ **FLOATING
C399 w_64971_58015.n9 a_65135_57360# 0 $ **FLOATING
C400 w_64971_58015.n10 a_65135_57360# 0 $ **FLOATING
C401 w_64971_58015.n11 a_65135_57360# 0 $ **FLOATING
C402 w_64971_58015.n12 a_65135_57360# 0 $ **FLOATING
C403 w_64971_58015.n13 a_65135_57360# 0 $ **FLOATING
C404 w_64971_58015.n14 a_65135_57360# 0 $ **FLOATING
C405 w_64971_58015.n15 a_65135_57360# 0 $ **FLOATING
C406 w_64971_58015.n16 a_65135_57360# 0 $ **FLOATING
C407 w_64971_58015.n17 a_65135_57360# 0 $ **FLOATING
C408 w_64971_58015.n18 a_65135_57360# 0 $ **FLOATING
C409 w_64971_58015.n19 a_65135_57360# 0 $ **FLOATING
C410 w_64971_58015.n20 a_65135_57360# 0 $ **FLOATING
C411 w_64971_58015.n21 a_65135_57360# 0 $ **FLOATING
C412 w_64971_58015.n22 a_65135_57360# 0 $ **FLOATING
C413 w_64971_58015.n23 a_65135_57360# 0 $ **FLOATING
C414 w_64971_58015.n24 a_65135_57360# 0 $ **FLOATING
C415 w_64971_58015.n25 a_65135_57360# 0 $ **FLOATING
C416 w_64971_58015.n26 a_65135_57360# 0 $ **FLOATING
C417 w_64971_58015.n27 a_65135_57360# 0 $ **FLOATING
C418 w_64971_58015.n28 a_65135_57360# 0 $ **FLOATING
C419 w_64971_58015.n29 a_65135_57360# 0 $ **FLOATING
C420 w_64971_58015.n30 a_65135_57360# 0 $ **FLOATING
C421 w_64971_58015.n31 a_65135_57360# 0 $ **FLOATING
C422 w_64971_58015.n32 a_65135_57360# 0 $ **FLOATING
C423 w_64971_58015.n33 a_65135_57360# 0 $ **FLOATING
C424 w_64971_58015.n34 a_65135_57360# 0 $ **FLOATING
C425 w_64971_58015.n35 a_65135_57360# 0 $ **FLOATING
C426 w_64971_58015.t11 a_65135_57360# 0 $ **FLOATING
C427 w_64971_58015.t19 a_65135_57360# 0 $ **FLOATING
C428 w_64971_58015.t7 a_65135_57360# 0 $ **FLOATING
C429 w_64971_58015.t9 a_65135_57360# 0 $ **FLOATING
C430 w_64971_58015.t17 a_65135_57360# 0 $ **FLOATING
C431 w_64971_58015.t21 a_65135_57360# 0 $ **FLOATING
C432 w_64971_58015.t15 a_65135_57360# 0 $ **FLOATING
C433 w_64971_58015.t13 a_65135_57360# 0 $ **FLOATING
C434 w_64971_58015.t23 a_65135_57360# 0 $ **FLOATING
C435 w_64971_58015.t5 a_65135_57360# 0 $ **FLOATING
C436 w_64971_58015.t6 a_65135_57360# 0 $ **FLOATING
C437 w_64971_58015.t0 a_65135_57360# 0 $ **FLOATING
C438 w_64971_58015.t25 a_65135_57360# 0 $ **FLOATING
C439 w_64971_58015.t2 a_65135_57360# 0 $ **FLOATING
C440 w_64971_58015.t3 a_65135_57360# 0 $ **FLOATING
C441 w_64971_58015.n36 a_65135_57360# 0 $ **FLOATING
C442 w_64971_58015.n37 a_65135_57360# 0 $ **FLOATING
C443 w_64971_58015.t14 a_65135_57360# 0 $ **FLOATING
C444 w_64971_58015.t24 a_65135_57360# 0 $ **FLOATING
C445 w_64971_58015.n38 a_65135_57360# 0 $ **FLOATING
C446 w_64971_58015.t12 a_65135_57360# 0 $ **FLOATING
C447 w_64971_58015.n39 a_65135_57360# 0 $ **FLOATING
C448 w_64971_58015.t10 a_65135_57360# 0 $ **FLOATING
C449 w_64971_58015.n40 a_65135_57360# 0 $ **FLOATING
C450 w_64971_58015.n41 a_65135_57360# 0 $ **FLOATING
C451 w_64971_58015.t1 a_65135_57360# 0 $ **FLOATING
C452 w_64971_58015.t26 a_65135_57360# 0 $ **FLOATING
C453 w_64971_58015.t18 a_65135_57360# 0 $ **FLOATING
C454 w_64971_58015.n42 a_65135_57360# 0 $ **FLOATING
C455 w_64971_58015.t22 a_65135_57360# 0 $ **FLOATING
C456 w_64971_58015.n43 a_65135_57360# 0 $ **FLOATING
C457 w_64971_58015.t16 a_65135_57360# 0 $ **FLOATING
C458 w_64971_58015.n44 a_65135_57360# 0 $ **FLOATING
C459 w_64971_58015.n45 a_65135_57360# 0 $ **FLOATING
C460 w_64971_58015.t4 a_65135_57360# 0 $ **FLOATING
C461 w_64971_58015.t20 a_65135_57360# 0 $ **FLOATING
C462 a_65000_58051.t0 a_65135_57360# 0 $ **FLOATING
C463 a_65303_58036.t0 a_65135_57360# 0 $ **FLOATING
C464 a_65602_58036.t0 a_65135_57360# 0 $ **FLOATING
C465 a_65890_58036.t0 a_65135_57360# 0 $ **FLOATING
C466 a_65284_57370.t7 a_65135_57360# 0 $ **FLOATING
C467 a_65284_57370.t6 a_65135_57360# 0 $ **FLOATING
C468 a_65284_57370.n0 a_65135_57360# 0 $ **FLOATING
C469 a_65284_57370.n1 a_65135_57360# 0 $ **FLOATING
C470 a_65284_57370.n2 a_65135_57360# 0 $ **FLOATING
C471 a_65284_57370.t2 a_65135_57360# 0 $ **FLOATING
C472 a_65284_57370.t4 a_65135_57360# 0 $ **FLOATING
C473 a_65284_57370.n3 a_65135_57360# 0 $ **FLOATING
C474 a_65284_57370.t3 a_65135_57360# 0 $ **FLOATING
C475 a_65284_57370.t5 a_65135_57360# 0 $ **FLOATING
C476 a_65284_57370.t1 a_65135_57360# 0 $ **FLOATING
C477 a_65284_57370.n4 a_65135_57360# 0 $ **FLOATING
C478 a_65284_57370.n5 a_65135_57360# 0 $ **FLOATING
C479 a_65284_57370.t0 a_65135_57360# 0 $ **FLOATING
C480 a_65227_57396.t1 a_65135_57360# 0 $ **FLOATING
C481 a_65227_57396.n0 a_65135_57360# 0 $ **FLOATING
C482 a_65227_57396.t0 a_65135_57360# 0 $ **FLOATING
C483 a_65426_57680.t0 a_65135_57360# 0 $ **FLOATING
C484 a_65606_57680.t0 a_65135_57360# 0 $ **FLOATING
C485 a_65798_57680.t0 a_65135_57360# 0 $ **FLOATING
C486 a_65640_57000.t0 a_65135_57360# 0 $ **FLOATING
C487 a_65640_57000.n0 a_65135_57360# 0 $ **FLOATING
C488 a_65640_57000.t1 a_65135_57360# 0 $ **FLOATING
C489 a_65423_57416.t0 a_65135_57360# 0 $ **FLOATING
C490 a_65603_57432.t0 a_65135_57360# 0 $ **FLOATING
C491 a_65795_57432.t0 a_65135_57360# 0 $ **FLOATING
C492 a_66181_57370.t0 a_65135_57360# 0 $ **FLOATING
C493 a_65323_57074.t0 a_65135_57360# 0 $ **FLOATING
C494 a_65323_57074.n0 a_65135_57360# 0 $ **FLOATING
C495 a_65323_57074.n1 a_65135_57360# 0 $ **FLOATING
C496 a_65323_57074.t2 a_65135_57360# 0 $ **FLOATING
C497 a_65323_57074.t1 a_65135_57360# 0 $ **FLOATING
C498 a_65678_57074.t0 a_65135_57360# 0 $ **FLOATING
C499 a_66085_57074.t0 a_65135_57360# 0 $ **FLOATING
C500 a_66163_57074.t0 a_65135_57360# 0 $ **FLOATING
.ends
