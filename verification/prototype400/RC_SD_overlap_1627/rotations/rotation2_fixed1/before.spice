* NGSPICE file created from RotatedCrop.ext - technology: sky130A

.subckt RotatedCrop
X0 a_n66151_n57518# a_n66181_n57649# a_n66200_n57518# a_n66151_n57518# sky130_fd_pr__nfet_01v8_lvt ad=0.2109 pd=2.05 as=0.0703 ps=1.67 w=0.74 l=0.15
X1 a_n65941_n57880# a_n66085_n57248# a_n65660_n57880# w_n66214_n57924# sky130_fd_pr__pfet_01v8 ad=0.165 pd=1.33 as=0.135 ps=1.27 w=1 l=0.15
X2 a_n66151_n57518# a_n65801_n57665# a_n65849_n57560# a_n66151_n57518# sky130_fd_pr__nfet_01v8_lvt ad=0.1344 pd=1.06 as=0.0864 ps=0.91 w=0.64 l=0.15
X3 a_n65480_n57880# a_n66085_n57248# a_n65941_n57880# w_n66214_n57924# sky130_fd_pr__pfet_01v8 ad=0.135 pd=1.27 as=0.165 ps=1.33 w=1 l=0.15
X4 w_n66214_n57924# a_n65890_n58100# a_n65950_n58100# w_n66214_n57924# sky130_fd_pr__pfet_01v8 ad=0.0912 pd=1.21 as=0.048 ps=0.62 w=0.32 l=0.15
X5 a_n65371_n58100# a_n65401_n58100# w_n66214_n57924# w_n66214_n57924# sky130_fd_pr__pfet_01v8 ad=0.1088 pd=1.32 as=0.096 ps=1.24 w=0.32 l=0.15
X6 w_n66214_n57924# a_n65144_n58100# a_n65203_n58100# w_n66214_n57924# sky130_fd_pr__pfet_01v8 ad=0.04715 pd=0.63 as=0.07227 ps=1.08 w=0.245 l=0.15
X7 a_n65651_n57560# a_n65915_n57648# a_n66151_n57518# a_n66151_n57518# sky130_fd_pr__nfet_01v8_lvt ad=0.0768 pd=0.88 as=0.1344 ps=1.06 w=0.64 l=0.15
X8 a_n65471_n57544# a_n66085_n57248# a_n65941_n57880# a_n66151_n57518# sky130_fd_pr__nfet_01v8_lvt ad=0.0768 pd=0.88 as=0.1222 ps=1.08 w=0.64 l=0.15
X9 a_n65295_n57888# a_n65941_n57880# w_n66214_n57924# w_n66214_n57924# sky130_fd_pr__pfet_01v8 ad=0.3304 pd=2.83 as=0.1934 ps=1.475 w=1.12 l=0.15
X10 a_n65950_n58100# a_n65980_n58100# w_n66214_n57924# w_n66214_n57924# sky130_fd_pr__pfet_01v8 ad=0.048 pd=0.62 as=0.0912 ps=1.21 w=0.32 l=0.15
X11 a_n65852_n57880# a_n65915_n57648# a_n65941_n57880# w_n66214_n57924# sky130_fd_pr__pfet_01v8 ad=0.135 pd=1.27 as=0.295 ps=2.59 w=1 l=0.15
X12 w_n66214_n57924# a_n66181_n57649# a_n66200_n57888# w_n66214_n57924# sky130_fd_pr__pfet_01v8 ad=0.3192 pd=2.81 as=0.1232 ps=2.46 w=1.12 l=0.15
X13 a_n65849_n57560# a_n65915_n57648# a_n65941_n57880# a_n66151_n57518# sky130_fd_pr__nfet_01v8_lvt ad=0.0864 pd=0.91 as=0.1733 ps=1.85 w=0.64 l=0.15
X14 a_n66133_n57222# a_n66200_n57052# a_n66200_n57222# a_n66151_n57518# sky130_fd_pr__nfet_01v8_lvt ad=0.0888 pd=0.98 as=0.1369 ps=1.85 w=0.74 l=0.15
X15 a_n65660_n57880# a_n65915_n57648# w_n66214_n57924# w_n66214_n57924# sky130_fd_pr__pfet_01v8 ad=0.135 pd=1.27 as=0.195 ps=1.39 w=1 l=0.15
X16 a_n65941_n57880# a_n66085_n57248# a_n65651_n57560# a_n66151_n57518# sky130_fd_pr__nfet_01v8_lvt ad=0.1222 pd=1.08 as=0.0768 ps=0.88 w=0.64 l=0.15
X17 a_n65295_n57888# a_n65941_n57880# a_n66151_n57518# a_n66151_n57518# sky130_fd_pr__nfet_01v8_lvt ad=0.2081 pd=2.05 as=0.1389 ps=1.135 w=0.74 l=0.15
X18 a_n65007_n58100# a_n65037_n58100# w_n66214_n57924# w_n66214_n57924# sky130_fd_pr__pfet_01v8 ad=8.575m pd=0.56 as=0.04715 ps=0.63 w=0.245 l=0.15
X19 a_n66151_n57518# a_n65801_n57665# a_n65471_n57544# a_n66151_n57518# sky130_fd_pr__nfet_01v8_lvt ad=0.1389 pd=1.135 as=0.0768 ps=0.88 w=0.64 l=0.15
X20 a_n66151_n57518# a_n66085_n57248# a_n66133_n57222# a_n66151_n57518# sky130_fd_pr__nfet_01v8_lvt ad=0.2109 pd=2.05 as=0.0888 ps=0.98 w=0.74 l=0.15
X21 a_n65648_n57222# a_n66200_n57888# a_n65749_n57222# a_n66151_n57518# sky130_fd_pr__nfet_01v8_lvt ad=0.1036 pd=1.02 as=0.2627 ps=2.19 w=0.74 l=0.15
X22 w_n66214_n57924# a_n65801_n57665# a_n65852_n57880# w_n66214_n57924# sky130_fd_pr__pfet_01v8 ad=0.195 pd=1.39 as=0.135 ps=1.27 w=1 l=0.15
X23 w_n66214_n57924# a_n65602_n58100# a_n65662_n58100# w_n66214_n57924# sky130_fd_pr__pfet_01v8 ad=0.0912 pd=1.21 as=0.048 ps=0.62 w=0.32 l=0.15
X24 a_n65648_n57222# a_n65461_n57052# a_n66151_n57518# a_n66151_n57518# sky130_fd_pr__nfet_01v8_lvt ad=0.2109 pd=2.05 as=0.3361 ps=1.68 w=0.74 l=0.15
X25 w_n66214_n57924# a_n65801_n57665# a_n65480_n57880# w_n66214_n57924# sky130_fd_pr__pfet_01v8 ad=0.1934 pd=1.475 as=0.135 ps=1.27 w=1 l=0.15
X26 a_n66151_n57518# a_n65915_n57648# a_n65648_n57222# a_n66151_n57518# sky130_fd_pr__nfet_01v8_lvt ad=0.3361 pd=1.68 as=0.1036 ps=1.02 w=0.74 l=0.15
X27 a_n65662_n58100# a_n65692_n58100# w_n66214_n57924# w_n66214_n57924# sky130_fd_pr__pfet_01v8 ad=0.048 pd=0.62 as=0.0912 ps=1.21 w=0.32 l=0.15
C0 a_n65401_n58100# a_n65461_n57052# 0.00183f
C1 a_n65602_n58100# a_n65915_n57648# 0
C2 a_n65890_n58100# a_n65371_n58100# 0.00166f
C3 a_n65602_n58100# m2_n65790_n58100# 0
C4 a_n65660_n57880# a_n65915_n57648# 0.00273f
C5 a_n65660_n57880# m2_n65790_n58100# 0.00142f
C6 a_n65295_n57888# w_n66214_n57924# 0.23739f
C7 a_n65915_n57648# a_n65890_n58100# 0.00374f
C8 m2_n65790_n58100# a_n65890_n58100# 0
C9 a_n65651_n57560# w_n66214_n57924# 0
C10 m1_n66200_n57023# w_n66214_n57924# 0
C11 a_n66085_n57248# a_n65480_n57880# 0.00978f
C12 a_n66200_n57888# a_n65662_n58100# 0
C13 a_n65801_n57665# a_n65480_n57880# 0.0028f
C14 a_n65037_n58100# a_n65144_n58100# 0.0054f
C15 a_n65941_n57880# a_n65480_n57880# 0.00749f
C16 a_n65849_n57560# a_n65801_n57665# 0.00551f
C17 a_n65037_n58100# a_n65371_n58100# 0
C18 a_n65662_n58100# a_n65692_n58100# 0.00254f
C19 a_n66133_n57222# a_n66085_n57248# 0.00188f
C20 a_n66133_n57222# a_n65801_n57665# 0.00291f
C21 a_n65849_n57560# a_n65941_n57880# 0.00893f
C22 a_n65602_n58100# a_n65401_n58100# 0.00243f
C23 li_n65017_n58100# a_n65461_n57052# 0
C24 a_n65651_n57560# a_n65295_n57888# 0.00171f
C25 a_n65801_n57665# a_n65461_n57052# 0.29164f
C26 a_n66085_n57248# a_n65461_n57052# 0.24124f
C27 a_n65950_n58100# w_n66214_n57924# 0.08129f
C28 a_n65941_n57880# a_n65461_n57052# 0.0107f
C29 m2_n65790_n58100# a_n66200_n57518# 0
C30 a_n65648_n57222# a_n65461_n57052# 0.06164f
C31 a_n65980_n58100# w_n66214_n57924# 0.03054f
C32 a_n65915_n57648# a_n65749_n57222# 0.06228f
C33 m2_n65790_n58100# a_n65749_n57222# 0.0055f
C34 a_n65471_n57544# w_n66214_n57924# 0
C35 a_n65602_n58100# a_n65662_n58100# 0.00316f
C36 a_n66181_n57649# w_n66214_n57924# 0.12244f
C37 a_n66200_n57888# a_n65801_n57665# 0.0619f
C38 a_n66200_n57888# a_n66085_n57248# 0.06427f
C39 a_n66200_n57888# a_n65941_n57880# 0.07885f
C40 w_n66214_n57924# a_n65144_n58100# 0.0286f
C41 a_n66200_n57888# a_n65648_n57222# 0.00888f
C42 a_n65852_n57880# a_n65941_n57880# 0.01522f
C43 a_n65371_n58100# w_n66214_n57924# 0.49704f
C44 a_n65801_n57665# a_n65692_n58100# 0
C45 a_n66200_n57222# a_n65749_n57222# 0.00231f
C46 a_n65941_n57880# a_n65692_n58100# 0
C47 a_n65915_n57648# w_n66214_n57924# 0.15771f
C48 m2_n65790_n58100# w_n66214_n57924# 0.17386f
C49 a_n65203_n58100# a_n66085_n57248# 0
C50 a_n65980_n58100# a_n65295_n57888# 0
C51 a_n65602_n58100# a_n65801_n57665# 0
C52 a_n65602_n58100# a_n66085_n57248# 0.00418f
C53 a_n65660_n57880# a_n65801_n57665# 0.00203f
C54 a_n65461_n57052# a_n65480_n57880# 0.00218f
C55 a_n66200_n57222# w_n66214_n57924# 0.00501f
C56 a_n65471_n57544# a_n65295_n57888# 0.00285f
C57 a_n65602_n58100# a_n65941_n57880# 0
C58 a_n66181_n57649# a_n65295_n57888# 0.05335f
C59 a_n65660_n57880# a_n65941_n57880# 0.01538f
C60 a_n66200_n57052# w_n66214_n57924# 0.00265f
C61 a_n65941_n57880# a_n65890_n58100# 0
C62 a_n66181_n57649# a_n65651_n57560# 0
C63 a_n65295_n57888# a_n65371_n58100# 0.00187f
C64 a_n66200_n57888# a_n65480_n57880# 0
C65 a_n65915_n57648# a_n65295_n57888# 0.09591f
C66 m2_n65790_n58100# a_n65295_n57888# 0.02291f
C67 a_n66200_n57888# a_n65849_n57560# 0
C68 a_n65651_n57560# a_n65915_n57648# 0.00102f
C69 a_n65401_n58100# w_n66214_n57924# 0.03188f
C70 a_n66200_n57888# a_n65461_n57052# 0
C71 li_n65017_n58100# a_n65037_n58100# 0.00323f
C72 a_n66200_n57052# a_n65295_n57888# 0
C73 a_n65980_n58100# a_n65950_n58100# 0.00254f
C74 a_n65662_n58100# w_n66214_n57924# 0.07727f
C75 a_n66200_n57888# a_n65852_n57880# 0.00508f
C76 a_n65203_n58100# a_n65461_n57052# 0
C77 a_n66085_n57248# a_n66200_n57518# 0
C78 a_n66200_n57518# a_n65801_n57665# 0.00129f
C79 a_n66200_n57888# a_n65692_n58100# 0
C80 a_n65801_n57665# a_n65749_n57222# 0.00399f
C81 a_n66085_n57248# a_n65749_n57222# 0.0464f
C82 a_n65941_n57880# a_n66200_n57518# 0
C83 a_n65950_n58100# a_n65144_n58100# 0
C84 a_n65371_n58100# a_n65950_n58100# 0.00756f
C85 a_n65648_n57222# a_n65749_n57222# 0.13586f
C86 a_n66200_n57222# m1_n66200_n57023# 0.0024f
C87 a_n65980_n58100# a_n65371_n58100# 0.00161f
C88 a_n65401_n58100# a_n65295_n57888# 0
C89 a_n65915_n57648# a_n65950_n58100# 0
C90 a_n66200_n57052# m1_n66200_n57023# 0.00304f
C91 m2_n65790_n58100# a_n65950_n58100# 0.00161f
C92 a_n65980_n58100# m2_n65790_n58100# 0
C93 a_n66181_n57649# a_n65371_n58100# 0
C94 li_n65017_n58100# w_n66214_n57924# 0.03016f
C95 a_n66181_n57649# a_n65915_n57648# 0.02192f
C96 a_n65371_n58100# a_n65144_n58100# 0.00145f
C97 a_n65801_n57665# w_n66214_n57924# 0.24503f
C98 a_n66085_n57248# w_n66214_n57924# 0.31898f
C99 a_n66181_n57649# m2_n65790_n58100# 0.00367f
C100 a_n66200_n57888# a_n65660_n57880# 0.00283f
C101 a_n65941_n57880# w_n66214_n57924# 0.38296f
C102 a_n65648_n57222# w_n66214_n57924# 0
C103 m2_n65790_n58100# a_n65144_n58100# 0
C104 a_n65602_n58100# a_n65692_n58100# 0.00693f
C105 a_n65915_n57648# a_n65371_n58100# 0
C106 m2_n65790_n58100# a_n65371_n58100# 0.00633f
C107 a_n65890_n58100# a_n65692_n58100# 0.00248f
C108 m2_n65790_n58100# a_n65915_n57648# 0.01513f
C109 a_n66181_n57649# a_n66200_n57222# 0
C110 a_n66181_n57649# a_n66200_n57052# 0.004f
C111 a_n65037_n58100# a_n65461_n57052# 0
C112 a_n66133_n57222# a_n65749_n57222# 0
C113 m2_n65790_n58100# a_n66200_n57222# 0
C114 a_n65295_n57888# a_n65801_n57665# 0.31103f
C115 a_n66085_n57248# a_n65295_n57888# 0.16992f
C116 a_n65941_n57880# a_n65295_n57888# 0.18875f
C117 a_n65749_n57222# a_n65461_n57052# 0.04148f
C118 a_n65651_n57560# a_n65801_n57665# 0.00229f
C119 a_n65480_n57880# w_n66214_n57924# 0.01679f
C120 a_n65651_n57560# a_n65941_n57880# 0.00942f
C121 a_n65401_n58100# a_n65144_n58100# 0
C122 a_n65401_n58100# a_n65371_n58100# 0.00502f
C123 a_n65849_n57560# w_n66214_n57924# 0
C124 a_n66200_n57888# a_n66200_n57518# 0.0022f
C125 a_n66133_n57222# w_n66214_n57924# 0.002f
C126 a_n66200_n57888# a_n65749_n57222# 0.0904f
C127 a_n66200_n57222# a_n66200_n57052# 0.06167f
C128 a_n66085_n57248# m1_n66200_n57023# 0.00687f
C129 m1_n66200_n57023# a_n65801_n57665# 0
C130 li_n65017_n58100# a_n65007_n58100# 0
C131 a_n65461_n57052# w_n66214_n57924# 0.09766f
C132 a_n65662_n58100# a_n65144_n58100# 0
C133 a_n65662_n58100# a_n65371_n58100# 0.00765f
C134 a_n65915_n57648# a_n65662_n58100# 0
C135 a_n66200_n57888# w_n66214_n57924# 0.34073f
C136 m2_n65790_n58100# a_n65662_n58100# 0.00157f
C137 a_n65852_n57880# w_n66214_n57924# 0.01489f
C138 a_n65295_n57888# a_n65480_n57880# 0
C139 a_n65692_n58100# w_n66214_n57924# 0.02599f
C140 a_n65980_n58100# a_n65801_n57665# 0
C141 a_n65980_n58100# a_n66085_n57248# 0
C142 a_n65849_n57560# a_n65295_n57888# 0.00194f
C143 a_n65471_n57544# a_n65801_n57665# 0.00269f
C144 a_n66181_n57649# a_n65801_n57665# 0.00667f
C145 a_n66181_n57649# a_n66085_n57248# 0.00385f
C146 a_n65471_n57544# a_n65941_n57880# 0.00875f
C147 a_n65203_n58100# w_n66214_n57924# 0.03649f
C148 a_n66181_n57649# a_n65941_n57880# 0.00594f
C149 a_n65295_n57888# a_n65461_n57052# 0.03562f
C150 li_n65017_n58100# a_n65371_n58100# 0
C151 a_n65801_n57665# a_n65144_n58100# 0
C152 a_n66085_n57248# a_n65371_n58100# 0
C153 a_n65801_n57665# a_n65371_n58100# 0.0059f
C154 a_n65941_n57880# a_n65371_n58100# 0.0026f
C155 a_n65602_n58100# w_n66214_n57924# 0.02533f
C156 a_n65648_n57222# a_n65371_n58100# 0
C157 a_n66085_n57248# a_n65915_n57648# 0.15009f
C158 a_n65915_n57648# a_n65801_n57665# 0.27393f
C159 a_n66085_n57248# m2_n65790_n58100# 0.06654f
C160 m2_n65790_n58100# a_n65801_n57665# 0.12947f
C161 a_n65660_n57880# w_n66214_n57924# 0.01297f
C162 a_n65941_n57880# a_n65915_n57648# 0.33845f
C163 a_n65890_n58100# w_n66214_n57924# 0.02766f
C164 a_n65648_n57222# a_n65915_n57648# 0.01825f
C165 m2_n65790_n58100# a_n65941_n57880# 0.01819f
C166 a_n66200_n57888# a_n65295_n57888# 0.0968f
C167 a_n65852_n57880# a_n65295_n57888# 0
C168 a_n66200_n57888# a_n65651_n57560# 0
C169 a_n66085_n57248# a_n66200_n57222# 0.04233f
C170 a_n66200_n57222# a_n65801_n57665# 0.01259f
C171 a_n66200_n57052# a_n65801_n57665# 0.00437f
C172 a_n66085_n57248# a_n66200_n57052# 0.03827f
C173 a_n65849_n57560# a_n66181_n57649# 0
C174 a_n66085_n57248# a_n65401_n58100# 0
C175 a_n65401_n58100# a_n65801_n57665# 0
C176 a_n65037_n58100# w_n66214_n57924# 0.02128f
C177 a_n65471_n57544# a_n65461_n57052# 0.00132f
C178 a_n65941_n57880# a_n65401_n58100# 0
C179 a_n66181_n57649# a_n65461_n57052# 0
C180 a_n65648_n57222# a_n65401_n58100# 0
C181 a_n65849_n57560# a_n65915_n57648# 0
C182 a_n66200_n57518# w_n66214_n57924# 0
C183 a_n65849_n57560# m2_n65790_n58100# 0
C184 a_n65461_n57052# a_n65144_n58100# 0
C185 a_n66200_n57888# a_n65980_n58100# 0
C186 a_n65749_n57222# w_n66214_n57924# 0.00264f
C187 a_n65461_n57052# a_n65371_n58100# 0.01928f
C188 a_n65915_n57648# a_n65461_n57052# 0.13033f
C189 a_n65662_n58100# a_n65801_n57665# 0.00165f
C190 a_n66085_n57248# a_n65662_n58100# 0
C191 a_n66200_n57888# a_n66181_n57649# 0.10939f
C192 a_n66200_n57888# a_n65371_n58100# 0
C193 a_n66133_n57222# a_n66200_n57222# 0.00959f
C194 a_n66200_n57888# a_n65915_n57648# 0.41095f
C195 a_n66200_n57888# m2_n65790_n58100# 0.33447f
C196 a_n65852_n57880# a_n65915_n57648# 0
C197 a_n65371_n58100# a_n65692_n58100# 0.00165f
C198 a_n65852_n57880# m2_n65790_n58100# 0.00194f
C199 a_n65915_n57648# a_n65692_n58100# 0.0044f
C200 m2_n65790_n58100# a_n65692_n58100# 0
C201 a_n65203_n58100# a_n65144_n58100# 0.00218f
C202 a_n65890_n58100# a_n65950_n58100# 0.00316f
C203 a_n65295_n57888# a_n66200_n57518# 0.00124f
C204 a_n65203_n58100# a_n65371_n58100# 0.02349f
C205 a_n65980_n58100# a_n65890_n58100# 0.00693f
C206 a_n66085_n57248# a_n65801_n57665# 0.22328f
C207 a_n65941_n57880# a_n65801_n57665# 0.20106f
C208 a_n66085_n57248# a_n65941_n57880# 0.21462f
C209 a_n65648_n57222# a_n65801_n57665# 0.00271f
C210 a_n65648_n57222# a_n66085_n57248# 0.06222f
C211 a_n65602_n58100# a_n65371_n58100# 0.00172f
C212 a_n66200_n57888# a_n66200_n57052# 0
C213 a_n65648_n57222# a_n65941_n57880# 0
C214 m5_n66100_n58100# a_n66151_n57518# 0 $ **FLOATING
C215 m4_n65112_n58100# a_n66151_n57518# 0 $ **FLOATING
C216 m4_n65288_n58100# a_n66151_n57518# 0 $ **FLOATING
C217 m4_n65464_n58100# a_n66151_n57518# 0 $ **FLOATING
C218 m4_n65640_n58100# a_n66151_n57518# 0 $ **FLOATING
C219 m4_n65148_n58012# a_n66151_n57518# 0 $ **FLOATING
C220 m4_n65324_n58012# a_n66151_n57518# 0 $ **FLOATING
C221 m4_n65500_n58012# a_n66151_n57518# 0 $ **FLOATING
C222 m4_n65676_n58012# a_n66151_n57518# 0 $ **FLOATING
C223 m4_n65008_n57836# a_n66151_n57518# 0 $ **FLOATING
C224 m4_n65184_n57836# a_n66151_n57518# 0 $ **FLOATING
C225 m4_n65360_n57836# a_n66151_n57518# 0 $ **FLOATING
C226 m4_n65536_n57836# a_n66151_n57518# 0 $ **FLOATING
C227 m4_n65712_n57836# a_n66151_n57518# 0 $ **FLOATING
C228 m4_n65044_n57660# a_n66151_n57518# 0 $ **FLOATING
C229 m4_n65220_n57660# a_n66151_n57518# 0 $ **FLOATING
C230 m4_n65396_n57660# a_n66151_n57518# 0 $ **FLOATING
C231 m4_n65572_n57660# a_n66151_n57518# 0 $ **FLOATING
C232 m4_n65080_n57484# a_n66151_n57518# 0 $ **FLOATING
C233 m4_n65256_n57484# a_n66151_n57518# 0 $ **FLOATING
C234 m4_n65432_n57484# a_n66151_n57518# 0 $ **FLOATING
C235 m4_n65608_n57484# a_n66151_n57518# 0 $ **FLOATING
C236 m4_n65116_n57308# a_n66151_n57518# 0 $ **FLOATING
C237 m4_n65292_n57308# a_n66151_n57518# 0 $ **FLOATING
C238 m4_n65468_n57308# a_n66151_n57518# 0 $ **FLOATING
C239 m4_n65644_n57308# a_n66151_n57518# 0 $ **FLOATING
C240 m4_n65152_n57132# a_n66151_n57518# 0 $ **FLOATING
C241 m4_n65328_n57132# a_n66151_n57518# 0 $ **FLOATING
C242 m4_n65504_n57132# a_n66151_n57518# 0 $ **FLOATING
C243 m4_n65680_n57132# a_n66151_n57518# 0 $ **FLOATING
C244 m3_n65042_n58100# a_n66151_n57518# 0 $ **FLOATING
C245 m3_n65218_n58100# a_n66151_n57518# 0 $ **FLOATING
C246 m3_n65394_n58100# a_n66151_n57518# 0 $ **FLOATING
C247 m3_n65570_n58100# a_n66151_n57518# 0 $ **FLOATING
C248 m3_n65078_n57942# a_n66151_n57518# 0 $ **FLOATING
C249 m3_n65254_n57942# a_n66151_n57518# 0 $ **FLOATING
C250 m3_n65430_n57942# a_n66151_n57518# 0 $ **FLOATING
C251 m3_n65606_n57942# a_n66151_n57518# 0 $ **FLOATING
C252 m3_n65114_n57766# a_n66151_n57518# 0 $ **FLOATING
C253 m3_n65290_n57766# a_n66151_n57518# 0 $ **FLOATING
C254 m3_n65466_n57766# a_n66151_n57518# 0 $ **FLOATING
C255 m3_n65642_n57766# a_n66151_n57518# 0 $ **FLOATING
C256 m3_n65818_n57766# a_n66151_n57518# 0 $ **FLOATING
C257 m3_n65994_n57766# a_n66151_n57518# 0 $ **FLOATING
C258 m3_n66170_n57766# a_n66151_n57518# 0 $ **FLOATING
C259 m3_n65150_n57590# a_n66151_n57518# 0 $ **FLOATING
C260 m3_n65326_n57590# a_n66151_n57518# 0 $ **FLOATING
C261 m3_n65502_n57590# a_n66151_n57518# 0 $ **FLOATING
C262 m3_n65678_n57590# a_n66151_n57518# 0 $ **FLOATING
C263 m3_n65854_n57590# a_n66151_n57518# 0 $ **FLOATING
C264 m3_n66030_n57590# a_n66151_n57518# 0 $ **FLOATING
C265 m3_n66200_n57590# a_n66151_n57518# 0 $ **FLOATING
C266 m3_n65010_n57414# a_n66151_n57518# 0 $ **FLOATING
C267 m3_n65186_n57414# a_n66151_n57518# 0 $ **FLOATING
C268 m3_n65362_n57414# a_n66151_n57518# 0 $ **FLOATING
C269 m3_n65538_n57414# a_n66151_n57518# 0 $ **FLOATING
C270 m3_n65714_n57414# a_n66151_n57518# 0 $ **FLOATING
C271 m3_n65890_n57414# a_n66151_n57518# 0 $ **FLOATING
C272 m3_n66066_n57414# a_n66151_n57518# 0 $ **FLOATING
C273 m3_n66200_n57414# a_n66151_n57518# 0 $ **FLOATING
C274 m3_n65046_n57238# a_n66151_n57518# 0 $ **FLOATING
C275 m3_n65222_n57238# a_n66151_n57518# 0 $ **FLOATING
C276 m3_n65398_n57238# a_n66151_n57518# 0 $ **FLOATING
C277 m3_n65574_n57238# a_n66151_n57518# 0 $ **FLOATING
C278 m3_n65750_n57238# a_n66151_n57518# 0 $ **FLOATING
C279 m2_n65152_n58084# a_n66151_n57518# 0 $ **FLOATING
C280 m2_n65168_n57928# a_n66151_n57518# 0 $ **FLOATING
C281 m2_n65300_n57900# a_n66151_n57518# 0 $ **FLOATING
C282 m2_n65280_n57800# a_n66151_n57518# 0 $ **FLOATING
C283 m2_n65060_n57700# a_n66151_n57518# 0 $ **FLOATING
C284 m2_n65120_n57500# a_n66151_n57518# 0 $ **FLOATING
C285 m2_n65100_n57400# a_n66151_n57518# 0 $ **FLOATING
C286 m2_n65080_n57300# a_n66151_n57518# 0 $ **FLOATING
C287 m2_n65060_n57200# a_n66151_n57518# 0 $ **FLOATING
C288 m2_n65640_n58100# a_n66151_n57518# 0 $ **FLOATING
C289 m2_n65700_n57900# a_n66151_n57518# 0 $ **FLOATING
C290 m2_n65790_n58100# a_n66151_n57518# 0.16111f
C291 m2_n65960_n57700# a_n66151_n57518# 0 $ **FLOATING
C292 m2_n66120_n57772# a_n66151_n57518# 0 $ **FLOATING
C293 m2_n65940_n57600# a_n66151_n57518# 0 $ **FLOATING
C294 m2_n66040_n57600# a_n66151_n57518# 0 $ **FLOATING
C295 m2_n66140_n57600# a_n66151_n57518# 0 $ **FLOATING
C296 m2_n65920_n57500# a_n66151_n57518# 0 $ **FLOATING
C297 m2_n65980_n57300# a_n66151_n57518# 0 $ **FLOATING
C298 m2_n66200_n57460# a_n66151_n57518# 0 $ **FLOATING
C299 m1_n65070_n57790# a_n66151_n57518# 0 $ **FLOATING
C300 m1_n65170_n57790# a_n66151_n57518# 0 $ **FLOATING
C301 m1_n65270_n57790# a_n66151_n57518# 0 $ **FLOATING
C302 m1_n65370_n57790# a_n66151_n57518# 0 $ **FLOATING
C303 m1_n65470_n57790# a_n66151_n57518# 0 $ **FLOATING
C304 m1_n65570_n57790# a_n66151_n57518# 0 $ **FLOATING
C305 m1_n65050_n57690# a_n66151_n57518# 0 $ **FLOATING
C306 m1_n65030_n57590# a_n66151_n57518# 0 $ **FLOATING
C307 m1_n65010_n57490# a_n66151_n57518# 0 $ **FLOATING
C308 m1_n65110_n57490# a_n66151_n57518# 0 $ **FLOATING
C309 m1_n66200_n57023# a_n66151_n57518# 0.0088f
C310 li_n65017_n58100# a_n66151_n57518# 0.01322f
C311 li_n65006_n57726# a_n66151_n57518# 0 $ **FLOATING
C312 a_n65007_n58100# a_n66151_n57518# 0 $ **FLOATING
C313 a_n65203_n58100# a_n66151_n57518# 0.00652f $ **FLOATING
C314 a_n65037_n58100# a_n66151_n57518# 0.0068f $ **FLOATING
C315 a_n65144_n58100# a_n66151_n57518# 0.00161f $ **FLOATING
C316 a_n65371_n58100# a_n66151_n57518# 0.23712f $ **FLOATING
C317 a_n65662_n58100# a_n66151_n57518# 0.01044f $ **FLOATING
C318 a_n65950_n58100# a_n66151_n57518# 0.01044f $ **FLOATING
C319 a_n65401_n58100# a_n66151_n57518# 0.00123f $ **FLOATING
C320 a_n65602_n58100# a_n66151_n57518# 0 $ **FLOATING
C321 a_n65692_n58100# a_n66151_n57518# 0 $ **FLOATING
C322 a_n65890_n58100# a_n66151_n57518# 0 $ **FLOATING
C323 a_n65980_n58100# a_n66151_n57518# 0.00319f $ **FLOATING
C324 a_n65480_n57880# a_n66151_n57518# 0 $ **FLOATING
C325 a_n65660_n57880# a_n66151_n57518# 0 $ **FLOATING
C326 a_n65852_n57880# a_n66151_n57518# 0 $ **FLOATING
C327 a_n65295_n57888# a_n66151_n57518# 0.309f $ **FLOATING
C328 a_n65471_n57544# a_n66151_n57518# 0.00549f $ **FLOATING
C329 a_n65651_n57560# a_n66151_n57518# 0.00339f $ **FLOATING
C330 a_n65849_n57560# a_n66151_n57518# 0.00208f $ **FLOATING
C331 a_n65941_n57880# a_n66151_n57518# 0.30041f $ **FLOATING
C332 a_n66200_n57518# a_n66151_n57518# 0.00416f $ **FLOATING
C333 a_n65801_n57665# a_n66151_n57518# 1.15715f $ **FLOATING
C334 a_n66181_n57649# a_n66151_n57518# 0.21943f $ **FLOATING
C335 a_n65648_n57222# a_n66151_n57518# 0.21271f $ **FLOATING
C336 a_n65749_n57222# a_n66151_n57518# 0.11319f $ **FLOATING
C337 a_n66133_n57222# a_n66151_n57518# 0.00893f $ **FLOATING
C338 a_n66200_n57222# a_n66151_n57518# 0.12376f $ **FLOATING
C339 a_n65461_n57052# a_n66151_n57518# 0.38176f $ **FLOATING
C340 a_n65915_n57648# a_n66151_n57518# 0.33313f $ **FLOATING
C341 a_n66200_n57888# a_n66151_n57518# 0.33092f $ **FLOATING
C342 a_n66085_n57248# a_n66151_n57518# 1.1461f $ **FLOATING
C343 a_n66200_n57052# a_n66151_n57518# 0.1128f $ **FLOATING
C344 w_n66214_n57924# a_n66151_n57518# 2.67126f $ **FLOATING
C345 a_n66151_n57518# a_n66151_n57518# 0 $ **FLOATING
.ends
