* NGSPICE file created from RotatedCrop.ext - technology: sky130A

.subckt RotatedCrop
X0 a_n66151_n57518.t16 a_n66181_n57649# a_n66200_n57518.t0 a_n66151_n57518.t15 sky130_fd_pr__nfet_01v8_lvt ad=0.2109 pd=2.05 as=0.0703 ps=1.67 w=0.74 l=0.15
X1 a_n65941_n57880.t1 a_n66085_n57248# a_n65660_n57880.t0 w_n66214_n57924.t2 sky130_fd_pr__pfet_01v8 ad=0.165 pd=1.33 as=0.135 ps=1.27 w=1 l=0.15
X2 a_n66151_n57518.t20 a_n65801_n57665# a_n65849_n57560.t0 a_n66151_n57518.t19 sky130_fd_pr__nfet_01v8_lvt ad=0.1344 pd=1.06 as=0.0864 ps=0.91 w=0.64 l=0.15
X3 a_n65480_n57880# a_n66085_n57248# a_n65941_n57880.t2 w_n66214_n57924.t3 sky130_fd_pr__pfet_01v8 ad=0.135 pd=1.27 as=0.165 ps=1.33 w=1 l=0.15
X4 w_n66214_n57924.t11 a_n65890_n58100# a_n65950_n58100.t0 w_n66214_n57924.t10 sky130_fd_pr__pfet_01v8 ad=0.0912 pd=1.21 as=0.048 ps=0.62 w=0.32 l=0.15
X5 a_n65371_n58100# a_n65401_n58100# w_n66214_n57924.t7 w_n66214_n57924.t6 sky130_fd_pr__pfet_01v8 ad=0.1088 pd=1.32 as=0.096 ps=1.24 w=0.32 l=0.15
X6 w_n66214_n57924.t17 a_n65144_n58100# a_n65203_n58100.t0 w_n66214_n57924.t16 sky130_fd_pr__pfet_01v8 ad=0.04715 pd=0.63 as=0.07227 ps=1.08 w=0.245 l=0.15
X7 a_n65651_n57560# a_n65915_n57648# a_n66151_n57518.t13 a_n66151_n57518.t12 sky130_fd_pr__nfet_01v8_lvt ad=0.0768 pd=0.88 as=0.1344 ps=1.06 w=0.64 l=0.15
X8 a_n65471_n57544# a_n66085_n57248# a_n65941_n57880.t0 a_n66151_n57518.t3 sky130_fd_pr__nfet_01v8_lvt ad=0.0768 pd=0.88 as=0.1222 ps=1.08 w=0.64 l=0.15
X9 a_n65295_n57888# a_n65941_n57880.t6 w_n66214_n57924.t5 w_n66214_n57924.t4 sky130_fd_pr__pfet_01v8 ad=0.3304 pd=2.83 as=0.1934 ps=1.475 w=1.12 l=0.15
X10 a_n65950_n58100# a_n65980_n58100# w_n66214_n57924.t13 w_n66214_n57924.t12 sky130_fd_pr__pfet_01v8 ad=0.048 pd=0.62 as=0.0912 ps=1.21 w=0.32 l=0.15
X11 a_n65852_n57880# a_n65915_n57648# a_n65941_n57880.t4 w_n66214_n57924.t18 sky130_fd_pr__pfet_01v8 ad=0.135 pd=1.27 as=0.295 ps=2.59 w=1 l=0.15
X12 w_n66214_n57924.t22 a_n66181_n57649# a_n66200_n57888.t0 w_n66214_n57924.t21 sky130_fd_pr__pfet_01v8 ad=0.3192 pd=2.81 as=0.1232 ps=2.46 w=1.12 l=0.15
X13 a_n65849_n57560# a_n65915_n57648# a_n65941_n57880.t5 a_n66151_n57518.t11 sky130_fd_pr__nfet_01v8_lvt ad=0.0864 pd=0.91 as=0.1733 ps=1.85 w=0.64 l=0.15
X14 a_n66133_n57222# a_n66200_n57052# a_n66200_n57222.t0 a_n66151_n57518.t4 sky130_fd_pr__nfet_01v8_lvt ad=0.0888 pd=0.98 as=0.1369 ps=1.85 w=0.74 l=0.15
X15 a_n65660_n57880# a_n65915_n57648# w_n66214_n57924.t20 w_n66214_n57924.t19 sky130_fd_pr__pfet_01v8 ad=0.135 pd=1.27 as=0.195 ps=1.39 w=1 l=0.15
X16 a_n65941_n57880.t3 a_n66085_n57248# a_n65651_n57560.t0 a_n66151_n57518.t2 sky130_fd_pr__nfet_01v8_lvt ad=0.1222 pd=1.08 as=0.0768 ps=0.88 w=0.64 l=0.15
X17 a_n65295_n57888.t0 a_n65941_n57880.t7 a_n66151_n57518.t8 a_n66151_n57518.t7 sky130_fd_pr__nfet_01v8_lvt ad=0.2081 pd=2.05 as=0.1389 ps=1.135 w=0.74 l=0.15
X18 a_n65007_n58100.t0 a_n65037_n58100# w_n66214_n57924.t15 w_n66214_n57924.t14 sky130_fd_pr__pfet_01v8 ad=8.575m pd=0.56 as=0.04715 ps=0.63 w=0.245 l=0.15
X19 a_n66151_n57518.t18 a_n65801_n57665# a_n65471_n57544.t0 a_n66151_n57518.t17 sky130_fd_pr__nfet_01v8_lvt ad=0.1389 pd=1.135 as=0.0768 ps=0.88 w=0.64 l=0.15
X20 a_n66151_n57518.t1 a_n66085_n57248# a_n66133_n57222.t0 a_n66151_n57518.t0 sky130_fd_pr__nfet_01v8_lvt ad=0.2109 pd=2.05 as=0.0888 ps=0.98 w=0.74 l=0.15
X21 a_n65648_n57222# a_n66200_n57888.t1 a_n65749_n57222.t0 a_n66151_n57518.t14 sky130_fd_pr__nfet_01v8_lvt ad=0.1036 pd=1.02 as=0.2627 ps=2.19 w=0.74 l=0.15
X22 w_n66214_n57924.t24 a_n65801_n57665# a_n65852_n57880.t0 w_n66214_n57924.t23 sky130_fd_pr__pfet_01v8 ad=0.195 pd=1.39 as=0.135 ps=1.27 w=1 l=0.15
X23 w_n66214_n57924.t9 a_n65602_n58100# a_n65662_n58100.t0 w_n66214_n57924.t8 sky130_fd_pr__pfet_01v8 ad=0.0912 pd=1.21 as=0.048 ps=0.62 w=0.32 l=0.15
X24 a_n65648_n57222.t0 a_n65461_n57052# a_n66151_n57518.t6 a_n66151_n57518.t5 sky130_fd_pr__nfet_01v8_lvt ad=0.2109 pd=2.05 as=0.3361 ps=1.68 w=0.74 l=0.15
X25 w_n66214_n57924.t26 a_n65801_n57665# a_n65480_n57880.t0 w_n66214_n57924.t25 sky130_fd_pr__pfet_01v8 ad=0.1934 pd=1.475 as=0.135 ps=1.27 w=1 l=0.15
X26 a_n66151_n57518.t10 a_n65915_n57648# a_n65648_n57222.t1 a_n66151_n57518.t9 sky130_fd_pr__nfet_01v8_lvt ad=0.3361 pd=1.68 as=0.1036 ps=1.02 w=0.74 l=0.15
X27 a_n65662_n58100# a_n65692_n58100# w_n66214_n57924.t1 w_n66214_n57924.t0 sky130_fd_pr__pfet_01v8 ad=0.048 pd=0.62 as=0.0912 ps=1.21 w=0.32 l=0.15
C0 a_n65648_n57222# a_n65941_n57880# 0
C1 a_n65915_n57648# a_n65602_n58100# 0
C2 a_n65915_n57648# a_n65950_n58100# 0
C3 a_n65749_n57222# a_n66200_n57888# 0.0904f
C4 a_n65461_n57052# a_n66200_n57888# 0
C5 a_n65371_n58100# a_n65801_n57665# 0.0059f
C6 w_n66214_n57924# a_n65692_n58100# 0.02599f
C7 a_n65295_n57888# a_n65471_n57544# 0.00285f
C8 a_n65480_n57880# a_n66200_n57888# 0
C9 a_n65401_n58100# a_n65461_n57052# 0.00183f
C10 a_n65749_n57222# m2_n65790_n58100# 0.0055f
C11 a_n65371_n58100# a_n65648_n57222# 0
C12 a_n65915_n57648# a_n66200_n57888# 0.41095f
C13 a_n65295_n57888# a_n65849_n57560# 0.00194f
C14 a_n65660_n57880# a_n66200_n57888# 0.00283f
C15 a_n65203_n58100# a_n66085_n57248# 0
C16 a_n65941_n57880# a_n65602_n58100# 0
C17 a_n65651_n57560# a_n65801_n57665# 0.00229f
C18 a_n65662_n58100# a_n65144_n58100# 0
C19 a_n65401_n58100# a_n65144_n58100# 0
C20 a_n65890_n58100# m2_n65790_n58100# 0
C21 a_n66133_n57222# a_n66085_n57248# 0.00188f
C22 a_n65144_n58100# m2_n65790_n58100# 0
C23 a_n65662_n58100# a_n65915_n57648# 0
C24 a_n66200_n57222# a_n66181_n57649# 0
C25 a_n66200_n57222# a_n66200_n57052# 0.06167f
C26 w_n66214_n57924# a_n65749_n57222# 0.00264f
C27 a_n65295_n57888# a_n66200_n57518# 0.00124f
C28 a_n65295_n57888# a_n66085_n57248# 0.16992f
C29 w_n66214_n57924# a_n65461_n57052# 0.09766f
C30 a_n65915_n57648# m2_n65790_n58100# 0.01513f
C31 a_n65660_n57880# m2_n65790_n58100# 0.00142f
C32 a_n65801_n57665# a_n65648_n57222# 0.00271f
C33 w_n66214_n57924# a_n65480_n57880# 0.01679f
C34 a_n65980_n58100# a_n65890_n58100# 0.00693f
C35 a_n66085_n57248# m1_n66200_n57023# 0.00687f
C36 a_n66200_n57518# a_n66085_n57248# 0
C37 a_n65941_n57880# a_n66200_n57888# 0.07885f
C38 a_n65371_n58100# a_n65602_n58100# 0.00172f
C39 a_n65371_n58100# a_n65950_n58100# 0.00756f
C40 a_n66181_n57649# a_n66200_n57888# 0.10939f
C41 a_n66200_n57052# a_n66200_n57888# 0
C42 w_n66214_n57924# a_n65890_n58100# 0.02766f
C43 w_n66214_n57924# a_n65144_n58100# 0.0286f
C44 a_n65037_n58100# a_n65461_n57052# 0
C45 w_n66214_n57924# a_n65915_n57648# 0.15771f
C46 w_n66214_n57924# a_n65660_n57880# 0.01297f
C47 a_n65401_n58100# a_n65941_n57880# 0
C48 a_n65471_n57544# a_n65461_n57052# 0.00132f
C49 m2_n65790_n58100# a_n65941_n57880# 0.01819f
C50 m2_n65790_n58100# a_n66181_n57649# 0.00367f
C51 a_n65144_n58100# a_n65037_n58100# 0.0054f
C52 a_n65801_n57665# a_n65602_n58100# 0
C53 a_n65371_n58100# a_n66200_n57888# 0
C54 a_n65203_n58100# a_n65461_n57052# 0
C55 a_n66133_n57222# a_n65749_n57222# 0
C56 a_n66200_n57222# a_n65801_n57665# 0.01259f
C57 a_n65144_n58100# a_n65203_n58100# 0.00218f
C58 a_n65371_n58100# a_n65401_n58100# 0.00502f
C59 a_n65662_n58100# a_n65371_n58100# 0.00765f
C60 w_n66214_n57924# a_n65941_n57880# 0.38296f
C61 w_n66214_n57924# a_n66181_n57649# 0.12244f
C62 w_n66214_n57924# a_n66200_n57052# 0.00265f
C63 a_n65371_n58100# m2_n65790_n58100# 0.00633f
C64 a_n65295_n57888# a_n65461_n57052# 0.03562f
C65 a_n65801_n57665# a_n66200_n57888# 0.0619f
C66 a_n65852_n57880# a_n66200_n57888# 0.00508f
C67 a_n65295_n57888# a_n65480_n57880# 0
C68 a_n65651_n57560# a_n66200_n57888# 0
C69 a_n65749_n57222# a_n66085_n57248# 0.0464f
C70 w_n66214_n57924# li_n65017_n58100# 0.03016f
C71 a_n65007_n58100# li_n65017_n58100# 0
C72 a_n65461_n57052# a_n66085_n57248# 0.24124f
C73 a_n65915_n57648# a_n65849_n57560# 0
C74 a_n65480_n57880# a_n66085_n57248# 0.00978f
C75 a_n65371_n58100# a_n65980_n58100# 0.00161f
C76 a_n65662_n58100# a_n65801_n57665# 0.00165f
C77 a_n65401_n58100# a_n65801_n57665# 0
C78 a_n65471_n57544# a_n65941_n57880# 0.00875f
C79 a_n65371_n58100# w_n66214_n57924# 0.49704f
C80 a_n65295_n57888# a_n65915_n57648# 0.09591f
C81 a_n65648_n57222# a_n66200_n57888# 0.00888f
C82 m2_n65790_n58100# a_n65801_n57665# 0.12947f
C83 a_n65852_n57880# m2_n65790_n58100# 0.00194f
C84 a_n65037_n58100# li_n65017_n58100# 0.00323f
C85 a_n65915_n57648# a_n66085_n57248# 0.15009f
C86 a_n65890_n58100# a_n65692_n58100# 0.00248f
C87 a_n65401_n58100# a_n65648_n57222# 0
C88 a_n65980_n58100# a_n65801_n57665# 0
C89 a_n65941_n57880# a_n65849_n57560# 0.00893f
C90 a_n65371_n58100# a_n65037_n58100# 0
C91 a_n66181_n57649# a_n65849_n57560# 0
C92 w_n66214_n57924# a_n65801_n57665# 0.24503f
C93 a_n65852_n57880# w_n66214_n57924# 0.01489f
C94 a_n65915_n57648# a_n65692_n58100# 0.0044f
C95 w_n66214_n57924# a_n65651_n57560# 0
C96 a_n65295_n57888# a_n65941_n57880# 0.18875f
C97 a_n65295_n57888# a_n66181_n57649# 0.05335f
C98 a_n65295_n57888# a_n66200_n57052# 0
C99 a_n66200_n57518# a_n65941_n57880# 0
C100 a_n65371_n58100# a_n65203_n58100# 0.02349f
C101 a_n66200_n57052# m1_n66200_n57023# 0.00304f
C102 a_n65941_n57880# a_n66085_n57248# 0.21462f
C103 a_n66181_n57649# a_n66085_n57248# 0.00385f
C104 a_n65749_n57222# a_n65461_n57052# 0.04148f
C105 a_n66200_n57052# a_n66085_n57248# 0.03827f
C106 w_n66214_n57924# a_n65648_n57222# 0
C107 a_n65662_n58100# a_n65602_n58100# 0.00316f
C108 a_n65401_n58100# a_n65602_n58100# 0.00243f
C109 a_n65480_n57880# a_n65461_n57052# 0.00218f
C110 a_n65471_n57544# a_n65801_n57665# 0.00269f
C111 a_n65692_n58100# a_n65941_n57880# 0
C112 m2_n65790_n58100# a_n65602_n58100# 0
C113 m2_n65790_n58100# a_n65950_n58100# 0.00161f
C114 a_n65371_n58100# a_n65295_n57888# 0.00187f
C115 a_n65144_n58100# a_n65461_n57052# 0
C116 a_n65915_n57648# a_n65749_n57222# 0.06228f
C117 a_n65371_n58100# a_n66085_n57248# 0
C118 a_n66200_n57222# m2_n65790_n58100# 0
C119 a_n65915_n57648# a_n65461_n57052# 0.13033f
C120 a_n65980_n58100# a_n65950_n58100# 0.00254f
C121 a_n65801_n57665# a_n65849_n57560# 0.00551f
C122 a_n66133_n57222# a_n65801_n57665# 0.00291f
C123 a_n65662_n58100# a_n66200_n57888# 0
C124 w_n66214_n57924# a_n65602_n58100# 0.02533f
C125 w_n66214_n57924# a_n65950_n58100# 0.08129f
C126 a_n65890_n58100# a_n65915_n57648# 0.00374f
C127 m2_n65790_n58100# a_n66200_n57888# 0.33447f
C128 a_n65371_n58100# a_n65692_n58100# 0.00165f
C129 a_n65295_n57888# a_n65801_n57665# 0.31103f
C130 a_n65852_n57880# a_n65295_n57888# 0
C131 a_n65295_n57888# a_n65651_n57560# 0.00171f
C132 a_n65801_n57665# m1_n66200_n57023# 0
C133 a_n66200_n57222# w_n66214_n57924# 0.00501f
C134 a_n66200_n57518# a_n65801_n57665# 0.00129f
C135 a_n65660_n57880# a_n65915_n57648# 0.00273f
C136 a_n65801_n57665# a_n66085_n57248# 0.22328f
C137 a_n65980_n58100# a_n66200_n57888# 0
C138 a_n65461_n57052# a_n65941_n57880# 0.0107f
C139 a_n65662_n58100# m2_n65790_n58100# 0.00157f
C140 a_n66181_n57649# a_n65461_n57052# 0
C141 a_n65480_n57880# a_n65941_n57880# 0.00749f
C142 w_n66214_n57924# a_n66200_n57888# 0.34073f
C143 a_n65801_n57665# a_n65692_n58100# 0
C144 a_n65890_n58100# a_n65941_n57880# 0
C145 a_n65461_n57052# li_n65017_n58100# 0
C146 a_n65648_n57222# a_n66085_n57248# 0.06222f
C147 a_n65980_n58100# m2_n65790_n58100# 0
C148 w_n66214_n57924# a_n65401_n58100# 0.03188f
C149 a_n65662_n58100# w_n66214_n57924# 0.07727f
C150 a_n65915_n57648# a_n65941_n57880# 0.33845f
C151 a_n65660_n57880# a_n65941_n57880# 0.01538f
C152 a_n65915_n57648# a_n66181_n57649# 0.02192f
C153 a_n65371_n58100# a_n65461_n57052# 0.01928f
C154 w_n66214_n57924# m2_n65790_n58100# 0.17386f
C155 a_n65371_n58100# a_n65890_n58100# 0.00166f
C156 a_n65371_n58100# a_n65144_n58100# 0.00145f
C157 a_n66200_n57222# a_n66133_n57222# 0.00959f
C158 a_n65980_n58100# w_n66214_n57924# 0.03054f
C159 a_n66085_n57248# a_n65602_n58100# 0.00418f
C160 a_n65371_n58100# a_n65915_n57648# 0
C161 a_n65749_n57222# a_n65801_n57665# 0.00399f
C162 a_n66200_n57888# a_n65849_n57560# 0
C163 a_n65801_n57665# a_n65461_n57052# 0.29164f
C164 a_n66200_n57222# m1_n66200_n57023# 0.0024f
C165 a_n66181_n57649# a_n65941_n57880# 0.00594f
C166 a_n66200_n57052# a_n66181_n57649# 0.004f
C167 a_n65480_n57880# a_n65801_n57665# 0.0028f
C168 a_n66200_n57222# a_n66085_n57248# 0.04233f
C169 a_n65692_n58100# a_n65602_n58100# 0.00693f
C170 a_n65295_n57888# a_n66200_n57888# 0.0968f
C171 a_n65144_n58100# a_n65801_n57665# 0
C172 w_n66214_n57924# a_n65037_n58100# 0.02128f
C173 a_n65749_n57222# a_n65648_n57222# 0.13586f
C174 a_n66200_n57518# a_n66200_n57888# 0.0022f
C175 a_n65648_n57222# a_n65461_n57052# 0.06164f
C176 a_n66085_n57248# a_n66200_n57888# 0.06427f
C177 m2_n65790_n58100# a_n65849_n57560# 0
C178 a_n65852_n57880# a_n65915_n57648# 0
C179 a_n65915_n57648# a_n65801_n57665# 0.27393f
C180 a_n65660_n57880# a_n65801_n57665# 0.00203f
C181 a_n65915_n57648# a_n65651_n57560# 0.00102f
C182 w_n66214_n57924# a_n65471_n57544# 0
C183 a_n65371_n58100# a_n65941_n57880# 0.0026f
C184 a_n65295_n57888# a_n65401_n58100# 0
C185 a_n65371_n58100# a_n66181_n57649# 0
C186 a_n65295_n57888# m2_n65790_n58100# 0.02291f
C187 w_n66214_n57924# a_n65203_n58100# 0.03649f
C188 a_n65692_n58100# a_n66200_n57888# 0
C189 a_n65662_n58100# a_n66085_n57248# 0
C190 a_n65401_n58100# a_n66085_n57248# 0
C191 m2_n65790_n58100# a_n66200_n57518# 0
C192 a_n65371_n58100# li_n65017_n58100# 0
C193 a_n65915_n57648# a_n65648_n57222# 0.01825f
C194 m2_n65790_n58100# a_n66085_n57248# 0.06654f
C195 w_n66214_n57924# a_n65849_n57560# 0
C196 a_n66133_n57222# w_n66214_n57924# 0.002f
C197 a_n65295_n57888# a_n65980_n58100# 0
C198 a_n65662_n58100# a_n65692_n58100# 0.00254f
C199 a_n65801_n57665# a_n65941_n57880# 0.20106f
C200 a_n65852_n57880# a_n65941_n57880# 0.01522f
C201 a_n65651_n57560# a_n65941_n57880# 0.00942f
C202 a_n66181_n57649# a_n65801_n57665# 0.00667f
C203 a_n65295_n57888# w_n66214_n57924# 0.23739f
C204 a_n65651_n57560# a_n66181_n57649# 0
C205 a_n66200_n57052# a_n65801_n57665# 0.00437f
C206 a_n65980_n58100# a_n66085_n57248# 0
C207 m2_n65790_n58100# a_n65692_n58100# 0
C208 w_n66214_n57924# m1_n66200_n57023# 0
C209 a_n66200_n57222# a_n65749_n57222# 0.00231f
C210 w_n66214_n57924# a_n66200_n57518# 0
C211 a_n65890_n58100# a_n65950_n58100# 0.00316f
C212 a_n65144_n58100# a_n65950_n58100# 0
C213 w_n66214_n57924# a_n66085_n57248# 0.31898f
R0 a_n65007_n58100# a_n65007_n58100.t0 675.429
R1 a_n65203_n58100# a_n65203_n58100.t0 237.204
R2 a_n65662_n58100# a_n65662_n58100.t0 184.689
R3 a_n65950_n58100# a_n65950_n58100.t0 184.689
R4 a_n65480_n57880# a_n65480_n57880.t0 53.1905
R5 a_n65660_n57880# a_n65660_n57880.t0 53.1905
R6 a_n65852_n57880# a_n65852_n57880.t0 53.1905
R7 a_n65295_n57888.t0 a_n65295_n57888# 437.211
R8 a_n65471_n57544# a_n65471_n57544.t0 45.0005
R9 a_n65651_n57560# a_n65651_n57560.t0 45.0005
R10 a_n65849_n57560# a_n65849_n57560.t0 50.6255
R11 a_n65941_n57880.n5 a_n65941_n57880.n6 99.0082
R12 a_n65941_n57880.n6 a_n65941_n57880.t0 26.251
R13 a_n65941_n57880.n6 a_n65941_n57880.t3 43.6617
R14 a_n65941_n57880.n4 a_n65941_n57880.n5 12.8005
R15 a_n65941_n57880.n3 a_n65941_n57880.n4 51.9534
R16 a_n65941_n57880.n3 a_n65941_n57880.n2 210.905
R17 a_n65941_n57880.n2 a_n65941_n57880.t1 29.5505
R18 a_n65941_n57880.n2 a_n65941_n57880.t2 35.4605
R19 a_n65941_n57880.n1 a_n65941_n57880.n3 311.046
R20 a_n65941_n57880# a_n65941_n57880.n1 28.5655
R21 a_n65941_n57880.n1 a_n65941_n57880.t4 29.5505
R22 a_n65941_n57880.n4 a_n65941_n57880.t5 322.863
R23 a_n65941_n57880.n5 a_n65941_n57880.n0 223.374
R24 a_n65941_n57880.n0 a_n65941_n57880.t6 250.548
R25 a_n65941_n57880.n0 a_n65941_n57880.t7 177.981
R26 a_n66200_n57518# a_n66200_n57518.t0 467.368
R27 a_n65648_n57222# a_n65648_n57222.n0 22.7032
R28 a_n65648_n57222.n0 a_n65648_n57222.t1 22.7032
R29 a_n65648_n57222.n0 a_n65648_n57222.t0 406.166
R30 a_n65749_n57222.t0 a_n65749_n57222# 114.352
R31 a_n66133_n57222# a_n66133_n57222.t0 38.9194
R32 a_n66200_n57222.t0 a_n66200_n57222# 207.774
R33 a_n66200_n57888.n0 a_n66200_n57888.t1 638.378
R34 a_n66200_n57888# a_n66200_n57888.n0 3.51836
R35 a_n66200_n57888.n0 a_n66200_n57888.t0 15.8309
R36 w_n66214_n57924.n0 w_n66214_n57924.t17 120.612
R37 w_n66214_n57924.n0 w_n66214_n57924.t15 188.959
R38 w_n66214_n57924.n32 w_n66214_n57924.n0 608.746
R39 w_n66214_n57924.n1 w_n66214_n57924.n42 9.3005
R40 w_n66214_n57924.n2 w_n66214_n57924.n3 4.5005
R41 w_n66214_n57924.n4 w_n66214_n57924.n5 4.5005
R42 w_n66214_n57924.n6 w_n66214_n57924.n7 4.5005
R43 w_n66214_n57924.n8 w_n66214_n57924.n9 4.5005
R44 w_n66214_n57924.n11 w_n66214_n57924.n21 4.5005
R45 w_n66214_n57924.n6 w_n66214_n57924.n22 9.3005
R46 w_n66214_n57924.n23 w_n66214_n57924.n41 9.3005
R47 w_n66214_n57924.n24 w_n66214_n57924.n39 9.3005
R48 w_n66214_n57924.n26 w_n66214_n57924.n25 9.3005
R49 w_n66214_n57924.n27 w_n66214_n57924.n38 9.3005
R50 w_n66214_n57924.n28 w_n66214_n57924.n37 9.3005
R51 w_n66214_n57924.n29 w_n66214_n57924.n35 9.3005
R52 w_n66214_n57924.n31 w_n66214_n57924.n30 9.3005
R53 w_n66214_n57924.n43 w_n66214_n57924.n44 6.8535
R54 w_n66214_n57924.n11 w_n66214_n57924.n43 0.0222965
R55 w_n66214_n57924.n2 w_n66214_n57924.n11 0.0821327
R56 w_n66214_n57924.n1 w_n66214_n57924.n2 0.0413163
R57 w_n66214_n57924.n4 w_n66214_n57924.n1 0.0413163
R58 w_n66214_n57924.n6 w_n66214_n57924.n4 0.0821327
R59 w_n66214_n57924.n8 w_n66214_n57924.n6 0.0821327
R60 w_n66214_n57924.n23 w_n66214_n57924.n8 0.0413163
R61 w_n66214_n57924.n24 w_n66214_n57924.n23 0.122949
R62 w_n66214_n57924.n26 w_n66214_n57924.n24 0.122949
R63 w_n66214_n57924.n27 w_n66214_n57924.n26 0.122949
R64 w_n66214_n57924.n28 w_n66214_n57924.n27 0.122949
R65 w_n66214_n57924.n29 w_n66214_n57924.n28 0.122949
R66 w_n66214_n57924.n31 w_n66214_n57924.n29 0.122949
R67 w_n66214_n57924.n32 w_n66214_n57924.n31 4.37628
R68 w_n66214_n57924.n43 w_n66214_n57924.n10 4.56115
R69 w_n66214_n57924.n44 w_n66214_n57924.t22 250.081
R70 w_n66214_n57924.n44 w_n66214_n57924.n42 15.8123
R71 w_n66214_n57924.n42 w_n66214_n57924.t13 698.289
R72 w_n66214_n57924.n42 w_n66214_n57924.n22 21.4593
R73 w_n66214_n57924.n22 w_n66214_n57924.n41 27.4829
R74 w_n66214_n57924.n41 w_n66214_n57924.t11 703.712
R75 w_n66214_n57924.n41 w_n66214_n57924.n39 10.9181
R76 w_n66214_n57924.n39 w_n66214_n57924.n40 313.168
R77 w_n66214_n57924.n39 w_n66214_n57924.t1 697.679
R78 w_n66214_n57924.n40 w_n66214_n57924.t24 39.4005
R79 w_n66214_n57924.n40 w_n66214_n57924.t20 37.4305
R80 w_n66214_n57924.n39 w_n66214_n57924.n25 20.7064
R81 w_n66214_n57924.n25 w_n66214_n57924.n38 27.4829
R82 w_n66214_n57924.n38 w_n66214_n57924.t9 703.712
R83 w_n66214_n57924.n38 w_n66214_n57924.n37 16.5652
R84 w_n66214_n57924.n37 w_n66214_n57924.t7 700.399
R85 w_n66214_n57924.n37 w_n66214_n57924.n35 0.376971
R86 w_n66214_n57924.n35 w_n66214_n57924.n36 223.704
R87 w_n66214_n57924.n36 w_n66214_n57924.t26 30.5355
R88 w_n66214_n57924.n36 w_n66214_n57924.t5 36.551
R89 w_n66214_n57924.n35 w_n66214_n57924.n30 31.624
R90 w_n66214_n57924.n30 w_n66214_n57924.n33 24.8476
R91 w_n66214_n57924.n34 w_n66214_n57924.n33 211.838
R92 w_n66214_n57924.t21 w_n66214_n57924.t12 398.517
R93 w_n66214_n57924.t12 w_n66214_n57924.t10 181.144
R94 w_n66214_n57924.t10 w_n66214_n57924.t18 16.1022
R95 w_n66214_n57924.t18 w_n66214_n57924.t23 169.069
R96 w_n66214_n57924.t23 w_n66214_n57924.t0 213.347
R97 w_n66214_n57924.t0 w_n66214_n57924.t19 4.02592
R98 w_n66214_n57924.t19 w_n66214_n57924.t2 169.069
R99 w_n66214_n57924.t2 w_n66214_n57924.t8 8.05135
R100 w_n66214_n57924.t8 w_n66214_n57924.t3 185.169
R101 w_n66214_n57924.t3 w_n66214_n57924.t25 169.069
R102 w_n66214_n57924.t25 w_n66214_n57924.t6 50.3183
R103 w_n66214_n57924.t6 w_n66214_n57924.t4 152.966
R104 w_n66214_n57924.t4 w_n66214_n57924.n34 318.009
R105 w_n66214_n57924.n34 w_n66214_n57924.t16 46.2929
R106 w_n66214_n57924.t16 w_n66214_n57924.t14 215.059
R107 w_n66214_n57924# w_n66214_n57924.t21 10117.3
R108 w_n66214_n57924.n33 w_n66214_n57924.n32 0.850602
R109 w_n66214_n57924.n12 w_n66214_n57924.n13 3.4105
R110 w_n66214_n57924.n14 w_n66214_n57924.n15 3.4105
R111 w_n66214_n57924.n16 w_n66214_n57924.n17 3.4105
R112 w_n66214_n57924.n10 w_n66214_n57924.n21 0.108608
R113 w_n66214_n57924.n21 w_n66214_n57924.n12 0.027527
R114 w_n66214_n57924.n3 w_n66214_n57924.n12 0.0815811
R115 w_n66214_n57924.n3 w_n66214_n57924.n14 0.0545541
R116 w_n66214_n57924.n5 w_n66214_n57924.n14 0.0545541
R117 w_n66214_n57924.n5 w_n66214_n57924.n16 0.0815811
R118 w_n66214_n57924.n7 w_n66214_n57924.n16 0.027527
R119 w_n66214_n57924.n7 w_n66214_n57924.n9 0.108608
R120 w_n66214_n57924.n13 w_n66214_n57924.n18 0.0292348
R121 w_n66214_n57924.n15 w_n66214_n57924.n19 3.4105
R122 w_n66214_n57924.n20 w_n66214_n57924.n17 0.0292348
R123 w_n66214_n57924.n10 w_n66214_n57924.n18 3.43926
R124 w_n66214_n57924.n15 w_n66214_n57924.n13 0.0574697
R125 w_n66214_n57924.n17 w_n66214_n57924.n15 0.0574697
R126 w_n66214_n57924.n9 w_n66214_n57924.n20 3.43926
R127 w_n66214_n57924.n18 w_n66214_n57924.n19 1.69615
R128 w_n66214_n57924.n20 w_n66214_n57924.n19 1.69615
R129 a_n66151_n57518.n0 a_n66151_n57518.t20 39.3755
R130 a_n66151_n57518.n0 a_n66151_n57518.t13 39.3755
R131 a_n66151_n57518.n21 a_n66151_n57518.n0 251.26
R132 a_n66151_n57518.n2 a_n66151_n57518.n1 9.3005
R133 a_n66151_n57518.n4 a_n66151_n57518.n3 9.3005
R134 a_n66151_n57518.n6 a_n66151_n57518.n5 9.3005
R135 a_n66151_n57518.n8 a_n66151_n57518.n7 9.3005
R136 a_n66151_n57518.n19 a_n66151_n57518.n1 27.8593
R137 a_n66151_n57518.n1 a_n66151_n57518.n3 36.1417
R138 a_n66151_n57518.n3 a_n66151_n57518.n5 36.1417
R139 a_n66151_n57518.n5 a_n66151_n57518.n21 18.824
R140 a_n66151_n57518.n7 a_n66151_n57518.n21 17.3181
R141 a_n66151_n57518.n12 a_n66151_n57518.n11 9.3005
R142 a_n66151_n57518.n14 a_n66151_n57518.n13 9.3005
R143 a_n66151_n57518.n7 a_n66151_n57518.n11 31.0674
R144 a_n66151_n57518.n11 a_n66151_n57518.n9 5.42088
R145 a_n66151_n57518.n13 a_n66151_n57518.n9 4.98327
R146 a_n66151_n57518.n13 a_n66151_n57518.n16 9.66968
R147 a_n66151_n57518.n16 a_n66151_n57518.n17 211.284
R148 a_n66151_n57518.n18 a_n66151_n57518.n19 3.82657
R149 a_n66151_n57518.n18 a_n66151_n57518.n2 2.44776
R150 a_n66151_n57518.n2 a_n66151_n57518.n4 0.122949
R151 a_n66151_n57518.n4 a_n66151_n57518.n6 0.122949
R152 a_n66151_n57518.n6 a_n66151_n57518.n8 0.122949
R153 a_n66151_n57518.n8 a_n66151_n57518.n12 0.122949
R154 a_n66151_n57518.n12 a_n66151_n57518.n14 0.122949
R155 a_n66151_n57518.n14 a_n66151_n57518.n15 0.493603
R156 a_n66151_n57518# a_n66151_n57518.n20 105.915
R157 a_n66151_n57518.n20 a_n66151_n57518.t16 39.0139
R158 a_n66151_n57518.n20 a_n66151_n57518.n18 123.421
R159 a_n66151_n57518.n19 a_n66151_n57518.t1 159.611
R160 a_n66151_n57518.n15 a_n66151_n57518.t7 1629.77
R161 a_n66151_n57518.t4 a_n66151_n57518.t15 123.945
R162 a_n66151_n57518.t0 a_n66151_n57518.t4 537.09
R163 a_n66151_n57518.t11 a_n66151_n57518.t0 1418.47
R164 a_n66151_n57518.t19 a_n66151_n57518.t11 578.404
R165 a_n66151_n57518.t12 a_n66151_n57518.t19 784.977
R166 a_n66151_n57518.t14 a_n66151_n57518.t12 20.6578
R167 a_n66151_n57518.t2 a_n66151_n57518.t14 516.433
R168 a_n66151_n57518.t9 a_n66151_n57518.t2 75.7439
R169 a_n66151_n57518.t3 a_n66151_n57518.t9 626.605
R170 a_n66151_n57518.t17 a_n66151_n57518.t3 537.09
R171 a_n66151_n57518.t5 a_n66151_n57518.t17 89.5154
R172 a_n66151_n57518.t7 a_n66151_n57518.t5 661.034
R173 a_n66151_n57518.n15 a_n66151_n57518.n16 7.00366
R174 a_n66151_n57518.n17 a_n66151_n57518.t18 30.938
R175 a_n66151_n57518.n17 a_n66151_n57518.t8 39.9583
R176 a_n66151_n57518.n9 a_n66151_n57518.n10 150.556
R177 a_n66151_n57518.n10 a_n66151_n57518.t10 61.6221
R178 a_n66151_n57518.n10 a_n66151_n57518.t6 61.6221
C214 m5_n66100_n58100# a_n66151_n57518# 0 $ **FLOATING
C215 m4_n65112_n58100# a_n66151_n57518# 0 $ **FLOATING
C216 m4_n65288_n58100# a_n66151_n57518# 0 $ **FLOATING
C217 m4_n65464_n58100# a_n66151_n57518# 0 $ **FLOATING
C218 m4_n65640_n58100# a_n66151_n57518# 0 $ **FLOATING
C219 m4_n65148_n58012# a_n66151_n57518# 0 $ **FLOATING
C220 m4_n65324_n58012# a_n66151_n57518# 0 $ **FLOATING
C221 m4_n65500_n58012# a_n66151_n57518# 0 $ **FLOATING
C222 m4_n65676_n58012# a_n66151_n57518# 0 $ **FLOATING
C223 m4_n65008_n57836# a_n66151_n57518# 0 $ **FLOATING
C224 m4_n65184_n57836# a_n66151_n57518# 0 $ **FLOATING
C225 m4_n65360_n57836# a_n66151_n57518# 0 $ **FLOATING
C226 m4_n65536_n57836# a_n66151_n57518# 0 $ **FLOATING
C227 m4_n65712_n57836# a_n66151_n57518# 0 $ **FLOATING
C228 m4_n65044_n57660# a_n66151_n57518# 0 $ **FLOATING
C229 m4_n65220_n57660# a_n66151_n57518# 0 $ **FLOATING
C230 m4_n65396_n57660# a_n66151_n57518# 0 $ **FLOATING
C231 m4_n65572_n57660# a_n66151_n57518# 0 $ **FLOATING
C232 m4_n65080_n57484# a_n66151_n57518# 0 $ **FLOATING
C233 m4_n65256_n57484# a_n66151_n57518# 0 $ **FLOATING
C234 m4_n65432_n57484# a_n66151_n57518# 0 $ **FLOATING
C235 m4_n65608_n57484# a_n66151_n57518# 0 $ **FLOATING
C236 m4_n65116_n57308# a_n66151_n57518# 0 $ **FLOATING
C237 m4_n65292_n57308# a_n66151_n57518# 0 $ **FLOATING
C238 m4_n65468_n57308# a_n66151_n57518# 0 $ **FLOATING
C239 m4_n65644_n57308# a_n66151_n57518# 0 $ **FLOATING
C240 m4_n65152_n57132# a_n66151_n57518# 0 $ **FLOATING
C241 m4_n65328_n57132# a_n66151_n57518# 0 $ **FLOATING
C242 m4_n65504_n57132# a_n66151_n57518# 0 $ **FLOATING
C243 m4_n65680_n57132# a_n66151_n57518# 0 $ **FLOATING
C244 m3_n65042_n58100# a_n66151_n57518# 0 $ **FLOATING
C245 m3_n65218_n58100# a_n66151_n57518# 0 $ **FLOATING
C246 m3_n65394_n58100# a_n66151_n57518# 0 $ **FLOATING
C247 m3_n65570_n58100# a_n66151_n57518# 0 $ **FLOATING
C248 m3_n65078_n57942# a_n66151_n57518# 0 $ **FLOATING
C249 m3_n65254_n57942# a_n66151_n57518# 0 $ **FLOATING
C250 m3_n65430_n57942# a_n66151_n57518# 0 $ **FLOATING
C251 m3_n65606_n57942# a_n66151_n57518# 0 $ **FLOATING
C252 m3_n65114_n57766# a_n66151_n57518# 0 $ **FLOATING
C253 m3_n65290_n57766# a_n66151_n57518# 0 $ **FLOATING
C254 m3_n65466_n57766# a_n66151_n57518# 0 $ **FLOATING
C255 m3_n65642_n57766# a_n66151_n57518# 0 $ **FLOATING
C256 m3_n65818_n57766# a_n66151_n57518# 0 $ **FLOATING
C257 m3_n65994_n57766# a_n66151_n57518# 0 $ **FLOATING
C258 m3_n66170_n57766# a_n66151_n57518# 0 $ **FLOATING
C259 m3_n65150_n57590# a_n66151_n57518# 0 $ **FLOATING
C260 m3_n65326_n57590# a_n66151_n57518# 0 $ **FLOATING
C261 m3_n65502_n57590# a_n66151_n57518# 0 $ **FLOATING
C262 m3_n65678_n57590# a_n66151_n57518# 0 $ **FLOATING
C263 m3_n65854_n57590# a_n66151_n57518# 0 $ **FLOATING
C264 m3_n66030_n57590# a_n66151_n57518# 0 $ **FLOATING
C265 m3_n66200_n57590# a_n66151_n57518# 0 $ **FLOATING
C266 m3_n65010_n57414# a_n66151_n57518# 0 $ **FLOATING
C267 m3_n65186_n57414# a_n66151_n57518# 0 $ **FLOATING
C268 m3_n65362_n57414# a_n66151_n57518# 0 $ **FLOATING
C269 m3_n65538_n57414# a_n66151_n57518# 0 $ **FLOATING
C270 m3_n65714_n57414# a_n66151_n57518# 0 $ **FLOATING
C271 m3_n65890_n57414# a_n66151_n57518# 0 $ **FLOATING
C272 m3_n66066_n57414# a_n66151_n57518# 0 $ **FLOATING
C273 m3_n66200_n57414# a_n66151_n57518# 0 $ **FLOATING
C274 m3_n65046_n57238# a_n66151_n57518# 0 $ **FLOATING
C275 m3_n65222_n57238# a_n66151_n57518# 0 $ **FLOATING
C276 m3_n65398_n57238# a_n66151_n57518# 0 $ **FLOATING
C277 m3_n65574_n57238# a_n66151_n57518# 0 $ **FLOATING
C278 m3_n65750_n57238# a_n66151_n57518# 0 $ **FLOATING
C279 m2_n65152_n58084# a_n66151_n57518# 0 $ **FLOATING
C280 m2_n65168_n57928# a_n66151_n57518# 0 $ **FLOATING
C281 m2_n65300_n57900# a_n66151_n57518# 0 $ **FLOATING
C282 m2_n65280_n57800# a_n66151_n57518# 0 $ **FLOATING
C283 m2_n65060_n57700# a_n66151_n57518# 0 $ **FLOATING
C284 m2_n65120_n57500# a_n66151_n57518# 0 $ **FLOATING
C285 m2_n65100_n57400# a_n66151_n57518# 0 $ **FLOATING
C286 m2_n65080_n57300# a_n66151_n57518# 0 $ **FLOATING
C287 m2_n65060_n57200# a_n66151_n57518# 0 $ **FLOATING
C288 m2_n65640_n58100# a_n66151_n57518# 0 $ **FLOATING
C289 m2_n65700_n57900# a_n66151_n57518# 0 $ **FLOATING
C290 m2_n65790_n58100# a_n66151_n57518# 0.16111f
C291 m2_n65960_n57700# a_n66151_n57518# 0 $ **FLOATING
C292 m2_n66120_n57772# a_n66151_n57518# 0 $ **FLOATING
C293 m2_n65940_n57600# a_n66151_n57518# 0 $ **FLOATING
C294 m2_n66040_n57600# a_n66151_n57518# 0 $ **FLOATING
C295 m2_n66140_n57600# a_n66151_n57518# 0 $ **FLOATING
C296 m2_n65920_n57500# a_n66151_n57518# 0 $ **FLOATING
C297 m2_n65980_n57300# a_n66151_n57518# 0 $ **FLOATING
C298 m2_n66200_n57460# a_n66151_n57518# 0 $ **FLOATING
C299 m1_n65070_n57790# a_n66151_n57518# 0 $ **FLOATING
C300 m1_n65170_n57790# a_n66151_n57518# 0 $ **FLOATING
C301 m1_n65270_n57790# a_n66151_n57518# 0 $ **FLOATING
C302 m1_n65370_n57790# a_n66151_n57518# 0 $ **FLOATING
C303 m1_n65470_n57790# a_n66151_n57518# 0 $ **FLOATING
C304 m1_n65570_n57790# a_n66151_n57518# 0 $ **FLOATING
C305 m1_n65050_n57690# a_n66151_n57518# 0 $ **FLOATING
C306 m1_n65030_n57590# a_n66151_n57518# 0 $ **FLOATING
C307 m1_n65010_n57490# a_n66151_n57518# 0 $ **FLOATING
C308 m1_n65110_n57490# a_n66151_n57518# 0 $ **FLOATING
C309 m1_n66200_n57023# a_n66151_n57518# 0.0088f
C310 li_n65017_n58100# a_n66151_n57518# 0.01322f
C311 li_n65006_n57726# a_n66151_n57518# 0 $ **FLOATING
C312 a_n65007_n58100# a_n66151_n57518# 0 $ **FLOATING
C313 a_n65203_n58100# a_n66151_n57518# 0.00652f $ **FLOATING
C314 a_n65037_n58100# a_n66151_n57518# 0.0068f $ **FLOATING
C315 a_n65144_n58100# a_n66151_n57518# 0.00161f $ **FLOATING
C316 a_n65371_n58100# a_n66151_n57518# 0.23712f $ **FLOATING
C317 a_n65662_n58100# a_n66151_n57518# 0.01044f $ **FLOATING
C318 a_n65950_n58100# a_n66151_n57518# 0.01044f $ **FLOATING
C319 a_n65401_n58100# a_n66151_n57518# 0.00123f $ **FLOATING
C320 a_n65602_n58100# a_n66151_n57518# 0 $ **FLOATING
C321 a_n65692_n58100# a_n66151_n57518# 0 $ **FLOATING
C322 a_n65890_n58100# a_n66151_n57518# 0 $ **FLOATING
C323 a_n65980_n58100# a_n66151_n57518# 0.00319f $ **FLOATING
C324 a_n65480_n57880# a_n66151_n57518# 0 $ **FLOATING
C325 a_n65660_n57880# a_n66151_n57518# 0 $ **FLOATING
C326 a_n65852_n57880# a_n66151_n57518# 0 $ **FLOATING
C327 a_n65295_n57888# a_n66151_n57518# 0.309f $ **FLOATING
C328 a_n65471_n57544# a_n66151_n57518# 0.00549f $ **FLOATING
C329 a_n65651_n57560# a_n66151_n57518# 0.00339f $ **FLOATING
C330 a_n65849_n57560# a_n66151_n57518# 0.00208f $ **FLOATING
C331 a_n65941_n57880# a_n66151_n57518# 0.30041f $ **FLOATING
C332 a_n66200_n57518# a_n66151_n57518# 0.00416f $ **FLOATING
C333 a_n65801_n57665# a_n66151_n57518# 1.15715f $ **FLOATING
C334 a_n66181_n57649# a_n66151_n57518# 0.21943f $ **FLOATING
C335 a_n65648_n57222# a_n66151_n57518# 0.21271f $ **FLOATING
C336 a_n65749_n57222# a_n66151_n57518# 0.11319f $ **FLOATING
C337 a_n66133_n57222# a_n66151_n57518# 0.00893f $ **FLOATING
C338 a_n66200_n57222# a_n66151_n57518# 0.12376f $ **FLOATING
C339 a_n65461_n57052# a_n66151_n57518# 0.38176f $ **FLOATING
C340 a_n65915_n57648# a_n66151_n57518# 0.33313f $ **FLOATING
C341 a_n66200_n57888# a_n66151_n57518# 0.33092f $ **FLOATING
C342 a_n66085_n57248# a_n66151_n57518# 1.1461f $ **FLOATING
C343 a_n66200_n57052# a_n66151_n57518# 0.1128f $ **FLOATING
C344 w_n66214_n57924# a_n66151_n57518# 2.67126f $ **FLOATING
C345 a_n66151_n57518# a_n66151_n57518# 0 $ **FLOATING
C346 a_n66151_n57518.t13 a_n66151_n57518# 0 $ **FLOATING
C347 a_n66151_n57518.n0 a_n66151_n57518# 0 $ **FLOATING
C348 a_n66151_n57518.n1 a_n66151_n57518# 0 $ **FLOATING
C349 a_n66151_n57518.n2 a_n66151_n57518# 0 $ **FLOATING
C350 a_n66151_n57518.n3 a_n66151_n57518# 0 $ **FLOATING
C351 a_n66151_n57518.n4 a_n66151_n57518# 0 $ **FLOATING
C352 a_n66151_n57518.n5 a_n66151_n57518# 0 $ **FLOATING
C353 a_n66151_n57518.n6 a_n66151_n57518# 0 $ **FLOATING
C354 a_n66151_n57518.n7 a_n66151_n57518# 0 $ **FLOATING
C355 a_n66151_n57518.n8 a_n66151_n57518# 0 $ **FLOATING
C356 a_n66151_n57518.n9 a_n66151_n57518# 0 $ **FLOATING
C357 a_n66151_n57518.t10 a_n66151_n57518# 0 $ **FLOATING
C358 a_n66151_n57518.t6 a_n66151_n57518# 0 $ **FLOATING
C359 a_n66151_n57518.n10 a_n66151_n57518# 0 $ **FLOATING
C360 a_n66151_n57518.n11 a_n66151_n57518# 0 $ **FLOATING
C361 a_n66151_n57518.n12 a_n66151_n57518# 0 $ **FLOATING
C362 a_n66151_n57518.n13 a_n66151_n57518# 0 $ **FLOATING
C363 a_n66151_n57518.n14 a_n66151_n57518# 0 $ **FLOATING
C364 a_n66151_n57518.n15 a_n66151_n57518# 0 $ **FLOATING
C365 a_n66151_n57518.n16 a_n66151_n57518# 0 $ **FLOATING
C366 a_n66151_n57518.t18 a_n66151_n57518# 0 $ **FLOATING
C367 a_n66151_n57518.t8 a_n66151_n57518# 0 $ **FLOATING
C368 a_n66151_n57518.n17 a_n66151_n57518# 0 $ **FLOATING
C369 a_n66151_n57518.t4 a_n66151_n57518# 0 $ **FLOATING
C370 a_n66151_n57518.t0 a_n66151_n57518# 0 $ **FLOATING
C371 a_n66151_n57518.t14 a_n66151_n57518# 0 $ **FLOATING
C372 a_n66151_n57518.t9 a_n66151_n57518# 0 $ **FLOATING
C373 a_n66151_n57518.t5 a_n66151_n57518# 0 $ **FLOATING
C374 a_n66151_n57518.t15 a_n66151_n57518# 0 $ **FLOATING
C375 a_n66151_n57518.t11 a_n66151_n57518# 0 $ **FLOATING
C376 a_n66151_n57518.t19 a_n66151_n57518# 0 $ **FLOATING
C377 a_n66151_n57518.t12 a_n66151_n57518# 0 $ **FLOATING
C378 a_n66151_n57518.t2 a_n66151_n57518# 0 $ **FLOATING
C379 a_n66151_n57518.t3 a_n66151_n57518# 0 $ **FLOATING
C380 a_n66151_n57518.t17 a_n66151_n57518# 0 $ **FLOATING
C381 a_n66151_n57518.t7 a_n66151_n57518# 0 $ **FLOATING
C382 a_n66151_n57518.n18 a_n66151_n57518# 0 $ **FLOATING
C383 a_n66151_n57518.n19 a_n66151_n57518# 0 $ **FLOATING
C384 a_n66151_n57518.t1 a_n66151_n57518# 0 $ **FLOATING
C385 a_n66151_n57518.n20 a_n66151_n57518# 0 $ **FLOATING
C386 a_n66151_n57518.t16 a_n66151_n57518# 0 $ **FLOATING
C387 a_n66151_n57518.n21 a_n66151_n57518# 0 $ **FLOATING
C388 a_n66151_n57518.t20 a_n66151_n57518# 0 $ **FLOATING
C389 w_n66214_n57924.t15 a_n66151_n57518# 0 $ **FLOATING
C390 w_n66214_n57924.n0 a_n66151_n57518# 0 $ **FLOATING
C391 w_n66214_n57924.n1 a_n66151_n57518# 0 $ **FLOATING
C392 w_n66214_n57924.n2 a_n66151_n57518# 0 $ **FLOATING
C393 w_n66214_n57924.n3 a_n66151_n57518# 0 $ **FLOATING
C394 w_n66214_n57924.n4 a_n66151_n57518# 0 $ **FLOATING
C395 w_n66214_n57924.n5 a_n66151_n57518# 0 $ **FLOATING
C396 w_n66214_n57924.n6 a_n66151_n57518# 0 $ **FLOATING
C397 w_n66214_n57924.n7 a_n66151_n57518# 0 $ **FLOATING
C398 w_n66214_n57924.n8 a_n66151_n57518# 0 $ **FLOATING
C399 w_n66214_n57924.n9 a_n66151_n57518# 0 $ **FLOATING
C400 w_n66214_n57924.n10 a_n66151_n57518# 0 $ **FLOATING
C401 w_n66214_n57924.n11 a_n66151_n57518# 0 $ **FLOATING
C402 w_n66214_n57924.n12 a_n66151_n57518# 0 $ **FLOATING
C403 w_n66214_n57924.n13 a_n66151_n57518# 0 $ **FLOATING
C404 w_n66214_n57924.n14 a_n66151_n57518# 0 $ **FLOATING
C405 w_n66214_n57924.n15 a_n66151_n57518# 0 $ **FLOATING
C406 w_n66214_n57924.n16 a_n66151_n57518# 0 $ **FLOATING
C407 w_n66214_n57924.n17 a_n66151_n57518# 0 $ **FLOATING
C408 w_n66214_n57924.n18 a_n66151_n57518# 0 $ **FLOATING
C409 w_n66214_n57924.n19 a_n66151_n57518# 0 $ **FLOATING
C410 w_n66214_n57924.n20 a_n66151_n57518# 0 $ **FLOATING
C411 w_n66214_n57924.n21 a_n66151_n57518# 0 $ **FLOATING
C412 w_n66214_n57924.n22 a_n66151_n57518# 0 $ **FLOATING
C413 w_n66214_n57924.n23 a_n66151_n57518# 0 $ **FLOATING
C414 w_n66214_n57924.n24 a_n66151_n57518# 0 $ **FLOATING
C415 w_n66214_n57924.n25 a_n66151_n57518# 0 $ **FLOATING
C416 w_n66214_n57924.n26 a_n66151_n57518# 0 $ **FLOATING
C417 w_n66214_n57924.n27 a_n66151_n57518# 0 $ **FLOATING
C418 w_n66214_n57924.n28 a_n66151_n57518# 0 $ **FLOATING
C419 w_n66214_n57924.n29 a_n66151_n57518# 0 $ **FLOATING
C420 w_n66214_n57924.n30 a_n66151_n57518# 0 $ **FLOATING
C421 w_n66214_n57924.n31 a_n66151_n57518# 0 $ **FLOATING
C422 w_n66214_n57924.n32 a_n66151_n57518# 0 $ **FLOATING
C423 w_n66214_n57924.n33 a_n66151_n57518# 0 $ **FLOATING
C424 w_n66214_n57924.n34 a_n66151_n57518# 0 $ **FLOATING
C425 w_n66214_n57924.t21 a_n66151_n57518# 0 $ **FLOATING
C426 w_n66214_n57924.t18 a_n66151_n57518# 0 $ **FLOATING
C427 w_n66214_n57924.t23 a_n66151_n57518# 0 $ **FLOATING
C428 w_n66214_n57924.t19 a_n66151_n57518# 0 $ **FLOATING
C429 w_n66214_n57924.t2 a_n66151_n57518# 0 $ **FLOATING
C430 w_n66214_n57924.t3 a_n66151_n57518# 0 $ **FLOATING
C431 w_n66214_n57924.t25 a_n66151_n57518# 0 $ **FLOATING
C432 w_n66214_n57924.t4 a_n66151_n57518# 0 $ **FLOATING
C433 w_n66214_n57924.t12 a_n66151_n57518# 0 $ **FLOATING
C434 w_n66214_n57924.t10 a_n66151_n57518# 0 $ **FLOATING
C435 w_n66214_n57924.t0 a_n66151_n57518# 0 $ **FLOATING
C436 w_n66214_n57924.t8 a_n66151_n57518# 0 $ **FLOATING
C437 w_n66214_n57924.t6 a_n66151_n57518# 0 $ **FLOATING
C438 w_n66214_n57924.t16 a_n66151_n57518# 0 $ **FLOATING
C439 w_n66214_n57924.t14 a_n66151_n57518# 0 $ **FLOATING
C440 w_n66214_n57924.n35 a_n66151_n57518# 0 $ **FLOATING
C441 w_n66214_n57924.n36 a_n66151_n57518# 0 $ **FLOATING
C442 w_n66214_n57924.t26 a_n66151_n57518# 0 $ **FLOATING
C443 w_n66214_n57924.t5 a_n66151_n57518# 0 $ **FLOATING
C444 w_n66214_n57924.n37 a_n66151_n57518# 0 $ **FLOATING
C445 w_n66214_n57924.t7 a_n66151_n57518# 0 $ **FLOATING
C446 w_n66214_n57924.n38 a_n66151_n57518# 0 $ **FLOATING
C447 w_n66214_n57924.t9 a_n66151_n57518# 0 $ **FLOATING
C448 w_n66214_n57924.n39 a_n66151_n57518# 0 $ **FLOATING
C449 w_n66214_n57924.n40 a_n66151_n57518# 0 $ **FLOATING
C450 w_n66214_n57924.t24 a_n66151_n57518# 0 $ **FLOATING
C451 w_n66214_n57924.t20 a_n66151_n57518# 0 $ **FLOATING
C452 w_n66214_n57924.t1 a_n66151_n57518# 0 $ **FLOATING
C453 w_n66214_n57924.n41 a_n66151_n57518# 0 $ **FLOATING
C454 w_n66214_n57924.t11 a_n66151_n57518# 0 $ **FLOATING
C455 w_n66214_n57924.n42 a_n66151_n57518# 0 $ **FLOATING
C456 w_n66214_n57924.t13 a_n66151_n57518# 0 $ **FLOATING
C457 w_n66214_n57924.n43 a_n66151_n57518# 0 $ **FLOATING
C458 w_n66214_n57924.n44 a_n66151_n57518# 0 $ **FLOATING
C459 w_n66214_n57924.t22 a_n66151_n57518# 0 $ **FLOATING
C460 w_n66214_n57924.t17 a_n66151_n57518# 0 $ **FLOATING
C461 a_n66200_n57888.t0 a_n66151_n57518# 0 $ **FLOATING
C462 a_n66200_n57888.n0 a_n66151_n57518# 0 $ **FLOATING
C463 a_n66200_n57888.t1 a_n66151_n57518# 0 $ **FLOATING
C464 a_n66200_n57222.t0 a_n66151_n57518# 0 $ **FLOATING
C465 a_n66133_n57222.t0 a_n66151_n57518# 0 $ **FLOATING
C466 a_n65749_n57222.t0 a_n66151_n57518# 0 $ **FLOATING
C467 a_n65648_n57222.n0 a_n66151_n57518# 0 $ **FLOATING
C468 a_n65648_n57222.t0 a_n66151_n57518# 0 $ **FLOATING
C469 a_n65648_n57222.t1 a_n66151_n57518# 0 $ **FLOATING
C470 a_n66200_n57518.t0 a_n66151_n57518# 0 $ **FLOATING
C471 a_n65941_n57880.t0 a_n66151_n57518# 0 $ **FLOATING
C472 a_n65941_n57880.t7 a_n66151_n57518# 0 $ **FLOATING
C473 a_n65941_n57880.t6 a_n66151_n57518# 0 $ **FLOATING
C474 a_n65941_n57880.n0 a_n66151_n57518# 0 $ **FLOATING
C475 a_n65941_n57880.t5 a_n66151_n57518# 0 $ **FLOATING
C476 a_n65941_n57880.n1 a_n66151_n57518# 0 $ **FLOATING
C477 a_n65941_n57880.t4 a_n66151_n57518# 0 $ **FLOATING
C478 a_n65941_n57880.n2 a_n66151_n57518# 0 $ **FLOATING
C479 a_n65941_n57880.t1 a_n66151_n57518# 0 $ **FLOATING
C480 a_n65941_n57880.t2 a_n66151_n57518# 0 $ **FLOATING
C481 a_n65941_n57880.n3 a_n66151_n57518# 0 $ **FLOATING
C482 a_n65941_n57880.n4 a_n66151_n57518# 0 $ **FLOATING
C483 a_n65941_n57880.n5 a_n66151_n57518# 0 $ **FLOATING
C484 a_n65941_n57880.t3 a_n66151_n57518# 0 $ **FLOATING
C485 a_n65941_n57880.n6 a_n66151_n57518# 0 $ **FLOATING
C486 a_n65849_n57560.t0 a_n66151_n57518# 0 $ **FLOATING
C487 a_n65651_n57560.t0 a_n66151_n57518# 0 $ **FLOATING
C488 a_n65471_n57544.t0 a_n66151_n57518# 0 $ **FLOATING
C489 a_n65295_n57888.t0 a_n66151_n57518# 0 $ **FLOATING
C490 a_n65852_n57880.t0 a_n66151_n57518# 0 $ **FLOATING
C491 a_n65660_n57880.t0 a_n66151_n57518# 0 $ **FLOATING
C492 a_n65480_n57880.t0 a_n66151_n57518# 0 $ **FLOATING
C493 a_n65950_n58100.t0 a_n66151_n57518# 0 $ **FLOATING
C494 a_n65662_n58100.t0 a_n66151_n57518# 0 $ **FLOATING
C495 a_n65203_n58100.t0 a_n66151_n57518# 0 $ **FLOATING
C496 a_n65007_n58100.t0 a_n66151_n57518# 0 $ **FLOATING
.ends
