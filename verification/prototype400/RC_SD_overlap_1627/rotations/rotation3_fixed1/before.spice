* NGSPICE file created from RotatedCrop.ext - technology: sky130A

.subckt RotatedCrop
X0 a_57396_n65284# a_57370_n65314# w_57628_n66214# w_57628_n66214# sky130_fd_pr__pfet_01v8 ad=0.3304 pd=2.83 as=0.1934 ps=1.475 w=1.12 l=0.15
X1 a_58036_n65662# a_58010_n65692# w_57628_n66214# w_57628_n66214# sky130_fd_pr__pfet_01v8 ad=0.048 pd=0.62 as=0.0912 ps=1.21 w=0.32 l=0.15
X2 a_58036_n65371# a_58010_n65401# w_57628_n66214# w_57628_n66214# sky130_fd_pr__pfet_01v8 ad=0.1088 pd=1.32 as=0.096 ps=1.24 w=0.32 l=0.15
X3 w_57628_n66214# a_57344_n66181# a_57000_n65706# w_57628_n66214# sky130_fd_pr__pfet_01v8 ad=0.3192 pd=2.81 as=0.1232 ps=2.46 w=1.12 l=0.15
X4 a_57074_n65648# a_57000_n65461# a_57074_n66055# a_57074_n66055# sky130_fd_pr__nfet_01v8_lvt ad=0.2109 pd=2.05 as=0.3361 ps=1.68 w=0.74 l=0.15
X5 a_57074_n66055# a_57318_n65795# a_57416_n65471# a_57074_n66055# sky130_fd_pr__nfet_01v8_lvt ad=0.1389 pd=1.135 as=0.0768 ps=0.88 w=0.64 l=0.15
X6 a_57432_n65849# a_57000_n65592# a_57370_n65314# a_57074_n66055# sky130_fd_pr__nfet_01v8_lvt ad=0.0864 pd=0.91 as=0.1733 ps=1.85 w=0.64 l=0.15
X7 a_57074_n66055# a_57000_n66085# a_57074_n66133# a_57074_n66055# sky130_fd_pr__nfet_01v8_lvt ad=0.2109 pd=2.05 as=0.0888 ps=0.98 w=0.74 l=0.15
X8 a_57074_n66055# a_57000_n65592# a_57074_n65648# a_57074_n66055# sky130_fd_pr__nfet_01v8_lvt ad=0.3361 pd=1.68 as=0.1036 ps=1.02 w=0.74 l=0.15
X9 a_57396_n65284# a_57370_n65314# a_57074_n66055# a_57074_n66055# sky130_fd_pr__nfet_01v8_lvt ad=0.2081 pd=2.05 as=0.1389 ps=1.135 w=0.74 l=0.15
X10 a_57680_n65852# a_57000_n65592# a_57370_n65314# w_57628_n66214# sky130_fd_pr__pfet_01v8 ad=0.135 pd=1.27 as=0.295 ps=2.59 w=1 l=0.15
X11 w_57628_n66214# a_57318_n65795# a_57680_n65852# w_57628_n66214# sky130_fd_pr__pfet_01v8 ad=0.195 pd=1.39 as=0.135 ps=1.27 w=1 l=0.15
X12 w_57628_n66214# a_58010_n65890# a_58036_n65950# w_57628_n66214# sky130_fd_pr__pfet_01v8 ad=0.0912 pd=1.21 as=0.048 ps=0.62 w=0.32 l=0.15
X13 a_58036_n65950# a_58010_n65980# w_57628_n66214# w_57628_n66214# sky130_fd_pr__pfet_01v8 ad=0.048 pd=0.62 as=0.0912 ps=1.21 w=0.32 l=0.15
X14 a_58051_n65007# a_58025_n65037# w_57628_n66214# w_57628_n66214# sky130_fd_pr__pfet_01v8 ad=8.575m pd=0.56 as=0.04715 ps=0.63 w=0.245 l=0.15
X15 a_57074_n66055# a_57344_n66181# a_57370_n66200# a_57074_n66055# sky130_fd_pr__nfet_01v8_lvt ad=0.2109 pd=2.05 as=0.0703 ps=1.67 w=0.74 l=0.15
X16 a_57680_n65480# a_57000_n66085# a_57370_n65314# w_57628_n66214# sky130_fd_pr__pfet_01v8 ad=0.135 pd=1.27 as=0.165 ps=1.33 w=1 l=0.15
X17 a_57074_n66055# a_57318_n65795# a_57432_n65849# a_57074_n66055# sky130_fd_pr__nfet_01v8_lvt ad=0.1344 pd=1.06 as=0.0864 ps=0.91 w=0.64 l=0.15
X18 a_57074_n65648# a_57000_n65706# a_57074_n65749# a_57074_n66055# sky130_fd_pr__nfet_01v8_lvt ad=0.1036 pd=1.02 as=0.2627 ps=2.19 w=0.74 l=0.15
X19 a_57680_n65660# a_57000_n65592# w_57628_n66214# w_57628_n66214# sky130_fd_pr__pfet_01v8 ad=0.135 pd=1.27 as=0.195 ps=1.39 w=1 l=0.15
X20 a_57416_n65471# a_57000_n66085# a_57370_n65314# a_57074_n66055# sky130_fd_pr__nfet_01v8_lvt ad=0.0768 pd=0.88 as=0.1222 ps=1.08 w=0.64 l=0.15
X21 w_57628_n66214# a_58010_n65602# a_58036_n65662# w_57628_n66214# sky130_fd_pr__pfet_01v8 ad=0.0912 pd=1.21 as=0.048 ps=0.62 w=0.32 l=0.15
X22 a_57432_n65651# a_57000_n65592# a_57074_n66055# a_57074_n66055# sky130_fd_pr__nfet_01v8_lvt ad=0.0768 pd=0.88 as=0.1344 ps=1.06 w=0.64 l=0.15
X23 w_57628_n66214# a_58025_n65144# a_58051_n65203# w_57628_n66214# sky130_fd_pr__pfet_01v8 ad=0.04715 pd=0.63 as=0.07227 ps=1.08 w=0.245 l=0.15
X24 w_57628_n66214# a_57318_n65795# a_57680_n65480# w_57628_n66214# sky130_fd_pr__pfet_01v8 ad=0.1934 pd=1.475 as=0.135 ps=1.27 w=1 l=0.15
X25 a_57370_n65314# a_57000_n66085# a_57680_n65660# w_57628_n66214# sky130_fd_pr__pfet_01v8 ad=0.165 pd=1.33 as=0.135 ps=1.27 w=1 l=0.15
X26 a_57074_n66133# a_57000_n66200# a_57074_n66200# a_57074_n66055# sky130_fd_pr__nfet_01v8_lvt ad=0.0888 pd=0.98 as=0.1369 ps=1.85 w=0.74 l=0.15
X27 a_57370_n65314# a_57000_n66085# a_57432_n65651# a_57074_n66055# sky130_fd_pr__nfet_01v8_lvt ad=0.1222 pd=1.08 as=0.0768 ps=0.88 w=0.64 l=0.15
C0 a_57680_n65480# a_57000_n65706# 0
C1 a_57074_n66200# a_57074_n66133# 0.00959f
C2 a_58036_n65662# a_58010_n65692# 0.00254f
C3 li_58047_n65017# a_58025_n65037# 0.00323f
C4 a_57680_n65480# a_57000_n65461# 0.00218f
C5 a_58010_n65602# a_57000_n66085# 0.00416f
C6 a_58010_n65602# a_57318_n65795# 0
C7 li_58047_n65017# a_58036_n65371# 0
C8 a_57074_n65749# a_57000_n65592# 0.06228f
C9 a_58010_n65401# a_57000_n65461# 0.00175f
C10 a_57432_n65651# a_57370_n65314# 0.00942f
C11 a_57318_n65795# a_58010_n65692# 0
C12 a_58036_n65371# a_57000_n65592# 0
C13 a_58036_n65371# a_58025_n65037# 0
C14 a_57370_n65314# a_57432_n65849# 0.00893f
C15 a_57680_n65480# w_57628_n66214# 0.01679f
C16 a_57370_n66200# m2_57000_n65790# 0
C17 a_57370_n66200# a_57000_n65706# 0.0022f
C18 a_58010_n65401# w_57628_n66214# 0.03188f
C19 a_58010_n65980# a_57396_n65284# 0
C20 a_57680_n65852# a_57370_n65314# 0.01522f
C21 a_58010_n65602# a_57370_n65314# 0
C22 a_57370_n65314# a_58010_n65692# 0
C23 a_57344_n66181# a_57000_n66085# 0.00385f
C24 a_58036_n65950# m2_57000_n65790# 0.00161f
C25 a_57344_n66181# a_57318_n65795# 0.00662f
C26 a_58036_n65662# m2_57000_n65790# 0.00157f
C27 a_58036_n65662# a_57000_n65706# 0
C28 a_57370_n66200# w_57628_n66214# 0
C29 a_57000_n65592# a_57680_n65660# 0.00273f
C30 a_57000_n66085# m2_57000_n65790# 0.06654f
C31 a_57000_n66085# a_57000_n65706# 0.06427f
C32 a_57344_n66181# a_57000_n66200# 0.004f
C33 a_57318_n65795# a_57000_n65706# 0.06121f
C34 a_57000_n66085# a_57000_n65461# 0.24124f
C35 a_57318_n65795# m2_57000_n65790# 0.12987f
C36 a_57074_n65648# a_57000_n65592# 0.01825f
C37 a_57318_n65795# a_57000_n65461# 0.29057f
C38 a_57074_n65648# a_57074_n65749# 0.13586f
C39 a_57000_n65706# a_57000_n66200# 0
C40 a_58036_n65371# a_57074_n65648# 0
C41 a_57000_n65592# a_57396_n65284# 0.09591f
C42 a_58010_n65890# a_58010_n65692# 0.00248f
C43 a_58036_n65950# w_57628_n66214# 0.08129f
C44 a_58036_n65371# a_57396_n65284# 0.00187f
C45 a_58036_n65662# w_57628_n66214# 0.07727f
C46 a_58051_n65203# a_57000_n65461# 0
C47 a_57000_n66085# w_57628_n66214# 0.31846f
C48 a_57318_n65795# w_57628_n66214# 0.24396f
C49 a_57344_n66181# a_57370_n65314# 0.00594f
C50 a_58025_n65144# a_58025_n65037# 0.0054f
C51 a_57432_n65651# a_57000_n65592# 0.00102f
C52 m1_57000_n66200# a_57074_n66200# 0.0024f
C53 w_57628_n66214# a_57000_n66200# 0.00265f
C54 a_58025_n65144# a_58036_n65371# 0.00145f
C55 a_57074_n66133# w_57628_n66214# 0.00205f
C56 a_57000_n65592# a_57432_n65849# 0
C57 a_57370_n65314# m2_57000_n65790# 0.01819f
C58 a_57370_n65314# a_57000_n65706# 0.07885f
C59 a_57370_n65314# a_57000_n65461# 0.0107f
C60 a_58051_n65203# w_57628_n66214# 0.03649f
C61 a_57074_n66200# a_57074_n65749# 0.00231f
C62 a_57680_n65852# a_57000_n65592# 0
C63 a_58010_n65602# a_57000_n65592# 0
C64 a_57370_n65314# w_57628_n66214# 0.38297f
C65 a_57000_n66085# a_57680_n65480# 0.00978f
C66 a_58010_n65890# m2_57000_n65790# 0
C67 a_57318_n65795# a_57680_n65480# 0.0028f
C68 a_58010_n65692# a_57000_n65592# 0.0044f
C69 a_58036_n65371# a_58010_n65602# 0.00172f
C70 a_57416_n65471# a_57396_n65284# 0.00285f
C71 a_57000_n66085# a_58010_n65401# 0
C72 a_58036_n65371# a_58010_n65692# 0.00165f
C73 a_57318_n65795# a_58010_n65401# 0
C74 a_58010_n65980# a_57000_n65706# 0
C75 a_58010_n65980# m2_57000_n65790# 0
C76 a_58010_n65890# w_57628_n66214# 0.02766f
C77 a_57370_n66200# a_57000_n66085# 0
C78 a_57370_n66200# a_57318_n65795# 0.00129f
C79 a_57432_n65651# a_57396_n65284# 0.00171f
C80 a_57370_n65314# a_57680_n65480# 0.00749f
C81 a_57396_n65284# a_57432_n65849# 0.00194f
C82 a_58010_n65401# a_57370_n65314# 0
C83 a_57344_n66181# a_57000_n65592# 0.02192f
C84 a_58010_n65980# w_57628_n66214# 0.03054f
C85 a_57344_n66181# a_58036_n65371# 0
C86 a_58036_n65662# a_57000_n66085# 0
C87 li_58047_n65017# a_57000_n65461# 0
C88 a_57000_n65592# m2_57000_n65790# 0.01513f
C89 a_57000_n65706# a_57000_n65592# 0.41095f
C90 a_58036_n65662# a_57318_n65795# 0.00165f
C91 a_57000_n65592# a_57000_n65461# 0.13033f
C92 a_58025_n65037# a_57000_n65461# 0
C93 a_57074_n65749# m2_57000_n65790# 0.0055f
C94 a_57074_n65749# a_57000_n65706# 0.0904f
C95 a_58036_n65371# m2_57000_n65790# 0.00633f
C96 a_58036_n65371# a_57000_n65706# 0
C97 a_57000_n66085# a_57318_n65795# 0.22329f
C98 a_57074_n65749# a_57000_n65461# 0.04148f
C99 a_58036_n65371# a_57000_n65461# 0.01928f
C100 m1_57000_n66200# w_57628_n66214# 0
C101 a_57680_n65852# a_57396_n65284# 0
C102 a_57000_n66085# a_57000_n66200# 0.03827f
C103 a_57370_n66200# a_57370_n65314# 0
C104 a_57000_n66085# a_57074_n66133# 0.00188f
C105 a_57318_n65795# a_57000_n66200# 0.00437f
C106 a_57318_n65795# a_57074_n66133# 0.00291f
C107 a_57000_n66085# a_58051_n65203# 0
C108 li_58047_n65017# w_57628_n66214# 0.03016f
C109 a_57000_n65592# w_57628_n66214# 0.15771f
C110 a_58025_n65037# w_57628_n66214# 0.02128f
C111 a_57074_n65749# w_57628_n66214# 0.00264f
C112 a_58036_n65371# w_57628_n66214# 0.49704f
C113 a_57000_n66085# a_57370_n65314# 0.21462f
C114 a_57318_n65795# a_57370_n65314# 0.19896f
C115 a_57680_n65660# m2_57000_n65790# 0.00142f
C116 a_57000_n65706# a_57680_n65660# 0.00283f
C117 a_57344_n66181# a_57396_n65284# 0.05335f
C118 a_57416_n65471# a_57000_n65461# 0.00132f
C119 a_57074_n65648# a_57000_n65706# 0.00888f
C120 a_58010_n65890# a_58036_n65950# 0.00316f
C121 a_57074_n65648# a_57000_n65461# 0.06164f
C122 a_58010_n65602# a_58010_n65692# 0.00693f
C123 a_57000_n65706# a_57396_n65284# 0.0968f
C124 a_57396_n65284# m2_57000_n65790# 0.02291f
C125 a_57000_n65461# a_57396_n65284# 0.03562f
C126 a_57680_n65660# w_57628_n66214# 0.01297f
C127 a_57344_n66181# a_57432_n65651# 0
C128 a_58036_n65371# a_58010_n65401# 0.00502f
C129 a_58010_n65980# a_58036_n65950# 0.00254f
C130 a_57416_n65471# w_57628_n66214# 0
C131 a_57344_n66181# a_57432_n65849# 0
C132 a_58025_n65144# m2_57000_n65790# 0
C133 a_57074_n65648# w_57628_n66214# 0
C134 a_57432_n65651# a_57000_n65706# 0
C135 a_58025_n65144# a_57000_n65461# 0
C136 a_57000_n66085# a_58010_n65980# 0
C137 a_57432_n65849# m2_57000_n65790# 0
C138 a_57000_n65706# a_57432_n65849# 0
C139 a_57318_n65795# a_58010_n65980# 0
C140 a_57396_n65284# w_57628_n66214# 0.23775f
C141 a_57074_n66200# a_57344_n66181# 0
C142 a_57074_n66200# m2_57000_n65790# 0
C143 m1_57000_n66200# a_57000_n66085# 0.00687f
C144 a_57370_n65314# a_58010_n65890# 0
C145 a_58025_n65144# w_57628_n66214# 0.0286f
C146 m1_57000_n66200# a_57318_n65795# 0
C147 a_57432_n65651# w_57628_n66214# 0
C148 a_57680_n65852# m2_57000_n65790# 0.00194f
C149 a_57680_n65852# a_57000_n65706# 0.00508f
C150 a_57000_n65592# a_58036_n65950# 0
C151 m1_57000_n66200# a_57000_n66200# 0.00304f
C152 a_57432_n65849# w_57628_n66214# 0
C153 a_58010_n65602# m2_57000_n65790# 0
C154 a_58036_n65662# a_57000_n65592# 0
C155 a_58036_n65371# a_58036_n65950# 0.00756f
C156 a_58010_n65692# m2_57000_n65790# 0
C157 a_58010_n65692# a_57000_n65706# 0
C158 a_57000_n66085# a_57000_n65592# 0.15009f
C159 a_58036_n65371# a_58036_n65662# 0.00765f
C160 a_57318_n65795# a_57000_n65592# 0.27393f
C161 a_57000_n66085# a_57074_n65749# 0.0464f
C162 a_57074_n66200# w_57628_n66214# 0.00501f
C163 a_58036_n65371# a_57000_n66085# 0
C164 a_57074_n65648# a_58010_n65401# 0
C165 a_57318_n65795# a_57074_n65749# 0.00409f
C166 a_57680_n65480# a_57396_n65284# 0
C167 a_58036_n65371# a_57318_n65795# 0.0059f
C168 a_58010_n65401# a_57396_n65284# 0
C169 a_57074_n65749# a_57074_n66133# 0
C170 a_57680_n65852# w_57628_n66214# 0.01489f
C171 a_58010_n65602# w_57628_n66214# 0.02533f
C172 a_58010_n65692# w_57628_n66214# 0.02599f
C173 a_58036_n65371# a_58051_n65203# 0.02349f
C174 a_58025_n65144# a_58010_n65401# 0
C175 a_58010_n65980# a_58010_n65890# 0.00693f
C176 a_57370_n66200# a_57396_n65284# 0.00124f
C177 a_57370_n65314# a_57000_n65592# 0.33845f
C178 a_57344_n66181# m2_57000_n65790# 0.00365f
C179 a_57344_n66181# a_57000_n65706# 0.10939f
C180 li_58047_n65017# a_58051_n65007# 0
C181 a_57344_n66181# a_57000_n65461# 0
C182 a_58036_n65371# a_57370_n65314# 0.0026f
C183 a_57000_n65706# m2_57000_n65790# 0.33447f
C184 a_57000_n65706# a_57000_n65461# 0
C185 a_57318_n65795# a_57680_n65660# 0.00203f
C186 a_57416_n65471# a_57318_n65795# 0.00269f
C187 a_57000_n66085# a_57074_n65648# 0.06222f
C188 a_57318_n65795# a_57074_n65648# 0.00271f
C189 a_58010_n65602# a_58010_n65401# 0.00243f
C190 a_58010_n65890# a_57000_n65592# 0.00374f
C191 a_57344_n66181# w_57628_n66214# 0.12244f
C192 a_57000_n66085# a_57396_n65284# 0.16992f
C193 a_57318_n65795# a_57396_n65284# 0.311f
C194 a_58036_n65371# a_58010_n65890# 0.00166f
C195 w_57628_n66214# m2_57000_n65790# 0.17378f
C196 a_57000_n65706# w_57628_n66214# 0.34073f
C197 a_58025_n65144# a_58036_n65950# 0
C198 a_57396_n65284# a_57000_n66200# 0
C199 a_57000_n65461# w_57628_n66214# 0.09768f
C200 a_58025_n65144# a_58036_n65662# 0
C201 a_58025_n65144# a_57318_n65795# 0
C202 a_57432_n65651# a_57318_n65795# 0.00229f
C203 a_57370_n65314# a_57680_n65660# 0.01538f
C204 a_58036_n65371# a_58010_n65980# 0.00161f
C205 a_57318_n65795# a_57432_n65849# 0.00551f
C206 a_57416_n65471# a_57370_n65314# 0.00875f
C207 a_57074_n65648# a_57370_n65314# 0
C208 a_58025_n65144# a_58051_n65203# 0.00218f
C209 a_57074_n66200# a_57000_n66085# 0.04233f
C210 a_57074_n66200# a_57318_n65795# 0.01259f
C211 a_57370_n65314# a_57396_n65284# 0.18875f
C212 a_58036_n65662# a_58010_n65602# 0.00316f
C213 a_57074_n66200# a_57000_n66200# 0.06167f
C214 m5_57184_n66100# a_57074_n66055# 0 $ **FLOATING
C215 m4_58072_n65640# a_57074_n66055# 0 $ **FLOATING
C216 m4_57896_n65676# a_57074_n66055# 0 $ **FLOATING
C217 m4_57720_n65712# a_57074_n66055# 0 $ **FLOATING
C218 m4_58072_n65464# a_57074_n66055# 0 $ **FLOATING
C219 m4_57896_n65500# a_57074_n66055# 0 $ **FLOATING
C220 m4_57720_n65536# a_57074_n66055# 0 $ **FLOATING
C221 m4_57544_n65572# a_57074_n66055# 0 $ **FLOATING
C222 m4_57368_n65608# a_57074_n66055# 0 $ **FLOATING
C223 m4_57192_n65644# a_57074_n66055# 0 $ **FLOATING
C224 m4_57016_n65680# a_57074_n66055# 0 $ **FLOATING
C225 m4_58072_n65288# a_57074_n66055# 0 $ **FLOATING
C226 m4_57896_n65324# a_57074_n66055# 0 $ **FLOATING
C227 m4_57720_n65360# a_57074_n66055# 0 $ **FLOATING
C228 m4_57544_n65396# a_57074_n66055# 0 $ **FLOATING
C229 m4_57368_n65432# a_57074_n66055# 0 $ **FLOATING
C230 m4_57192_n65468# a_57074_n66055# 0 $ **FLOATING
C231 m4_57016_n65504# a_57074_n66055# 0 $ **FLOATING
C232 m4_58072_n65112# a_57074_n66055# 0 $ **FLOATING
C233 m4_57896_n65148# a_57074_n66055# 0 $ **FLOATING
C234 m4_57720_n65184# a_57074_n66055# 0 $ **FLOATING
C235 m4_57544_n65220# a_57074_n66055# 0 $ **FLOATING
C236 m4_57368_n65256# a_57074_n66055# 0 $ **FLOATING
C237 m4_57192_n65292# a_57074_n66055# 0 $ **FLOATING
C238 m4_57016_n65328# a_57074_n66055# 0 $ **FLOATING
C239 m4_57720_n65008# a_57074_n66055# 0 $ **FLOATING
C240 m4_57544_n65044# a_57074_n66055# 0 $ **FLOATING
C241 m4_57368_n65080# a_57074_n66055# 0 $ **FLOATING
C242 m4_57192_n65116# a_57074_n66055# 0 $ **FLOATING
C243 m4_57016_n65152# a_57074_n66055# 0 $ **FLOATING
C244 m3_57650_n66170# a_57074_n66055# 0 $ **FLOATING
C245 m3_57474_n66200# a_57074_n66055# 0 $ **FLOATING
C246 m3_57298_n66200# a_57074_n66055# 0 $ **FLOATING
C247 m3_57650_n65994# a_57074_n66055# 0 $ **FLOATING
C248 m3_57474_n66030# a_57074_n66055# 0 $ **FLOATING
C249 m3_57298_n66066# a_57074_n66055# 0 $ **FLOATING
C250 m3_57650_n65818# a_57074_n66055# 0 $ **FLOATING
C251 m3_57474_n65854# a_57074_n66055# 0 $ **FLOATING
C252 m3_57298_n65890# a_57074_n66055# 0 $ **FLOATING
C253 m3_58002_n65570# a_57074_n66055# 0 $ **FLOATING
C254 m3_57826_n65606# a_57074_n66055# 0 $ **FLOATING
C255 m3_57650_n65642# a_57074_n66055# 0 $ **FLOATING
C256 m3_57474_n65678# a_57074_n66055# 0 $ **FLOATING
C257 m3_57298_n65714# a_57074_n66055# 0 $ **FLOATING
C258 m3_57122_n65750# a_57074_n66055# 0 $ **FLOATING
C259 m3_58002_n65394# a_57074_n66055# 0 $ **FLOATING
C260 m3_57826_n65430# a_57074_n66055# 0 $ **FLOATING
C261 m3_57650_n65466# a_57074_n66055# 0 $ **FLOATING
C262 m3_57474_n65502# a_57074_n66055# 0 $ **FLOATING
C263 m3_57298_n65538# a_57074_n66055# 0 $ **FLOATING
C264 m3_57122_n65574# a_57074_n66055# 0 $ **FLOATING
C265 m3_58002_n65218# a_57074_n66055# 0 $ **FLOATING
C266 m3_57826_n65254# a_57074_n66055# 0 $ **FLOATING
C267 m3_57650_n65290# a_57074_n66055# 0 $ **FLOATING
C268 m3_57474_n65326# a_57074_n66055# 0 $ **FLOATING
C269 m3_57298_n65362# a_57074_n66055# 0 $ **FLOATING
C270 m3_57122_n65398# a_57074_n66055# 0 $ **FLOATING
C271 m3_58002_n65042# a_57074_n66055# 0 $ **FLOATING
C272 m3_57826_n65078# a_57074_n66055# 0 $ **FLOATING
C273 m3_57650_n65114# a_57074_n66055# 0 $ **FLOATING
C274 m3_57474_n65150# a_57074_n66055# 0 $ **FLOATING
C275 m3_57298_n65186# a_57074_n66055# 0 $ **FLOATING
C276 m3_57122_n65222# a_57074_n66055# 0 $ **FLOATING
C277 m3_57298_n65010# a_57074_n66055# 0 $ **FLOATING
C278 m3_57122_n65046# a_57074_n66055# 0 $ **FLOATING
C279 m2_57344_n66200# a_57074_n66055# 0 $ **FLOATING
C280 m2_57656_n66120# a_57074_n66055# 0 $ **FLOATING
C281 m2_57540_n66140# a_57074_n66055# 0 $ **FLOATING
C282 m2_57540_n66040# a_57074_n66055# 0 $ **FLOATING
C283 m2_57640_n65960# a_57074_n66055# 0 $ **FLOATING
C284 m2_57540_n65940# a_57074_n66055# 0 $ **FLOATING
C285 m2_57240_n65980# a_57074_n66055# 0 $ **FLOATING
C286 m2_57440_n65920# a_57074_n66055# 0 $ **FLOATING
C287 m2_57000_n65790# a_57074_n66055# 0.16042f
C288 m2_57840_n65700# a_57074_n66055# 0 $ **FLOATING
C289 m2_58040_n65640# a_57074_n66055# 0 $ **FLOATING
C290 m2_57840_n65300# a_57074_n66055# 0 $ **FLOATING
C291 m2_57740_n65280# a_57074_n66055# 0 $ **FLOATING
C292 m2_57968_n65152# a_57074_n66055# 0 $ **FLOATING
C293 m2_57812_n65168# a_57074_n66055# 0 $ **FLOATING
C294 m2_57440_n65120# a_57074_n66055# 0 $ **FLOATING
C295 m2_57640_n65060# a_57074_n66055# 0 $ **FLOATING
C296 m2_57340_n65100# a_57074_n66055# 0 $ **FLOATING
C297 m2_57240_n65080# a_57074_n66055# 0 $ **FLOATING
C298 m2_57140_n65060# a_57074_n66055# 0 $ **FLOATING
C299 m1_57730_n65570# a_57074_n66055# 0 $ **FLOATING
C300 m1_57730_n65470# a_57074_n66055# 0 $ **FLOATING
C301 m1_57730_n65370# a_57074_n66055# 0 $ **FLOATING
C302 m1_57730_n65270# a_57074_n66055# 0 $ **FLOATING
C303 m1_57000_n66200# a_57074_n66055# 0.0088f
C304 m1_57730_n65170# a_57074_n66055# 0 $ **FLOATING
C305 m1_57730_n65070# a_57074_n66055# 0 $ **FLOATING
C306 m1_57430_n65110# a_57074_n66055# 0 $ **FLOATING
C307 m1_57630_n65050# a_57074_n66055# 0 $ **FLOATING
C308 m1_57530_n65030# a_57074_n66055# 0 $ **FLOATING
C309 m1_57430_n65010# a_57074_n66055# 0 $ **FLOATING
C310 li_58047_n65017# a_57074_n66055# 0.01322f
C311 li_57610_n65006# a_57074_n66055# 0 $ **FLOATING
C312 a_57370_n66200# a_57074_n66055# 0.00416f $ **FLOATING
C313 a_57074_n66200# a_57074_n66055# 0.12376f $ **FLOATING
C314 a_57344_n66181# a_57074_n66055# 0.21943f $ **FLOATING
C315 a_57000_n66200# a_57074_n66055# 0.1128f $ **FLOATING
C316 a_57074_n66133# a_57074_n66055# 0.00893f $ **FLOATING
C317 a_58010_n65980# a_57074_n66055# 0.00319f $ **FLOATING
C318 a_58036_n65950# a_57074_n66055# 0.01044f $ **FLOATING
C319 a_58010_n65890# a_57074_n66055# 0 $ **FLOATING
C320 a_57680_n65852# a_57074_n66055# 0 $ **FLOATING
C321 a_57432_n65849# a_57074_n66055# 0.00208f $ **FLOATING
C322 a_58010_n65692# a_57074_n66055# 0 $ **FLOATING
C323 a_58036_n65662# a_57074_n66055# 0.01044f $ **FLOATING
C324 a_57680_n65660# a_57074_n66055# 0 $ **FLOATING
C325 a_58010_n65602# a_57074_n66055# 0 $ **FLOATING
C326 a_57432_n65651# a_57074_n66055# 0.00339f $ **FLOATING
C327 a_57680_n65480# a_57074_n66055# 0 $ **FLOATING
C328 a_57000_n66085# a_57074_n66055# 1.14614f $ **FLOATING
C329 a_58010_n65401# a_57074_n66055# 0.00123f $ **FLOATING
C330 a_57416_n65471# a_57074_n66055# 0.00549f $ **FLOATING
C331 a_57074_n65749# a_57074_n66055# 0.11319f $ **FLOATING
C332 a_57000_n65706# a_57074_n66055# 0.33092f $ **FLOATING
C333 a_57000_n65592# a_57074_n66055# 0.33313f $ **FLOATING
C334 a_57318_n65795# a_57074_n66055# 1.16062f $ **FLOATING
C335 a_58036_n65371# a_57074_n66055# 0.23712f $ **FLOATING
C336 a_57000_n65461# a_57074_n66055# 0.38189f $ **FLOATING
C337 a_57074_n65648# a_57074_n66055# 0.21271f $ **FLOATING
C338 a_57370_n65314# a_57074_n66055# 0.30041f $ **FLOATING
C339 a_57396_n65284# a_57074_n66055# 0.309f $ **FLOATING
C340 a_58051_n65203# a_57074_n66055# 0.00652f $ **FLOATING
C341 a_58025_n65144# a_57074_n66055# 0.00161f $ **FLOATING
C342 a_58025_n65037# a_57074_n66055# 0.0068f $ **FLOATING
C343 a_58051_n65007# a_57074_n66055# 0 $ **FLOATING
C344 w_57628_n66214# a_57074_n66055# 2.67195f $ **FLOATING
C345 a_57074_n66055# a_57074_n66055# 0 $ **FLOATING
.ends
