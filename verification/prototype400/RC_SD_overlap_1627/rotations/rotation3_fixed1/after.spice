* NGSPICE file created from RotatedCrop.ext - technology: sky130A

.subckt RotatedCrop
X0 a_57396_n65284.t0 a_57370_n65314.t6 w_57628_n66214.t5 w_57628_n66214.t4 sky130_fd_pr__pfet_01v8 ad=0.3304 pd=2.83 as=0.1934 ps=1.475 w=1.12 l=0.15
X1 a_58036_n65662# a_58010_n65692# w_57628_n66214.t11 w_57628_n66214.t10 sky130_fd_pr__pfet_01v8 ad=0.048 pd=0.62 as=0.0912 ps=1.21 w=0.32 l=0.15
X2 a_58036_n65371.t0 a_58010_n65401# w_57628_n66214.t26 w_57628_n66214.t25 sky130_fd_pr__pfet_01v8 ad=0.1088 pd=1.32 as=0.096 ps=1.24 w=0.32 l=0.15
X3 w_57628_n66214.t15 a_57344_n66181# a_57000_n65706.t0 w_57628_n66214.t14 sky130_fd_pr__pfet_01v8 ad=0.3192 pd=2.81 as=0.1232 ps=2.46 w=1.12 l=0.15
X4 a_57074_n65648.t1 a_57000_n65461# a_57074_n66055.t20 a_57074_n66055.t19 sky130_fd_pr__nfet_01v8_lvt ad=0.2109 pd=2.05 as=0.3361 ps=1.68 w=0.74 l=0.15
X5 a_57074_n66055.t13 a_57318_n65795# a_57416_n65471.t0 a_57074_n66055.t12 sky130_fd_pr__nfet_01v8_lvt ad=0.1389 pd=1.135 as=0.0768 ps=0.88 w=0.64 l=0.15
X6 a_57432_n65849# a_57000_n65592# a_57370_n65314.t4 a_57074_n66055.t18 sky130_fd_pr__nfet_01v8_lvt ad=0.0864 pd=0.91 as=0.1733 ps=1.85 w=0.64 l=0.15
X7 a_57074_n66055.t3 a_57000_n66085# a_57074_n66133.t0 a_57074_n66055.t2 sky130_fd_pr__nfet_01v8_lvt ad=0.2109 pd=2.05 as=0.0888 ps=0.98 w=0.74 l=0.15
X8 a_57074_n66055.t17 a_57000_n65592# a_57074_n65648.t0 a_57074_n66055.t16 sky130_fd_pr__nfet_01v8_lvt ad=0.3361 pd=1.68 as=0.1036 ps=1.02 w=0.74 l=0.15
X9 a_57396_n65284.t1 a_57370_n65314.t7 a_57074_n66055.t5 a_57074_n66055.t4 sky130_fd_pr__nfet_01v8_lvt ad=0.2081 pd=2.05 as=0.1389 ps=1.135 w=0.74 l=0.15
X10 a_57680_n65852# a_57000_n65592# a_57370_n65314.t5 w_57628_n66214.t24 sky130_fd_pr__pfet_01v8 ad=0.135 pd=1.27 as=0.295 ps=2.59 w=1 l=0.15
X11 w_57628_n66214.t21 a_57318_n65795# a_57680_n65852.t0 w_57628_n66214.t20 sky130_fd_pr__pfet_01v8 ad=0.195 pd=1.39 as=0.135 ps=1.27 w=1 l=0.15
X12 w_57628_n66214.t9 a_58010_n65890# a_58036_n65950.t0 w_57628_n66214.t8 sky130_fd_pr__pfet_01v8 ad=0.0912 pd=1.21 as=0.048 ps=0.62 w=0.32 l=0.15
X13 a_58036_n65950# a_58010_n65980# w_57628_n66214.t13 w_57628_n66214.t12 sky130_fd_pr__pfet_01v8 ad=0.048 pd=0.62 as=0.0912 ps=1.21 w=0.32 l=0.15
X14 a_58051_n65007.t0 a_58025_n65037# w_57628_n66214.t3 w_57628_n66214.t2 sky130_fd_pr__pfet_01v8 ad=8.575m pd=0.56 as=0.04715 ps=0.63 w=0.245 l=0.15
X15 a_57074_n66055.t8 a_57344_n66181# a_57370_n66200.t0 a_57074_n66055.t7 sky130_fd_pr__nfet_01v8_lvt ad=0.2109 pd=2.05 as=0.0703 ps=1.67 w=0.74 l=0.15
X16 a_57680_n65480# a_57000_n66085# a_57370_n65314.t0 w_57628_n66214.t0 sky130_fd_pr__pfet_01v8 ad=0.135 pd=1.27 as=0.165 ps=1.33 w=1 l=0.15
X17 a_57074_n66055.t11 a_57318_n65795# a_57432_n65849.t0 a_57074_n66055.t10 sky130_fd_pr__nfet_01v8_lvt ad=0.1344 pd=1.06 as=0.0864 ps=0.91 w=0.64 l=0.15
X18 a_57074_n65648# a_57000_n65706.t1 a_57074_n65749.t0 a_57074_n66055.t6 sky130_fd_pr__nfet_01v8_lvt ad=0.1036 pd=1.02 as=0.2627 ps=2.19 w=0.74 l=0.15
X19 a_57680_n65660# a_57000_n65592# w_57628_n66214.t23 w_57628_n66214.t22 sky130_fd_pr__pfet_01v8 ad=0.135 pd=1.27 as=0.195 ps=1.39 w=1 l=0.15
X20 a_57416_n65471# a_57000_n66085# a_57370_n65314.t2 a_57074_n66055.t0 sky130_fd_pr__nfet_01v8_lvt ad=0.0768 pd=0.88 as=0.1222 ps=1.08 w=0.64 l=0.15
X21 w_57628_n66214.t7 a_58010_n65602# a_58036_n65662.t0 w_57628_n66214.t6 sky130_fd_pr__pfet_01v8 ad=0.0912 pd=1.21 as=0.048 ps=0.62 w=0.32 l=0.15
X22 a_57432_n65651# a_57000_n65592# a_57074_n66055.t15 a_57074_n66055.t14 sky130_fd_pr__nfet_01v8_lvt ad=0.0768 pd=0.88 as=0.1344 ps=1.06 w=0.64 l=0.15
X23 w_57628_n66214.t17 a_58025_n65144# a_58051_n65203.t0 w_57628_n66214.t16 sky130_fd_pr__pfet_01v8 ad=0.04715 pd=0.63 as=0.07227 ps=1.08 w=0.245 l=0.15
X24 w_57628_n66214.t19 a_57318_n65795# a_57680_n65480.t0 w_57628_n66214.t18 sky130_fd_pr__pfet_01v8 ad=0.1934 pd=1.475 as=0.135 ps=1.27 w=1 l=0.15
X25 a_57370_n65314.t3 a_57000_n66085# a_57680_n65660.t0 w_57628_n66214.t1 sky130_fd_pr__pfet_01v8 ad=0.165 pd=1.33 as=0.135 ps=1.27 w=1 l=0.15
X26 a_57074_n66133# a_57000_n66200# a_57074_n66200.t0 a_57074_n66055.t9 sky130_fd_pr__nfet_01v8_lvt ad=0.0888 pd=0.98 as=0.1369 ps=1.85 w=0.74 l=0.15
X27 a_57370_n65314.t1 a_57000_n66085# a_57432_n65651.t0 a_57074_n66055.t1 sky130_fd_pr__nfet_01v8_lvt ad=0.1222 pd=1.08 as=0.0768 ps=0.88 w=0.64 l=0.15
C0 a_57074_n65648# a_58036_n65371# 0
C1 a_58036_n65662# a_58010_n65602# 0.00316f
C2 a_57000_n65592# a_58036_n65371# 0
C3 a_57370_n65314# a_57074_n65648# 0
C4 a_57416_n65471# a_57370_n65314# 0.00875f
C5 a_57074_n65749# a_57074_n66133# 0
C6 a_58010_n65980# a_58036_n65950# 0.00254f
C7 a_57000_n65592# a_57370_n65314# 0.33845f
C8 a_57680_n65480# a_57000_n65461# 0.00218f
C9 a_57074_n66133# a_57074_n66200# 0.00959f
C10 a_57000_n65706# a_58010_n65980# 0
C11 a_58025_n65144# a_58036_n65950# 0
C12 a_58010_n65890# a_58010_n65692# 0.00248f
C13 a_57000_n65592# a_57344_n66181# 0.02192f
C14 w_57628_n66214# a_57000_n66200# 0.00265f
C15 a_57370_n66200# a_57370_n65314# 0
C16 a_57000_n65706# a_57318_n65795# 0.06121f
C17 a_57396_n65284# a_58036_n65371# 0.00187f
C18 a_57370_n65314# a_57396_n65284# 0.18875f
C19 w_57628_n66214# a_57680_n65660# 0.01297f
C20 w_57628_n66214# a_58010_n65692# 0.02599f
C21 a_57680_n65852# a_57000_n65592# 0
C22 a_58010_n65980# a_57318_n65795# 0
C23 a_57074_n65749# a_57000_n65706# 0.0904f
C24 a_57432_n65849# m2_57000_n65790# 0
C25 m2_57000_n65790# a_58036_n65662# 0.00157f
C26 a_58025_n65037# w_57628_n66214# 0.02128f
C27 a_57396_n65284# a_57344_n66181# 0.05335f
C28 a_57000_n65706# a_57000_n65461# 0
C29 a_58025_n65144# a_57318_n65795# 0
C30 a_57000_n66085# a_58036_n65662# 0
C31 a_57680_n65852# a_57396_n65284# 0
C32 a_57074_n65749# a_57318_n65795# 0.00409f
C33 a_58010_n65692# a_58036_n65371# 0.00165f
C34 a_57370_n65314# a_57680_n65660# 0.01538f
C35 a_57074_n66200# a_57318_n65795# 0.01259f
C36 a_57370_n65314# a_58010_n65692# 0
C37 a_57000_n65592# a_57074_n65648# 0.01825f
C38 a_57000_n65461# a_57318_n65795# 0.29057f
C39 a_58025_n65144# a_57000_n65461# 0
C40 a_57000_n66200# a_57344_n66181# 0.004f
C41 a_58025_n65037# a_58036_n65371# 0
C42 a_57074_n65749# a_57074_n66200# 0.00231f
C43 a_57432_n65849# w_57628_n66214# 0
C44 a_58036_n65662# w_57628_n66214# 0.07727f
C45 a_57680_n65480# a_57000_n66085# 0.00978f
C46 a_57074_n65749# a_57000_n65461# 0.04148f
C47 a_57416_n65471# a_57396_n65284# 0.00285f
C48 a_57000_n66085# a_57074_n66133# 0.00188f
C49 a_57000_n65592# a_57396_n65284# 0.09591f
C50 a_58010_n65602# a_57318_n65795# 0
C51 m2_57000_n65790# a_58036_n65950# 0.00161f
C52 a_57680_n65480# w_57628_n66214# 0.01679f
C53 m2_57000_n65790# a_57000_n65706# 0.33447f
C54 a_57370_n66200# a_57396_n65284# 0.00124f
C55 w_57628_n66214# a_57074_n66133# 0.00205f
C56 a_58036_n65662# a_58036_n65371# 0.00765f
C57 a_57432_n65849# a_57370_n65314# 0.00893f
C58 m2_57000_n65790# a_58010_n65980# 0
C59 a_57000_n66085# a_57000_n65706# 0.06427f
C60 a_58025_n65037# li_58047_n65017# 0.00323f
C61 a_58010_n65890# a_58036_n65950# 0.00316f
C62 a_57000_n65592# a_57680_n65660# 0.00273f
C63 a_57000_n65592# a_58010_n65692# 0.0044f
C64 m2_57000_n65790# a_57318_n65795# 0.12987f
C65 a_58025_n65144# m2_57000_n65790# 0
C66 a_57432_n65651# a_57000_n65706# 0
C67 a_57432_n65849# a_57344_n66181# 0
C68 a_57000_n66085# a_58010_n65980# 0
C69 w_57628_n66214# a_58036_n65950# 0.08129f
C70 a_58025_n65144# a_58051_n65203# 0.00218f
C71 a_57680_n65480# a_57370_n65314# 0.00749f
C72 a_57074_n65749# m2_57000_n65790# 0.0055f
C73 a_57000_n66200# a_57396_n65284# 0
C74 a_57000_n65706# w_57628_n66214# 0.34073f
C75 a_58010_n65890# a_58010_n65980# 0.00693f
C76 a_57000_n66085# a_57318_n65795# 0.22329f
C77 m2_57000_n65790# a_57074_n66200# 0
C78 a_57000_n66200# m1_57000_n66200# 0.00304f
C79 a_57432_n65651# a_57318_n65795# 0.00229f
C80 w_57628_n66214# a_58010_n65980# 0.03054f
C81 a_57074_n65749# a_57000_n66085# 0.0464f
C82 a_58051_n65203# a_57000_n65461# 0
C83 a_57000_n66085# a_57074_n66200# 0.04233f
C84 a_57000_n66085# a_57000_n65461# 0.24124f
C85 w_57628_n66214# a_57318_n65795# 0.24396f
C86 a_58025_n65144# w_57628_n66214# 0.0286f
C87 a_58010_n65401# a_57318_n65795# 0
C88 a_58025_n65144# a_58010_n65401# 0
C89 a_58036_n65950# a_58036_n65371# 0.00756f
C90 m2_57000_n65790# a_58010_n65602# 0
C91 a_57432_n65849# a_57000_n65592# 0
C92 a_57000_n65706# a_58036_n65371# 0
C93 a_58036_n65662# a_57000_n65592# 0
C94 a_57000_n65706# a_57370_n65314# 0.07885f
C95 a_57074_n65749# w_57628_n66214# 0.00264f
C96 w_57628_n66214# a_57074_n66200# 0.00501f
C97 a_57000_n66085# a_58010_n65602# 0.00416f
C98 w_57628_n66214# a_57000_n65461# 0.09768f
C99 a_58010_n65401# a_57000_n65461# 0.00175f
C100 a_58010_n65980# a_58036_n65371# 0.00161f
C101 a_57000_n65706# a_57344_n66181# 0.10939f
C102 a_57432_n65849# a_57396_n65284# 0.00194f
C103 a_58036_n65371# a_57318_n65795# 0.0059f
C104 a_58025_n65144# a_58036_n65371# 0.00145f
C105 a_57370_n65314# a_57318_n65795# 0.19896f
C106 w_57628_n66214# a_58010_n65602# 0.02533f
C107 a_57680_n65852# a_57000_n65706# 0.00508f
C108 a_58010_n65401# a_58010_n65602# 0.00243f
C109 a_57344_n66181# a_57318_n65795# 0.00662f
C110 a_57000_n65461# a_58036_n65371# 0.01928f
C111 a_57680_n65480# a_57396_n65284# 0
C112 a_57000_n65461# a_57370_n65314# 0.0107f
C113 m2_57000_n65790# a_57000_n66085# 0.06654f
C114 a_57000_n66085# a_58051_n65203# 0
C115 a_57000_n65592# a_58036_n65950# 0
C116 m2_57000_n65790# a_58010_n65890# 0
C117 a_57344_n66181# a_57074_n66200# 0
C118 a_58036_n65662# a_58010_n65692# 0.00254f
C119 a_57000_n65461# a_57344_n66181# 0
C120 a_57000_n65706# a_57074_n65648# 0.00888f
C121 a_57000_n65706# a_57000_n65592# 0.41095f
C122 a_58010_n65602# a_58036_n65371# 0.00172f
C123 a_57370_n65314# a_58010_n65602# 0
C124 m2_57000_n65790# w_57628_n66214# 0.17378f
C125 w_57628_n66214# a_58051_n65203# 0.03649f
C126 a_57000_n65706# a_57370_n66200# 0.0022f
C127 a_57000_n66085# w_57628_n66214# 0.31846f
C128 a_57416_n65471# a_57318_n65795# 0.00269f
C129 a_57000_n65706# a_57396_n65284# 0.0968f
C130 a_57074_n65648# a_57318_n65795# 0.00271f
C131 a_57000_n66085# a_58010_n65401# 0
C132 a_57000_n65592# a_57318_n65795# 0.27393f
C133 li_58047_n65017# a_57000_n65461# 0
C134 a_57432_n65651# w_57628_n66214# 0
C135 w_57628_n66214# a_58010_n65890# 0.02766f
C136 a_57074_n65749# a_57074_n65648# 0.13586f
C137 a_58010_n65980# a_57396_n65284# 0
C138 a_57074_n65749# a_57000_n65592# 0.06228f
C139 m2_57000_n65790# a_58036_n65371# 0.00633f
C140 a_57370_n66200# a_57318_n65795# 0.00129f
C141 m2_57000_n65790# a_57370_n65314# 0.01819f
C142 a_57000_n65461# a_57074_n65648# 0.06164f
C143 a_57416_n65471# a_57000_n65461# 0.00132f
C144 a_57000_n65592# a_57000_n65461# 0.13033f
C145 a_57396_n65284# a_57318_n65795# 0.311f
C146 a_58010_n65401# w_57628_n66214# 0.03188f
C147 a_58051_n65203# a_58036_n65371# 0.02349f
C148 m1_57000_n66200# a_57318_n65795# 0
C149 a_57000_n65706# a_57000_n66200# 0
C150 a_57000_n66085# a_58036_n65371# 0
C151 m2_57000_n65790# a_57344_n66181# 0.00365f
C152 a_57000_n66085# a_57370_n65314# 0.21462f
C153 a_57000_n65706# a_57680_n65660# 0.00283f
C154 a_57000_n65706# a_58010_n65692# 0
C155 a_57000_n65592# a_58010_n65602# 0
C156 a_58010_n65890# a_58036_n65371# 0.00166f
C157 a_57000_n65461# a_57396_n65284# 0.03562f
C158 a_57432_n65651# a_57370_n65314# 0.00942f
C159 a_58010_n65890# a_57370_n65314# 0
C160 m1_57000_n66200# a_57074_n66200# 0.0024f
C161 a_57680_n65852# m2_57000_n65790# 0.00194f
C162 a_57000_n66085# a_57344_n66181# 0.00385f
C163 a_57000_n66200# a_57318_n65795# 0.00437f
C164 w_57628_n66214# a_58036_n65371# 0.49704f
C165 a_58010_n65401# a_58036_n65371# 0.00502f
C166 w_57628_n66214# a_57370_n65314# 0.38297f
C167 a_58010_n65401# a_57370_n65314# 0
C168 a_57432_n65651# a_57344_n66181# 0
C169 a_57680_n65660# a_57318_n65795# 0.00203f
C170 a_58010_n65692# a_57318_n65795# 0
C171 a_57000_n66200# a_57074_n66200# 0.06167f
C172 li_58047_n65017# a_58051_n65007# 0
C173 w_57628_n66214# a_57344_n66181# 0.12244f
C174 a_58025_n65037# a_58025_n65144# 0.0054f
C175 m2_57000_n65790# a_57000_n65592# 0.01513f
C176 a_57432_n65849# a_57000_n65706# 0
C177 a_57000_n65706# a_58036_n65662# 0
C178 a_57680_n65852# w_57628_n66214# 0.01489f
C179 a_57370_n65314# a_58036_n65371# 0.0026f
C180 a_57000_n66085# a_57074_n65648# 0.06222f
C181 a_58025_n65037# a_57000_n65461# 0
C182 a_57000_n66085# a_57000_n65592# 0.15009f
C183 m2_57000_n65790# a_57370_n66200# 0
C184 li_58047_n65017# w_57628_n66214# 0.03016f
C185 m2_57000_n65790# a_57396_n65284# 0.02291f
C186 a_58010_n65692# a_58010_n65602# 0.00693f
C187 a_57432_n65651# a_57000_n65592# 0.00102f
C188 a_58010_n65890# a_57000_n65592# 0.00374f
C189 a_57344_n66181# a_58036_n65371# 0
C190 a_57432_n65849# a_57318_n65795# 0.00551f
C191 a_57370_n65314# a_57344_n66181# 0.00594f
C192 a_58036_n65662# a_57318_n65795# 0.00165f
C193 a_58025_n65144# a_58036_n65662# 0
C194 a_57680_n65480# a_57000_n65706# 0
C195 a_57000_n66085# a_57370_n66200# 0
C196 w_57628_n66214# a_57074_n65648# 0
C197 a_57416_n65471# w_57628_n66214# 0
C198 a_57000_n66085# a_57396_n65284# 0.16992f
C199 a_58010_n65401# a_57074_n65648# 0
C200 w_57628_n66214# a_57000_n65592# 0.15771f
C201 a_57680_n65852# a_57370_n65314# 0.01522f
C202 a_57000_n66085# m1_57000_n66200# 0.00687f
C203 a_57432_n65651# a_57396_n65284# 0.00171f
C204 li_58047_n65017# a_58036_n65371# 0
C205 a_57680_n65480# a_57318_n65795# 0.0028f
C206 w_57628_n66214# a_57370_n66200# 0
C207 m2_57000_n65790# a_57680_n65660# 0.00142f
C208 m2_57000_n65790# a_58010_n65692# 0
C209 w_57628_n66214# a_57396_n65284# 0.23775f
C210 a_57074_n66133# a_57318_n65795# 0.00291f
C211 a_58010_n65401# a_57396_n65284# 0
C212 w_57628_n66214# m1_57000_n66200# 0
C213 a_57000_n66085# a_57000_n66200# 0.03827f
R0 a_57370_n66200# a_57370_n66200.t0 467.368
R1 a_57074_n66200# a_57074_n66200.t0 218.214
R2 a_57074_n66133# a_57074_n66133.t0 38.9194
R3 a_58036_n65950# a_58036_n65950.t0 184.689
R4 a_57680_n65852# a_57680_n65852.t0 53.1905
R5 a_57432_n65849# a_57432_n65849.t0 50.6255
R6 a_58036_n65662# a_58036_n65662.t0 184.689
R7 a_57680_n65660# a_57680_n65660.t0 53.1905
R8 a_57432_n65651# a_57432_n65651.t0 45.0005
R9 a_57680_n65480# a_57680_n65480.t0 53.1905
R10 a_57416_n65471# a_57416_n65471.t0 45.0005
R11 a_57074_n65749# a_57074_n65749.t0 114.35
R12 a_57000_n65706.n0 a_57000_n65706.t0 437.308
R13 a_57000_n65706# a_57000_n65706.n0 51.9082
R14 a_57000_n65706.n0 a_57000_n65706.t1 216.9
R15 a_58036_n65371# a_58036_n65371.t0 92.7064
R16 a_57074_n65648# a_57074_n65648.n0 22.7032
R17 a_57074_n65648.n0 a_57074_n65648.t0 22.7032
R18 a_57074_n65648.n0 a_57074_n65648.t1 406.166
R19 a_57370_n65314.n4 a_57370_n65314.n5 99.0072
R20 a_57370_n65314.n5 a_57370_n65314.t2 26.251
R21 a_57370_n65314.t1 a_57370_n65314.n5 43.6617
R22 a_57370_n65314.n4 a_57370_n65314.n0 6.4005
R23 a_57370_n65314.n3 a_57370_n65314.n4 223.374
R24 a_57370_n65314.n3 a_57370_n65314.t6 250.548
R25 a_57370_n65314.t7 a_57370_n65314.n3 177.981
R26 a_57370_n65314# a_57370_n65314.t7 160.667
R27 a_57370_n65314.n0 a_57370_n65314.n2 64.7534
R28 a_57370_n65314.n2 a_57370_n65314.n1 204.505
R29 a_57370_n65314.n1 a_57370_n65314.t3 29.5505
R30 a_57370_n65314.n1 a_57370_n65314.t0 35.4605
R31 a_57370_n65314.n2 a_57370_n65314.t5 334.197
R32 a_57370_n65314.n0 a_57370_n65314.t4 316.462
R33 a_57396_n65284# a_57396_n65284.n0 90.7164
R34 a_57396_n65284.t1 a_57396_n65284.n0 36.5725
R35 a_57396_n65284.n0 a_57396_n65284.t0 411.57
R36 a_58051_n65203# a_58051_n65203.t0 237.204
R37 a_58051_n65007# a_58051_n65007.t0 675.429
R38 w_57628_n66214.n0 w_57628_n66214.t17 120.612
R39 w_57628_n66214.n0 w_57628_n66214.t3 188.959
R40 w_57628_n66214.n32 w_57628_n66214.n0 608.746
R41 w_57628_n66214.n2 w_57628_n66214.n1 9.3005
R42 w_57628_n66214.n3 w_57628_n66214.n35 9.3005
R43 w_57628_n66214.n5 w_57628_n66214.n4 9.3005
R44 w_57628_n66214.n7 w_57628_n66214.n6 9.3005
R45 w_57628_n66214.n7 w_57628_n66214.n8 4.5005
R46 w_57628_n66214.n10 w_57628_n66214.n11 4.5005
R47 w_57628_n66214.n12 w_57628_n66214.n13 4.5005
R48 w_57628_n66214.n14 w_57628_n66214.n15 4.5005
R49 w_57628_n66214.n16 w_57628_n66214.n17 4.5005
R50 w_57628_n66214.n10 w_57628_n66214.n27 0.0222965
R51 w_57628_n66214.n28 w_57628_n66214.n38 9.3005
R52 w_57628_n66214.n29 w_57628_n66214.n39 9.3005
R53 w_57628_n66214.n30 w_57628_n66214.n40 9.3005
R54 w_57628_n66214.n31 w_57628_n66214.n42 9.3005
R55 w_57628_n66214.n44 w_57628_n66214.n43 9.3005
R56 w_57628_n66214.n27 w_57628_n66214.n9 4.56115
R57 w_57628_n66214.n12 w_57628_n66214.n10 0.0821327
R58 w_57628_n66214.n28 w_57628_n66214.n12 0.0413163
R59 w_57628_n66214.n14 w_57628_n66214.n28 0.0413163
R60 w_57628_n66214.n7 w_57628_n66214.n14 0.0821327
R61 w_57628_n66214.n16 w_57628_n66214.n7 0.0821327
R62 w_57628_n66214.n29 w_57628_n66214.n16 0.0413163
R63 w_57628_n66214.n30 w_57628_n66214.n29 0.122949
R64 w_57628_n66214.n5 w_57628_n66214.n30 0.122949
R65 w_57628_n66214.n31 w_57628_n66214.n5 0.122949
R66 w_57628_n66214.n44 w_57628_n66214.n31 0.122949
R67 w_57628_n66214.n3 w_57628_n66214.n44 0.122949
R68 w_57628_n66214.n2 w_57628_n66214.n3 0.122949
R69 w_57628_n66214.n32 w_57628_n66214.n2 4.37628
R70 w_57628_n66214.n43 w_57628_n66214.t26 700.399
R71 w_57628_n66214.n43 w_57628_n66214.n35 0.376971
R72 w_57628_n66214.n42 w_57628_n66214.n43 16.5652
R73 w_57628_n66214.n42 w_57628_n66214.t7 703.712
R74 w_57628_n66214.n40 w_57628_n66214.n4 20.7064
R75 w_57628_n66214.n4 w_57628_n66214.n42 27.4829
R76 w_57628_n66214.n40 w_57628_n66214.n41 313.168
R77 w_57628_n66214.n40 w_57628_n66214.t11 697.679
R78 w_57628_n66214.n41 w_57628_n66214.t21 39.4005
R79 w_57628_n66214.n41 w_57628_n66214.t23 37.4305
R80 w_57628_n66214.n39 w_57628_n66214.n40 10.9181
R81 w_57628_n66214.n39 w_57628_n66214.t9 703.712
R82 w_57628_n66214.n38 w_57628_n66214.n6 21.4593
R83 w_57628_n66214.n6 w_57628_n66214.n39 27.4829
R84 w_57628_n66214.n38 w_57628_n66214.t13 698.289
R85 w_57628_n66214.n37 w_57628_n66214.n38 15.8123
R86 w_57628_n66214.n37 w_57628_n66214.t15 250.081
R87 w_57628_n66214.n27 w_57628_n66214.n37 6.8535
R88 w_57628_n66214.n35 w_57628_n66214.n36 223.704
R89 w_57628_n66214.n36 w_57628_n66214.t19 30.5355
R90 w_57628_n66214.n36 w_57628_n66214.t5 36.551
R91 w_57628_n66214.n35 w_57628_n66214.n1 31.624
R92 w_57628_n66214.n1 w_57628_n66214.n33 24.8476
R93 w_57628_n66214.n34 w_57628_n66214.n33 211.838
R94 w_57628_n66214.t14 w_57628_n66214.t12 398.517
R95 w_57628_n66214.t12 w_57628_n66214.t8 181.144
R96 w_57628_n66214.t8 w_57628_n66214.t24 16.1022
R97 w_57628_n66214.t24 w_57628_n66214.t20 169.069
R98 w_57628_n66214.t20 w_57628_n66214.t10 213.347
R99 w_57628_n66214.t10 w_57628_n66214.t22 4.02592
R100 w_57628_n66214.t22 w_57628_n66214.t1 169.069
R101 w_57628_n66214.t1 w_57628_n66214.t6 8.05135
R102 w_57628_n66214.t6 w_57628_n66214.t0 185.169
R103 w_57628_n66214.t0 w_57628_n66214.t18 169.069
R104 w_57628_n66214.t18 w_57628_n66214.t25 50.3183
R105 w_57628_n66214.t25 w_57628_n66214.t4 152.966
R106 w_57628_n66214.t4 w_57628_n66214.n34 318.009
R107 w_57628_n66214.n34 w_57628_n66214.t16 46.2929
R108 w_57628_n66214.t16 w_57628_n66214.t2 215.038
R109 w_57628_n66214# w_57628_n66214.t14 10117.3
R110 w_57628_n66214.n33 w_57628_n66214.n32 0.850602
R111 w_57628_n66214.n18 w_57628_n66214.n19 3.4105
R112 w_57628_n66214.n20 w_57628_n66214.n21 3.4105
R113 w_57628_n66214.n22 w_57628_n66214.n23 3.4105
R114 w_57628_n66214.n9 w_57628_n66214.n11 0.108608
R115 w_57628_n66214.n11 w_57628_n66214.n20 0.027527
R116 w_57628_n66214.n13 w_57628_n66214.n20 0.0815811
R117 w_57628_n66214.n13 w_57628_n66214.n22 0.0545541
R118 w_57628_n66214.n15 w_57628_n66214.n22 0.0545541
R119 w_57628_n66214.n15 w_57628_n66214.n18 0.0815811
R120 w_57628_n66214.n8 w_57628_n66214.n18 0.027527
R121 w_57628_n66214.n8 w_57628_n66214.n17 0.108608
R122 w_57628_n66214.n24 w_57628_n66214.n19 0.0292348
R123 w_57628_n66214.n21 w_57628_n66214.n25 0.0292348
R124 w_57628_n66214.n23 w_57628_n66214.n26 3.4105
R125 w_57628_n66214.n9 w_57628_n66214.n25 3.43926
R126 w_57628_n66214.n23 w_57628_n66214.n21 0.0574697
R127 w_57628_n66214.n19 w_57628_n66214.n23 0.0574697
R128 w_57628_n66214.n17 w_57628_n66214.n24 3.43926
R129 w_57628_n66214.n25 w_57628_n66214.n26 1.69615
R130 w_57628_n66214.n24 w_57628_n66214.n26 1.69615
R131 a_57074_n66055.t13 a_57074_n66055.n0 30.938
R132 a_57074_n66055.n0 a_57074_n66055.t5 39.9583
R133 a_57074_n66055.n2 a_57074_n66055.n1 7.00362
R134 a_57074_n66055.n1 a_57074_n66055.n0 211.284
R135 a_57074_n66055.n4 a_57074_n66055.n3 9.3005
R136 a_57074_n66055.n6 a_57074_n66055.n5 9.3005
R137 a_57074_n66055.n8 a_57074_n66055.n7 9.3005
R138 a_57074_n66055.n10 a_57074_n66055.n9 9.3005
R139 a_57074_n66055.n12 a_57074_n66055.n11 9.3005
R140 a_57074_n66055.n14 a_57074_n66055.n13 9.3005
R141 a_57074_n66055.n20 a_57074_n66055.n15 3.82657
R142 a_57074_n66055.n4 a_57074_n66055.n2 0.493641
R143 a_57074_n66055.n15 a_57074_n66055.n14 2.44776
R144 a_57074_n66055.n14 a_57074_n66055.n12 0.122949
R145 a_57074_n66055.n12 a_57074_n66055.n10 0.122949
R146 a_57074_n66055.n10 a_57074_n66055.n8 0.122949
R147 a_57074_n66055.n8 a_57074_n66055.n6 0.122949
R148 a_57074_n66055.n6 a_57074_n66055.n4 0.122949
R149 a_57074_n66055.t9 a_57074_n66055.t7 123.945
R150 a_57074_n66055.t2 a_57074_n66055.t9 537.09
R151 a_57074_n66055.t18 a_57074_n66055.t2 1418.47
R152 a_57074_n66055.t10 a_57074_n66055.t18 578.404
R153 a_57074_n66055.t14 a_57074_n66055.t10 784.977
R154 a_57074_n66055.t6 a_57074_n66055.t14 20.6578
R155 a_57074_n66055.t1 a_57074_n66055.t6 516.433
R156 a_57074_n66055.t16 a_57074_n66055.t1 75.7439
R157 a_57074_n66055.t0 a_57074_n66055.t16 626.605
R158 a_57074_n66055.t12 a_57074_n66055.t0 537.09
R159 a_57074_n66055.t19 a_57074_n66055.t12 89.5154
R160 a_57074_n66055.t4 a_57074_n66055.t19 661.034
R161 a_57074_n66055.n2 a_57074_n66055.t4 1629.77
R162 a_57074_n66055.n15 a_57074_n66055.t8 162.434
R163 a_57074_n66055.n21 a_57074_n66055.n20 120.597
R164 a_57074_n66055# a_57074_n66055.n21 105.915
R165 a_57074_n66055.n21 a_57074_n66055.t3 39.0139
R166 a_57074_n66055.n20 a_57074_n66055.n13 27.8593
R167 a_57074_n66055.n13 a_57074_n66055.n11 36.1417
R168 a_57074_n66055.n11 a_57074_n66055.n9 36.1417
R169 a_57074_n66055.n9 a_57074_n66055.n18 12.424
R170 a_57074_n66055.n18 a_57074_n66055.n19 257.659
R171 a_57074_n66055.n19 a_57074_n66055.t11 39.3755
R172 a_57074_n66055.n19 a_57074_n66055.t15 39.3755
R173 a_57074_n66055.n7 a_57074_n66055.n18 10.9181
R174 a_57074_n66055.n7 a_57074_n66055.n5 31.0674
R175 a_57074_n66055.n5 a_57074_n66055.n16 5.42088
R176 a_57074_n66055.n3 a_57074_n66055.n16 4.98327
R177 a_57074_n66055.n3 a_57074_n66055.n1 9.66968
R178 a_57074_n66055.n16 a_57074_n66055.n17 150.556
R179 a_57074_n66055.n17 a_57074_n66055.t17 61.6221
R180 a_57074_n66055.n17 a_57074_n66055.t20 61.6221
C214 m5_57184_n66100# a_57074_n66055# 0 $ **FLOATING
C215 m4_58072_n65640# a_57074_n66055# 0 $ **FLOATING
C216 m4_57896_n65676# a_57074_n66055# 0 $ **FLOATING
C217 m4_57720_n65712# a_57074_n66055# 0 $ **FLOATING
C218 m4_58072_n65464# a_57074_n66055# 0 $ **FLOATING
C219 m4_57896_n65500# a_57074_n66055# 0 $ **FLOATING
C220 m4_57720_n65536# a_57074_n66055# 0 $ **FLOATING
C221 m4_57544_n65572# a_57074_n66055# 0 $ **FLOATING
C222 m4_57368_n65608# a_57074_n66055# 0 $ **FLOATING
C223 m4_57192_n65644# a_57074_n66055# 0 $ **FLOATING
C224 m4_57016_n65680# a_57074_n66055# 0 $ **FLOATING
C225 m4_58072_n65288# a_57074_n66055# 0 $ **FLOATING
C226 m4_57896_n65324# a_57074_n66055# 0 $ **FLOATING
C227 m4_57720_n65360# a_57074_n66055# 0 $ **FLOATING
C228 m4_57544_n65396# a_57074_n66055# 0 $ **FLOATING
C229 m4_57368_n65432# a_57074_n66055# 0 $ **FLOATING
C230 m4_57192_n65468# a_57074_n66055# 0 $ **FLOATING
C231 m4_57016_n65504# a_57074_n66055# 0 $ **FLOATING
C232 m4_58072_n65112# a_57074_n66055# 0 $ **FLOATING
C233 m4_57896_n65148# a_57074_n66055# 0 $ **FLOATING
C234 m4_57720_n65184# a_57074_n66055# 0 $ **FLOATING
C235 m4_57544_n65220# a_57074_n66055# 0 $ **FLOATING
C236 m4_57368_n65256# a_57074_n66055# 0 $ **FLOATING
C237 m4_57192_n65292# a_57074_n66055# 0 $ **FLOATING
C238 m4_57016_n65328# a_57074_n66055# 0 $ **FLOATING
C239 m4_57720_n65008# a_57074_n66055# 0 $ **FLOATING
C240 m4_57544_n65044# a_57074_n66055# 0 $ **FLOATING
C241 m4_57368_n65080# a_57074_n66055# 0 $ **FLOATING
C242 m4_57192_n65116# a_57074_n66055# 0 $ **FLOATING
C243 m4_57016_n65152# a_57074_n66055# 0 $ **FLOATING
C244 m3_57650_n66170# a_57074_n66055# 0 $ **FLOATING
C245 m3_57474_n66200# a_57074_n66055# 0 $ **FLOATING
C246 m3_57298_n66200# a_57074_n66055# 0 $ **FLOATING
C247 m3_57650_n65994# a_57074_n66055# 0 $ **FLOATING
C248 m3_57474_n66030# a_57074_n66055# 0 $ **FLOATING
C249 m3_57298_n66066# a_57074_n66055# 0 $ **FLOATING
C250 m3_57650_n65818# a_57074_n66055# 0 $ **FLOATING
C251 m3_57474_n65854# a_57074_n66055# 0 $ **FLOATING
C252 m3_57298_n65890# a_57074_n66055# 0 $ **FLOATING
C253 m3_58002_n65570# a_57074_n66055# 0 $ **FLOATING
C254 m3_57826_n65606# a_57074_n66055# 0 $ **FLOATING
C255 m3_57650_n65642# a_57074_n66055# 0 $ **FLOATING
C256 m3_57474_n65678# a_57074_n66055# 0 $ **FLOATING
C257 m3_57298_n65714# a_57074_n66055# 0 $ **FLOATING
C258 m3_57122_n65750# a_57074_n66055# 0 $ **FLOATING
C259 m3_58002_n65394# a_57074_n66055# 0 $ **FLOATING
C260 m3_57826_n65430# a_57074_n66055# 0 $ **FLOATING
C261 m3_57650_n65466# a_57074_n66055# 0 $ **FLOATING
C262 m3_57474_n65502# a_57074_n66055# 0 $ **FLOATING
C263 m3_57298_n65538# a_57074_n66055# 0 $ **FLOATING
C264 m3_57122_n65574# a_57074_n66055# 0 $ **FLOATING
C265 m3_58002_n65218# a_57074_n66055# 0 $ **FLOATING
C266 m3_57826_n65254# a_57074_n66055# 0 $ **FLOATING
C267 m3_57650_n65290# a_57074_n66055# 0 $ **FLOATING
C268 m3_57474_n65326# a_57074_n66055# 0 $ **FLOATING
C269 m3_57298_n65362# a_57074_n66055# 0 $ **FLOATING
C270 m3_57122_n65398# a_57074_n66055# 0 $ **FLOATING
C271 m3_58002_n65042# a_57074_n66055# 0 $ **FLOATING
C272 m3_57826_n65078# a_57074_n66055# 0 $ **FLOATING
C273 m3_57650_n65114# a_57074_n66055# 0 $ **FLOATING
C274 m3_57474_n65150# a_57074_n66055# 0 $ **FLOATING
C275 m3_57298_n65186# a_57074_n66055# 0 $ **FLOATING
C276 m3_57122_n65222# a_57074_n66055# 0 $ **FLOATING
C277 m3_57298_n65010# a_57074_n66055# 0 $ **FLOATING
C278 m3_57122_n65046# a_57074_n66055# 0 $ **FLOATING
C279 m2_57344_n66200# a_57074_n66055# 0 $ **FLOATING
C280 m2_57656_n66120# a_57074_n66055# 0 $ **FLOATING
C281 m2_57540_n66140# a_57074_n66055# 0 $ **FLOATING
C282 m2_57540_n66040# a_57074_n66055# 0 $ **FLOATING
C283 m2_57640_n65960# a_57074_n66055# 0 $ **FLOATING
C284 m2_57540_n65940# a_57074_n66055# 0 $ **FLOATING
C285 m2_57240_n65980# a_57074_n66055# 0 $ **FLOATING
C286 m2_57440_n65920# a_57074_n66055# 0 $ **FLOATING
C287 m2_57000_n65790# a_57074_n66055# 0.16042f
C288 m2_57840_n65700# a_57074_n66055# 0 $ **FLOATING
C289 m2_58040_n65640# a_57074_n66055# 0 $ **FLOATING
C290 m2_57840_n65300# a_57074_n66055# 0 $ **FLOATING
C291 m2_57740_n65280# a_57074_n66055# 0 $ **FLOATING
C292 m2_57968_n65152# a_57074_n66055# 0 $ **FLOATING
C293 m2_57812_n65168# a_57074_n66055# 0 $ **FLOATING
C294 m2_57440_n65120# a_57074_n66055# 0 $ **FLOATING
C295 m2_57640_n65060# a_57074_n66055# 0 $ **FLOATING
C296 m2_57340_n65100# a_57074_n66055# 0 $ **FLOATING
C297 m2_57240_n65080# a_57074_n66055# 0 $ **FLOATING
C298 m2_57140_n65060# a_57074_n66055# 0 $ **FLOATING
C299 m1_57730_n65570# a_57074_n66055# 0 $ **FLOATING
C300 m1_57730_n65470# a_57074_n66055# 0 $ **FLOATING
C301 m1_57730_n65370# a_57074_n66055# 0 $ **FLOATING
C302 m1_57730_n65270# a_57074_n66055# 0 $ **FLOATING
C303 m1_57000_n66200# a_57074_n66055# 0.0088f
C304 m1_57730_n65170# a_57074_n66055# 0 $ **FLOATING
C305 m1_57730_n65070# a_57074_n66055# 0 $ **FLOATING
C306 m1_57430_n65110# a_57074_n66055# 0 $ **FLOATING
C307 m1_57630_n65050# a_57074_n66055# 0 $ **FLOATING
C308 m1_57530_n65030# a_57074_n66055# 0 $ **FLOATING
C309 m1_57430_n65010# a_57074_n66055# 0 $ **FLOATING
C310 li_58047_n65017# a_57074_n66055# 0.01322f
C311 li_57610_n65006# a_57074_n66055# 0 $ **FLOATING
C312 a_57370_n66200# a_57074_n66055# 0.00416f $ **FLOATING
C313 a_57074_n66200# a_57074_n66055# 0.12376f $ **FLOATING
C314 a_57344_n66181# a_57074_n66055# 0.21943f $ **FLOATING
C315 a_57000_n66200# a_57074_n66055# 0.1128f $ **FLOATING
C316 a_57074_n66133# a_57074_n66055# 0.00893f $ **FLOATING
C317 a_58010_n65980# a_57074_n66055# 0.00319f $ **FLOATING
C318 a_58036_n65950# a_57074_n66055# 0.01044f $ **FLOATING
C319 a_58010_n65890# a_57074_n66055# 0 $ **FLOATING
C320 a_57680_n65852# a_57074_n66055# 0 $ **FLOATING
C321 a_57432_n65849# a_57074_n66055# 0.00208f $ **FLOATING
C322 a_58010_n65692# a_57074_n66055# 0 $ **FLOATING
C323 a_58036_n65662# a_57074_n66055# 0.01044f $ **FLOATING
C324 a_57680_n65660# a_57074_n66055# 0 $ **FLOATING
C325 a_58010_n65602# a_57074_n66055# 0 $ **FLOATING
C326 a_57432_n65651# a_57074_n66055# 0.00339f $ **FLOATING
C327 a_57680_n65480# a_57074_n66055# 0 $ **FLOATING
C328 a_57000_n66085# a_57074_n66055# 1.14614f $ **FLOATING
C329 a_58010_n65401# a_57074_n66055# 0.00123f $ **FLOATING
C330 a_57416_n65471# a_57074_n66055# 0.00549f $ **FLOATING
C331 a_57074_n65749# a_57074_n66055# 0.11319f $ **FLOATING
C332 a_57000_n65706# a_57074_n66055# 0.33092f $ **FLOATING
C333 a_57000_n65592# a_57074_n66055# 0.33313f $ **FLOATING
C334 a_57318_n65795# a_57074_n66055# 1.16062f $ **FLOATING
C335 a_58036_n65371# a_57074_n66055# 0.23712f $ **FLOATING
C336 a_57000_n65461# a_57074_n66055# 0.38189f $ **FLOATING
C337 a_57074_n65648# a_57074_n66055# 0.21271f $ **FLOATING
C338 a_57370_n65314# a_57074_n66055# 0.30041f $ **FLOATING
C339 a_57396_n65284# a_57074_n66055# 0.309f $ **FLOATING
C340 a_58051_n65203# a_57074_n66055# 0.00652f $ **FLOATING
C341 a_58025_n65144# a_57074_n66055# 0.00161f $ **FLOATING
C342 a_58025_n65037# a_57074_n66055# 0.0068f $ **FLOATING
C343 a_58051_n65007# a_57074_n66055# 0 $ **FLOATING
C344 w_57628_n66214# a_57074_n66055# 2.67195f $ **FLOATING
C345 a_57074_n66055# a_57074_n66055# 0 $ **FLOATING
C346 a_57074_n66055.t13 a_57074_n66055# 0 $ **FLOATING
C347 a_57074_n66055.n0 a_57074_n66055# 0 $ **FLOATING
C348 a_57074_n66055.n1 a_57074_n66055# 0 $ **FLOATING
C349 a_57074_n66055.n2 a_57074_n66055# 0 $ **FLOATING
C350 a_57074_n66055.n3 a_57074_n66055# 0 $ **FLOATING
C351 a_57074_n66055.n4 a_57074_n66055# 0 $ **FLOATING
C352 a_57074_n66055.n5 a_57074_n66055# 0 $ **FLOATING
C353 a_57074_n66055.n6 a_57074_n66055# 0 $ **FLOATING
C354 a_57074_n66055.n7 a_57074_n66055# 0 $ **FLOATING
C355 a_57074_n66055.n8 a_57074_n66055# 0 $ **FLOATING
C356 a_57074_n66055.n9 a_57074_n66055# 0 $ **FLOATING
C357 a_57074_n66055.n10 a_57074_n66055# 0 $ **FLOATING
C358 a_57074_n66055.n11 a_57074_n66055# 0 $ **FLOATING
C359 a_57074_n66055.n12 a_57074_n66055# 0 $ **FLOATING
C360 a_57074_n66055.n13 a_57074_n66055# 0 $ **FLOATING
C361 a_57074_n66055.n14 a_57074_n66055# 0 $ **FLOATING
C362 a_57074_n66055.n15 a_57074_n66055# 0 $ **FLOATING
C363 a_57074_n66055.n16 a_57074_n66055# 0 $ **FLOATING
C364 a_57074_n66055.t20 a_57074_n66055# 0 $ **FLOATING
C365 a_57074_n66055.t17 a_57074_n66055# 0 $ **FLOATING
C366 a_57074_n66055.n17 a_57074_n66055# 0 $ **FLOATING
C367 a_57074_n66055.n18 a_57074_n66055# 0 $ **FLOATING
C368 a_57074_n66055.t15 a_57074_n66055# 0 $ **FLOATING
C369 a_57074_n66055.t11 a_57074_n66055# 0 $ **FLOATING
C370 a_57074_n66055.n19 a_57074_n66055# 0 $ **FLOATING
C371 a_57074_n66055.n20 a_57074_n66055# 0 $ **FLOATING
C372 a_57074_n66055.n21 a_57074_n66055# 0 $ **FLOATING
C373 a_57074_n66055.t3 a_57074_n66055# 0 $ **FLOATING
C374 a_57074_n66055.t8 a_57074_n66055# 0 $ **FLOATING
C375 a_57074_n66055.t4 a_57074_n66055# 0 $ **FLOATING
C376 a_57074_n66055.t19 a_57074_n66055# 0 $ **FLOATING
C377 a_57074_n66055.t12 a_57074_n66055# 0 $ **FLOATING
C378 a_57074_n66055.t0 a_57074_n66055# 0 $ **FLOATING
C379 a_57074_n66055.t16 a_57074_n66055# 0 $ **FLOATING
C380 a_57074_n66055.t1 a_57074_n66055# 0 $ **FLOATING
C381 a_57074_n66055.t6 a_57074_n66055# 0 $ **FLOATING
C382 a_57074_n66055.t14 a_57074_n66055# 0 $ **FLOATING
C383 a_57074_n66055.t10 a_57074_n66055# 0 $ **FLOATING
C384 a_57074_n66055.t18 a_57074_n66055# 0 $ **FLOATING
C385 a_57074_n66055.t2 a_57074_n66055# 0 $ **FLOATING
C386 a_57074_n66055.t9 a_57074_n66055# 0 $ **FLOATING
C387 a_57074_n66055.t7 a_57074_n66055# 0 $ **FLOATING
C388 a_57074_n66055.t5 a_57074_n66055# 0 $ **FLOATING
C389 w_57628_n66214.t3 a_57074_n66055# 0 $ **FLOATING
C390 w_57628_n66214.n0 a_57074_n66055# 0 $ **FLOATING
C391 w_57628_n66214.n1 a_57074_n66055# 0 $ **FLOATING
C392 w_57628_n66214.n2 a_57074_n66055# 0 $ **FLOATING
C393 w_57628_n66214.n3 a_57074_n66055# 0 $ **FLOATING
C394 w_57628_n66214.n4 a_57074_n66055# 0 $ **FLOATING
C395 w_57628_n66214.n5 a_57074_n66055# 0 $ **FLOATING
C396 w_57628_n66214.n6 a_57074_n66055# 0 $ **FLOATING
C397 w_57628_n66214.n7 a_57074_n66055# 0 $ **FLOATING
C398 w_57628_n66214.n8 a_57074_n66055# 0 $ **FLOATING
C399 w_57628_n66214.n9 a_57074_n66055# 0 $ **FLOATING
C400 w_57628_n66214.n10 a_57074_n66055# 0 $ **FLOATING
C401 w_57628_n66214.n11 a_57074_n66055# 0 $ **FLOATING
C402 w_57628_n66214.n12 a_57074_n66055# 0 $ **FLOATING
C403 w_57628_n66214.n13 a_57074_n66055# 0 $ **FLOATING
C404 w_57628_n66214.n14 a_57074_n66055# 0 $ **FLOATING
C405 w_57628_n66214.n15 a_57074_n66055# 0 $ **FLOATING
C406 w_57628_n66214.n16 a_57074_n66055# 0 $ **FLOATING
C407 w_57628_n66214.n17 a_57074_n66055# 0 $ **FLOATING
C408 w_57628_n66214.n18 a_57074_n66055# 0 $ **FLOATING
C409 w_57628_n66214.n19 a_57074_n66055# 0 $ **FLOATING
C410 w_57628_n66214.n20 a_57074_n66055# 0 $ **FLOATING
C411 w_57628_n66214.n21 a_57074_n66055# 0 $ **FLOATING
C412 w_57628_n66214.n22 a_57074_n66055# 0 $ **FLOATING
C413 w_57628_n66214.n23 a_57074_n66055# 0 $ **FLOATING
C414 w_57628_n66214.n24 a_57074_n66055# 0 $ **FLOATING
C415 w_57628_n66214.n25 a_57074_n66055# 0 $ **FLOATING
C416 w_57628_n66214.n26 a_57074_n66055# 0 $ **FLOATING
C417 w_57628_n66214.n27 a_57074_n66055# 0 $ **FLOATING
C418 w_57628_n66214.n28 a_57074_n66055# 0 $ **FLOATING
C419 w_57628_n66214.n29 a_57074_n66055# 0 $ **FLOATING
C420 w_57628_n66214.n30 a_57074_n66055# 0 $ **FLOATING
C421 w_57628_n66214.n31 a_57074_n66055# 0 $ **FLOATING
C422 w_57628_n66214.n32 a_57074_n66055# 0 $ **FLOATING
C423 w_57628_n66214.n33 a_57074_n66055# 0 $ **FLOATING
C424 w_57628_n66214.n34 a_57074_n66055# 0 $ **FLOATING
C425 w_57628_n66214.t16 a_57074_n66055# 0 $ **FLOATING
C426 w_57628_n66214.t25 a_57074_n66055# 0 $ **FLOATING
C427 w_57628_n66214.t2 a_57074_n66055# 0 $ **FLOATING
C428 w_57628_n66214.t4 a_57074_n66055# 0 $ **FLOATING
C429 w_57628_n66214.t18 a_57074_n66055# 0 $ **FLOATING
C430 w_57628_n66214.t0 a_57074_n66055# 0 $ **FLOATING
C431 w_57628_n66214.t1 a_57074_n66055# 0 $ **FLOATING
C432 w_57628_n66214.t6 a_57074_n66055# 0 $ **FLOATING
C433 w_57628_n66214.t22 a_57074_n66055# 0 $ **FLOATING
C434 w_57628_n66214.t10 a_57074_n66055# 0 $ **FLOATING
C435 w_57628_n66214.t20 a_57074_n66055# 0 $ **FLOATING
C436 w_57628_n66214.t24 a_57074_n66055# 0 $ **FLOATING
C437 w_57628_n66214.t8 a_57074_n66055# 0 $ **FLOATING
C438 w_57628_n66214.t12 a_57074_n66055# 0 $ **FLOATING
C439 w_57628_n66214.t14 a_57074_n66055# 0 $ **FLOATING
C440 w_57628_n66214.n35 a_57074_n66055# 0 $ **FLOATING
C441 w_57628_n66214.n36 a_57074_n66055# 0 $ **FLOATING
C442 w_57628_n66214.t5 a_57074_n66055# 0 $ **FLOATING
C443 w_57628_n66214.t19 a_57074_n66055# 0 $ **FLOATING
C444 w_57628_n66214.n37 a_57074_n66055# 0 $ **FLOATING
C445 w_57628_n66214.t15 a_57074_n66055# 0 $ **FLOATING
C446 w_57628_n66214.n38 a_57074_n66055# 0 $ **FLOATING
C447 w_57628_n66214.t13 a_57074_n66055# 0 $ **FLOATING
C448 w_57628_n66214.n39 a_57074_n66055# 0 $ **FLOATING
C449 w_57628_n66214.t9 a_57074_n66055# 0 $ **FLOATING
C450 w_57628_n66214.n40 a_57074_n66055# 0 $ **FLOATING
C451 w_57628_n66214.n41 a_57074_n66055# 0 $ **FLOATING
C452 w_57628_n66214.t23 a_57074_n66055# 0 $ **FLOATING
C453 w_57628_n66214.t21 a_57074_n66055# 0 $ **FLOATING
C454 w_57628_n66214.t11 a_57074_n66055# 0 $ **FLOATING
C455 w_57628_n66214.n42 a_57074_n66055# 0 $ **FLOATING
C456 w_57628_n66214.t7 a_57074_n66055# 0 $ **FLOATING
C457 w_57628_n66214.n43 a_57074_n66055# 0 $ **FLOATING
C458 w_57628_n66214.t26 a_57074_n66055# 0 $ **FLOATING
C459 w_57628_n66214.n44 a_57074_n66055# 0 $ **FLOATING
C460 w_57628_n66214.t17 a_57074_n66055# 0 $ **FLOATING
C461 a_58051_n65007.t0 a_57074_n66055# 0 $ **FLOATING
C462 a_58051_n65203.t0 a_57074_n66055# 0 $ **FLOATING
C463 a_57396_n65284.t1 a_57074_n66055# 0 $ **FLOATING
C464 a_57396_n65284.n0 a_57074_n66055# 0 $ **FLOATING
C465 a_57396_n65284.t0 a_57074_n66055# 0 $ **FLOATING
C466 a_57370_n65314.t1 a_57074_n66055# 0 $ **FLOATING
C467 a_57370_n65314.t4 a_57074_n66055# 0 $ **FLOATING
C468 a_57370_n65314.n0 a_57074_n66055# 0 $ **FLOATING
C469 a_57370_n65314.t5 a_57074_n66055# 0 $ **FLOATING
C470 a_57370_n65314.n1 a_57074_n66055# 0 $ **FLOATING
C471 a_57370_n65314.t0 a_57074_n66055# 0 $ **FLOATING
C472 a_57370_n65314.t3 a_57074_n66055# 0 $ **FLOATING
C473 a_57370_n65314.n2 a_57074_n66055# 0 $ **FLOATING
C474 a_57370_n65314.t7 a_57074_n66055# 0 $ **FLOATING
C475 a_57370_n65314.t6 a_57074_n66055# 0 $ **FLOATING
C476 a_57370_n65314.n3 a_57074_n66055# 0 $ **FLOATING
C477 a_57370_n65314.n4 a_57074_n66055# 0 $ **FLOATING
C478 a_57370_n65314.n5 a_57074_n66055# 0 $ **FLOATING
C479 a_57370_n65314.t2 a_57074_n66055# 0 $ **FLOATING
C480 a_57074_n65648.n0 a_57074_n66055# 0 $ **FLOATING
C481 a_57074_n65648.t1 a_57074_n66055# 0 $ **FLOATING
C482 a_57074_n65648.t0 a_57074_n66055# 0 $ **FLOATING
C483 a_58036_n65371.t0 a_57074_n66055# 0 $ **FLOATING
C484 a_57000_n65706.t0 a_57074_n66055# 0 $ **FLOATING
C485 a_57000_n65706.t1 a_57074_n66055# 0 $ **FLOATING
C486 a_57000_n65706.n0 a_57074_n66055# 0 $ **FLOATING
C487 a_57074_n65749.t0 a_57074_n66055# 0 $ **FLOATING
C488 a_57416_n65471.t0 a_57074_n66055# 0 $ **FLOATING
C489 a_57680_n65480.t0 a_57074_n66055# 0 $ **FLOATING
C490 a_57432_n65651.t0 a_57074_n66055# 0 $ **FLOATING
C491 a_57680_n65660.t0 a_57074_n66055# 0 $ **FLOATING
C492 a_58036_n65662.t0 a_57074_n66055# 0 $ **FLOATING
C493 a_57432_n65849.t0 a_57074_n66055# 0 $ **FLOATING
C494 a_57680_n65852.t0 a_57074_n66055# 0 $ **FLOATING
C495 a_58036_n65950.t0 a_57074_n66055# 0 $ **FLOATING
C496 a_57074_n66133.t0 a_57074_n66055# 0 $ **FLOATING
C497 a_57074_n66200.t0 a_57074_n66055# 0 $ **FLOATING
C498 a_57370_n66200.t0 a_57074_n66055# 0 $ **FLOATING
.ends
